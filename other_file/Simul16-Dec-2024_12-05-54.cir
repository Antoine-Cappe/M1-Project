Simul16-Dec-2024_12-05-54.cir
********************************************************************************
*
*                        Spice Netlist Generated by
*
*                              BIOCAD Program
*                               Release 1.0
*
*   Authors: Vincent Senez
*
*   Release 1.0 : January 2019
*
********************************************************************************
.CONTROL
  DESTROY ALL
  AC DEC 10.000000 1000.000000 1000000.000000
  WRITE Simul16-Dec-2024_12-05-54.spi vdb(677,44)-vdb(44)-100 vp(677,44)-vp(44)
  DESTROY ALL
  AC DEC 1 1000.000000 1000.000000
  WRITE Simul16-Dec-2024_12-05-54_1000Hz.spi_cou all
  DESTROY ALL
  AC DEC 1 500000.000000 500000.000000
  WRITE Simul16-Dec-2024_12-05-54_500000Hz.spi_cou all
  DESTROY ALL
  AC DEC 1 1000000.000000 1000000.000000
  WRITE Simul16-Dec-2024_12-05-54_1000000Hz.spi_cou all
.ENDC
Vin	677	0	DC 0 AC 0.025000
Rg	44	0	50e-5
R1_7	1	7	1.3257450756887489e-07
R1_2	1	2	1.5908940908264988e-06
R1_3	1	3	4.4255368300684447e-07
R1_8	1	8	4.9352505360534380e-07
R1_9	1	9	7.9544704541324940e-07
R1_11	1	11	9.9430880676656177e-07
R2_7	2	7	1.4559246902541462e-06
R2_3	2	3	4.7517269921698367e-07
R2_19	2	19	1.9412329203388613e-07
R2_15	2	15	2.3294795044066352e-06
R2_4	2	4	1.2986101355530941e-06
R3_7	3	7	7.0976600373787379e-07
R3_8	3	8	2.1085083914521230e-07
R3_5	3	5	5.6295751089589444e-07
R3_6	3	6	1.7155571729943892e-07
R3_9	3	9	7.8011108225730523e-07
R3_19	3	19	5.6409355396319064e-07
R3_4	3	4	8.4596898735595265e-07
R3_27	3	27	9.7400055717162700e-07
R4_19	4	19	7.4721008097951859e-07
R4_15	4	15	8.9112882803647006e-07
R4_27	4	27	8.0697440121848236e-08
R4_17	4	17	1.0973345800046950e-06
R4_5	4	5	9.3102905056735271e-07
R4_20	4	20	8.6846694912416973e-07
R4_23	4	23	1.1923734494678834e-06
R5_8	5	8	3.2400322414259316e-07
R5_6	5	6	6.8173853668807610e-07
R5_9	5	9	1.3237766782135984e-06
R5_10	5	10	8.7500331419576979e-07
R5_27	5	27	8.4603202407430083e-07
R5_23	5	23	1.1560693524951033e-06
R5_28	5	28	1.4941571012339687e-07
R5_22	5	22	1.6054286993651237e-06
R6_8	6	8	2.2738643536132029e-07
R6_7	6	7	1.3916666509223593e-06
R6_11	6	11	9.4166326188503058e-07
R6_19	6	19	1.4933312556317773e-06
R6_27	6	27	1.1099076103719231e-06
R6_28	6	28	8.1981368709394343e-07
R6_29	6	29	4.9440815356469130e+01
R6_30	6	30	6.9745319570959822e+01
R6_31	6	31	4.6695689672661032e+01
R6_32	6	32	1.0910892800548353e+02
R7_8	7	8	9.5136568332757743e-07
R7_11	7	11	1.5333791316131055e-06
R7_19	7	19	1.5333791316131077e-06
R7_30	7	30	8.8167582238309322e+01
R7_32	7	32	8.7944940301702147e+01
R7_33	7	33	3.0667582785600024e+02
R8_9	8	9	9.2038476021226645e-08
R8_10	8	10	1.0496310058496270e-06
R8_11	8	11	9.2038476021226645e-08
R8_28	8	28	4.0755901849924150e-07
R8_34	8	34	1.0496310058496270e-06
R9_10	9	10	1.6696763840749850e-06
R9_11	9	11	4.1741909601874626e-07
R9_34	9	34	2.0870954800937314e-06
R10_28	10	28	9.3183488451548396e-07
R10_22	10	22	7.0270038344674114e-07
R10_34	10	34	2.5473909553863568e-07
R10_13	10	13	4.0758255286181709e-06
R10_35	10	35	2.5473909553863570e-06
R11_28	11	28	6.2675170566791398e-07
R11_29	11	29	4.5145022101049214e+01
R11_30	11	30	2.8858200931015134e+01
R11_34	11	34	7.9544704143601371e-07
R11_36	11	36	3.8174456864269949e+01
R12_13	12	13	1.8140769777689745e-07
R12_35	12	35	2.0661755701884814e-07
R12_22	12	22	2.6222882361038269e-07
R12_37	12	37	5.6980321267946615e-08
R12_24	12	24	4.6837255284005318e-07
R12_38	12	38	2.4148567904067232e-07
R12_14	12	14	5.1055380723123298e-07
R12_40	12	40	2.6067094984143323e-07
R13_35	13	35	1.1491889672860999e-07
R13_22	13	22	5.3565111316249758e-07
R13_40	13	40	8.6189172546457513e-07
R13_14	13	14	1.3790267607433200e-06
R14_40	14	40	1.9990795801750648e-07
R14_38	14	38	1.5992636641400518e-06
R15_19	15	19	8.6966145976880010e-07
R15_27	15	27	7.5548909985293556e-07
R15_17	15	17	5.4189367703428058e-07
R15_46	15	46	1.7393229195376013e-07
R15_18	15	18	2.0871875034451186e-06
R16_20	16	20	7.9167030643540452e-07
R16_26	16	26	3.5493299528534653e-07
R16_17	16	17	8.2876291126705238e-07
R16_21	16	21	4.8587239473875566e-07
R16_44	16	44	3.2542858150267102e-07
R16_48	16	48	8.2330617869785402e-07
R16_52	16	52	1.3284327060085367e-07
R16_49	16	49	6.5801160073169314e-07
R16_45	16	45	8.2050256355224166e-07
R16_53	16	53	7.4426870378612618e-07
R17_20	17	20	2.4406448001027782e-07
R17_26	17	26	2.6082435404528825e-07
R17_27	17	27	2.3804682222653055e-07
R17_46	17	46	3.3152049371442087e-07
R17_18	17	18	3.9419001044051171e-07
R17_53	17	53	5.4993299708523090e-08
R17_45	17	45	6.7217937522161085e-07
R18_46	18	46	5.8861521666491440e-07
R18_53	18	53	3.9594428017579528e-07
R18_45	18	45	4.4433762262276935e-07
R18_56	18	56	1.1772304333298320e-07
R18_54	18	54	1.4126765199957974e-06
R19_27	19	27	5.1249346300323934e-07
R19_31	19	31	1.9108151223010115e+01
R19_32	19	32	3.2717525571700975e+01
R19_46	19	46	1.6287640954718546e-06
R19_60	19	60	8.4820152540999672e+01
R20_26	20	26	5.1868385338422484e-08
R20_21	20	21	9.8634791843554149e-08
R20_27	20	27	1.8391303319022655e-07
R20_23	20	23	2.1570959720385215e-07
R20_65	20	65	2.2196867840631614e-07
R21_26	21	26	1.9402137155823480e-07
R21_44	21	44	2.5425280885342309e-08
R21_48	21	48	4.6534142932796931e-07
R21_25	21	25	1.7141484847787588e-07
R21_23	21	23	4.7668371285293425e-07
R21_65	21	65	2.4105623422034912e-07
R22_28	22	28	3.6530791997286403e-07
R22_23	22	23	5.6434252804047065e-07
R22_34	22	34	4.0844653802473190e-07
R22_35	22	35	2.9757528070398917e-07
R22_37	22	37	3.8142496762970282e-07
R22_24	22	24	6.0298470645833947e-07
R22_67	22	67	7.3211555855752299e-08
R23_27	23	27	4.2109272038925382e-07
R23_28	23	28	4.0310731029442659e-07
R23_65	23	65	6.0966103872171609e-08
R23_25	23	25	5.8016886225065842e-07
R23_24	23	24	6.3803893909200268e-07
R23_67	23	67	5.0354873045681903e-07
R24_37	24	37	2.6348664170183459e-07
R24_38	24	38	4.9258376459689049e-07
R24_62	24	62	4.6340949977125473e-08
R24_39	24	39	7.2098939430759792e-07
R24_42	24	42	3.9531416532050422e-07
R24_65	24	65	3.3800223971796911e-07
R24_25	24	25	3.1835333288207418e-07
R24_67	24	67	3.0833284573574606e-07
R24_69	24	69	3.2489336939188338e-07
R25_44	25	44	1.7534569639106666e-07
R25_48	25	48	3.4918096495383079e-07
R25_65	25	65	2.5943120098341499e-07
R25_69	25	69	7.9077221734333409e-08
R25_42	25	42	3.9125811662979474e-07
R26_27	26	27	3.8799892956375296e-07
R26_44	26	44	1.2714401058347198e-07
R26_43	26	43	2.6103951234806113e-07
R26_52	26	52	2.6782866586604022e-07
R26_53	26	53	3.0012870668403257e-07
R26_65	26	65	2.6479803461656725e-07
R26_74	26	74	3.4454733910220012e+00
R27_28	27	28	5.6163182984831345e-07
R27_29	27	29	2.9234936565493744e+01
R27_31	27	31	1.4306846474658423e+01
R27_46	27	46	6.4737050033972942e-07
R27_47	27	47	1.8205069058688924e+01
R27_53	27	53	8.0198770142298938e-07
R27_65	27	65	6.0327741808664823e-07
R27_74	27	74	1.9613734675682327e+01
R27_75	27	75	2.2810863449421632e+01
R27_77	27	77	2.7238243963508950e+01
R28_29	28	29	9.3687096218830135e+00
R28_34	28	34	2.1726823537457045e-07
R28_36	28	36	3.3248169874247210e+01
R28_65	28	65	7.2271810324545639e-07
R28_66	28	66	1.1331128719354924e+01
R28_67	28	67	3.8125880841466215e-07
R28_75	28	75	4.4558102100118766e+01
R28_78	28	78	4.1930421829760569e+01
R29_30	29	30	5.9420833452658336e+01
R29_31	29	31	4.0023289646316705e+01
R29_36	29	36	5.2407685789065887e+01
R29_64	29	64	4.6576176156135006e+01
R29_66	29	66	4.1220841824631499e+01
R29_75	29	75	8.7554268544133080e+01
R29_77	29	77	8.4273720157175589e+01
R29_78	29	78	3.5986367330348720e+01
R29_79	29	79	3.4274129654339291e+01
R30_31	30	31	1.5344211167424896e+02
R30_32	30	32	7.0037908704778715e+01
R30_33	30	33	5.8391353648124699e+01
R30_36	30	36	8.5770848941281272e+01
R30_57	30	57	1.0558511625685024e+02
R30_59	30	59	1.7334596957406848e+02
R30_64	30	64	9.5821619515004883e+01
R30_79	30	79	9.6557040482880410e+01
R31_32	31	32	1.6016581038178181e+01
R31_46	31	46	3.5898327243216279e+01
R31_47	31	47	2.3425507382622904e+01
R31_60	31	60	1.1459206934990904e+01
R31_77	31	77	1.7838425400348005e+01
R31_79	31	79	1.6456419592219170e+01
R32_33	32	33	3.2395443165475932e+01
R32_60	32	60	5.1437888558017669e+01
R32_61	32	61	6.6588980659939892e+01
R32_79	32	79	4.8601719588892358e+01
R33_57	33	57	7.3926314401755619e+01
R33_59	33	59	4.1492536350403995e+01
R33_58	33	58	7.9462528656445386e+01
R33_61	33	61	4.0305997575953420e+01
R33_79	33	79	7.4087415984762117e+01
R34_35	34	35	8.6697613023726308e-07
R34_36	34	36	4.8891477587703982e+01
R34_66	34	66	3.0610423646961234e+01
R34_67	34	67	6.7072851914016606e-07
R34_63	34	63	5.7958838336898388e+01
R34_81	34	81	6.1300583617218052e+01
R35_37	35	37	2.1485960441741222e-07
R35_40	35	40	6.5367177991481538e-07
R35_63	35	63	8.6423993064249842e+00
R35_67	35	67	5.1085033905630388e-07
R35_68	35	68	4.3970294624499743e+01
R35_81	35	81	6.9289233078293691e+01
R36_64	36	64	1.7051832898614023e+01
R36_57	36	57	6.2850902965176907e+01
R36_66	36	66	1.5110062497069446e+01
R36_81	36	81	7.4045849317465425e+01
R36_82	36	82	2.7490249575600611e+01
R37_38	37	38	2.8606941357775949e-07
R37_40	37	40	5.0951196112530596e-07
R37_62	37	62	3.7600037953006277e-07
R37_63	37	63	1.0624989952826700e+01
R37_67	37	67	2.9092927007528759e-07
R37_85	37	85	1.2893553662725630e+01
R37_87	37	87	5.2367042073245927e-07
R38_40	38	40	6.0966539464404362e-07
R38_62	38	62	4.8876365193092844e-07
R38_39	38	39	7.3159847357285344e-07
R38_87	38	87	1.2193307892880871e-07
R39_62	39	62	3.2461850131575516e-07
R39_42	39	42	3.5017834370598354e-07
R39_86	39	86	1.0117305676964943e-07
R39_41	39	41	1.2140766812357915e-06
R39_87	39	87	7.5879792577237158e-07
R40_63	40	63	5.4820925819857358e+01
R40_68	40	68	3.7424685014102856e+01
R40_85	40	85	4.0682007999161371e+01
R40_87	40	87	1.5058164325685335e-06
R40_89	40	89	5.1232991106439222e+01
R40_91	40	91	1.5058164626848622e+02
R41_42	41	42	2.7624624572184406e-07
R41_84	41	84	2.0765421946309431e-07
R41_70	41	70	2.0721595994849074e-07
R41_86	41	86	3.6711371147189658e-07
R41_92	41	92	7.3422742294379404e-08
R41_93	41	93	8.8107290753255248e-07
R42_62	42	62	2.4035988908748636e-07
R42_69	42	69	1.1758967318664288e-07
R42_48	42	48	2.9963468175662396e-07
R42_84	42	84	4.5510462790458978e-08
R42_70	42	70	3.1552708812773124e-07
R42_86	42	86	2.8197495463103960e-07
R42_96	42	96	2.6947007081371759e-07
R43_44	43	44	2.1410214892923081e-08
R43_52	43	52	3.4711003593112454e-07
R43_65	43	65	4.1778644181098560e-07
R43_69	43	69	2.1764167922437864e-07
R43_73	43	73	1.1020376662042567e+01
R43_74	43	74	1.4591995853476567e+01
R43_72	43	72	5.8154036999470566e+00
R43_75	43	75	2.7265670551244206e+01
R43_76	43	76	1.0233370176802145e+01
R43_96	43	96	4.1746887943906387e-07
R44_48	44	48	1.1733783920207428e-07
R44_52	44	52	1.1908866137734482e-07
R44_65	44	65	2.3832170489498663e-07
R44_69	44	69	1.3106556782441024e-07
R44_96	44	96	2.0107672976157970e-07
R45_49	45	49	3.2614309698547544e-07
R45_52	45	52	3.4051960802766250e-07
R45_53	45	53	2.4827489389167169e-07
R45_56	45	56	3.8875049027667089e-07
R45_54	45	54	4.5505490209059947e-07
R45_102	45	102	4.7179793835707627e-08
R45_51	45	51	5.2574416850768055e-07
R45_50	45	50	6.2556850561124575e-07
R46_47	46	47	4.4254252828295741e+01
R46_53	46	53	1.1978404936681788e-06
R46_56	46	56	4.0758254471016496e-06
R46_60	46	60	1.4394454437928732e+02
R46_106	46	106	1.3890693830692231e+02
R46_107	46	107	1.1651247589830596e+02
R47_53	47	53	1.3405414551297403e+01
R47_60	47	60	4.4602558480592904e+01
R47_74	47	74	2.5353340053666663e+01
R47_77	47	77	6.7455535404568669e+00
R47_104	47	104	2.4710104637837990e+01
R47_106	47	106	1.9036157410195035e+01
R47_107	47	107	3.4369868478248563e+01
R48_52	48	52	5.9764114898580032e-07
R48_49	48	49	7.6123185355797188e-07
R48_69	48	69	6.8683936705940423e-07
R48_96	48	96	1.1398537621346985e-07
R48_70	48	70	1.4319166106975891e-06
R48_97	48	97	1.2117486030871512e-06
R48_110	48	110	7.3309368309699785e-07
R49_52	49	52	2.4053706397842104e-07
R49_102	49	102	4.8174166549198747e-07
R49_50	49	50	4.0677305774000319e-07
R49_110	49	110	1.0329786655833120e-07
R49_97	49	97	8.8270929990034350e-07
R50_102	50	102	7.4734854687416368e-07
R50_51	50	51	7.5972336318828330e-07
R50_109	50	109	1.7557215863348254e-07
R50_99	50	99	1.0929159479770664e-06
R50_100	50	100	1.8198298552114289e-06
R50_97	50	97	1.4048989066248557e-06
R50_110	50	110	8.5206962600269092e-07
R50_111	50	111	8.6638803042156805e-07
R51_102	51	102	4.8363309428407738e-07
R51_54	51	54	4.1311337656091638e-07
R51_111	51	111	9.9780278576104350e-08
R51_55	51	55	9.4898874522030975e-07
R51_99	51	99	5.2065457701738061e-07
R52_53	52	53	4.2088102849423019e-07
R52_74	52	74	2.1157092541922239e+01
R52_72	52	72	9.5072183608458065e+00
R52_96	52	96	4.1921980908399021e-07
R52_102	52	102	4.2397324137956728e-07
R52_104	52	104	2.9960327971702203e+01
R52_108	52	108	3.3928733014551867e+01
R52_110	52	110	2.1592723137490384e-07
R52_114	52	114	1.0454860639620051e+01
R53_56	53	56	4.5201637212604148e-07
R53_74	53	74	1.9042311715370214e+01
R53_102	53	102	7.7914929151448427e-07
R53_104	53	104	2.0379084452282001e+01
R53_106	53	106	1.4585766407153377e+01
R53_114	53	114	4.3388335802532168e+01
R54_56	54	56	4.9987547938660824e-07
R54_102	54	102	3.0880024081576931e-07
R54_103	54	103	9.9975095877321265e-08
R54_111	54	111	2.0558471668584964e-07
R54_55	54	55	5.9985057526393180e-07
R54_116	54	116	7.4981321907991395e-07
R55_111	55	111	3.0043324334915355e-07
R55_99	55	99	6.5807745371838521e-07
R55_113	55	113	8.2259681714798128e-07
R55_116	55	116	1.6451936342959620e-07
R56_102	56	102	3.7424651574296284e-07
R56_103	56	103	1.0803036809842490e-06
R56_106	56	106	1.8498472509651673e+01
R56_107	56	107	4.4791455112210308e+01
R56_122	56	122	2.5056243621789434e+01
R57_59	57	59	1.3813004839672089e+01
R57_58	57	58	6.8870194204307651e+01
R57_64	57	64	1.2201567610010212e+01
R57_82	57	82	5.3709712802999455e+01
R57_83	57	83	3.5819654678041857e+01
R57_117	57	117	2.6734812861556222e+01
R57_124	57	124	4.7100762687969336e+01
R58_59	58	59	2.5419814606186428e+01
R58_61	58	61	7.2573741787993299e+01
R58_124	58	124	5.4404075961990600e+01
R58_119	58	119	5.3752108933379098e+01
R58_126	58	126	5.3789512344530863e+01
R58_127	58	127	9.6018937567897026e+01
R59_61	59	61	9.6431292686081580e+00
R59_64	59	64	2.1599409903871827e+01
R59_79	59	79	1.1585155098825842e+01
R59_80	59	80	5.0459092189572978e+01
R59_117	59	117	1.1110314543800849e+01
R59_118	59	118	2.5178089847183170e+01
R59_124	59	124	3.7749860628424599e+01
R59_119	59	119	1.1534029935150494e+01
R59_126	59	126	2.4602463138363689e+01
R59_128	59	128	1.1927209261900439e+01
R59_129	59	129	4.6658881043955361e+01
R60_77	60	77	3.1182697182277007e+01
R60_61	60	61	4.9343982844204085e+01
R60_79	60	79	3.5373234771464233e+01
R60_80	60	80	1.3362068378461959e+01
R60_107	60	107	4.0331030771890426e+01
R60_125	60	125	7.6365343753484524e+01
R60_129	60	129	8.6769538637116227e+01
R61_79	61	79	2.8544889723125774e+01
R61_80	61	80	4.6180919134330075e+01
R61_126	61	126	6.4831282314746261e+01
R61_129	61	129	4.6810292361681185e+01
R62_67	62	67	8.0847184724724766e-07
R62_63	62	63	5.9230093806649862e+01
R62_65	62	65	9.4576633398025182e-07
R62_69	62	69	4.5477775675198882e-07
R62_71	62	71	1.4925265280137374e+01
R62_84	62	84	9.2801082410593156e-07
R62_85	62	85	1.9803292621934375e+01
R62_86	62	86	6.1972617005977568e-07
R62_87	62	87	6.1930320171693420e-07
R62_88	62	88	1.7905025846429410e+01
R62_131	62	131	4.4721155013107733e+01
R63_67	63	67	1.5155936093150522e+01
R63_66	63	66	5.2211548117096527e+01
R63_68	63	68	1.3548260174219697e+01
R63_81	63	81	2.0212494123809201e+01
R63_85	63	85	1.7105417607299437e+01
R63_131	63	131	1.1307804033270395e+01
R64_66	64	66	3.1312598099723505e+01
R64_78	64	78	3.5350697804426595e+01
R64_79	64	79	1.3634387674319244e+01
R64_82	64	82	1.3634387674319255e+01
R64_83	64	83	3.3188476263219606e+01
R64_117	64	117	1.3876061939672349e+01
R64_118	64	118	1.1159276938424755e+01
R64_133	64	133	1.0666149948710089e+01
R65_66	65	66	1.5052474144710564e+02
R65_67	65	67	1.5795332749367851e-06
R65_69	65	69	7.5074881765383417e-07
R65_71	65	71	8.0049000804697343e+01
R65_73	65	73	3.2654362910702226e+01
R65_74	65	74	9.3088993423722357e+01
R65_75	65	75	3.0148713537094515e+01
R65_78	65	78	9.6510819721281493e+01
R65_134	65	134	9.6025709571502418e+01
R66_67	66	67	1.3990981695672270e+01
R66_78	66	78	7.3182525295228178e+00
R66_81	66	81	1.6912713494120116e+01
R66_82	66	82	2.9114648787401649e+01
R66_131	66	131	2.6567791045319538e+01
R66_132	66	132	9.8034476777675277e+00
R66_133	66	133	2.4565922809610171e+01
R66_134	66	134	2.9484476273697840e+01
R67_71	67	71	5.0067058475021504e+01
R67_131	67	131	2.9484895802867143e+01
R67_134	67	134	6.0152572428634713e+01
R68_81	68	81	3.3994689485675167e+01
R68_85	68	85	2.6675626815006744e+01
R68_89	68	89	3.0670525041743637e+01
R68_91	68	91	2.3400792544359891e+01
R68_131	68	131	2.5590912506675608e+01
R68_90	68	90	2.8597442735013818e+01
R68_138	68	138	2.4743485611562662e+01
R69_71	69	71	1.3044591100343279e+01
R69_73	69	73	8.0951944572883647e+00
R69_76	69	76	1.0830917183027747e+01
R69_84	69	84	3.5884804518885078e-07
R69_96	69	96	1.7319576281605337e-07
R69_141	69	141	1.0294079520598416e+01
R70_84	70	84	2.8298006625110481e-07
R70_92	70	92	3.1135889448724693e-07
R70_93	70	93	3.7063926084550385e-07
R70_96	70	96	2.7337131113347308e-07
R70_97	70	97	4.7277970784764966e-07
R70_142	70	142	5.5268139912005348e-08
R70_98	70	98	4.2686594010131017e-07
R71_73	71	73	2.9483827612883150e+01
R71_84	71	84	1.0561934294749365e+02
R71_88	71	88	2.9483827612883115e+01
R71_131	71	131	8.2118867043520396e+01
R71_134	71	134	1.3912817459058536e+01
R71_136	71	136	5.3537438663068926e+01
R71_140	71	140	1.0776388957011469e+02
R71_141	71	141	6.3165694208183155e+01
R71_145	71	145	2.0803240324908248e+01
R72_74	72	74	3.1171369706744017e+01
R72_73	72	73	5.6483644530683463e+01
R72_75	72	75	8.5849570865091295e+01
R72_76	72	76	1.6498256261219826e+01
R72_96	72	96	1.0091436924432226e+02
R72_104	72	104	4.4793034207693516e+01
R72_108	72	108	5.2272406935803339e+01
R72_114	72	114	7.9170446767378465e+01
R72_115	72	115	2.4668353017644115e+01
R72_146	72	146	5.1766391314375873e+01
R73_75	73	75	1.7045331108739074e+01
R73_76	73	76	8.9127944476425256e+00
R73_78	73	78	4.8522351982344354e+01
R73_134	73	134	1.6088231973329307e+01
R73_140	73	140	2.9205372153206142e+01
R73_141	73	141	4.0737724406994438e+01
R73_146	73	146	2.0561708778580776e+01
R74_75	74	75	2.4848539513085893e+01
R74_77	74	77	7.1228566796263650e+01
R74_104	74	104	2.8725753708564948e+01
R74_146	74	146	1.2475109818082629e+02
R75_77	75	77	4.2186164070835730e+01
R75_78	75	78	2.4002662453501365e+01
R75_146	75	146	4.4311449810201104e+01
R76_96	76	96	2.0179989565480117e+01
R76_108	76	108	1.6383505652144937e+01
R76_115	76	115	3.0679137093967238e+01
R76_140	76	140	1.1839095098800037e+01
R76_141	76	141	1.7116364685264003e+01
R76_146	76	146	3.5312370273529496e+01
R77_78	77	78	6.0240914271964492e+01
R77_79	77	79	4.0738705045083087e+01
R77_80	77	80	2.9876639268578057e+01
R77_104	77	104	2.2728296464949807e+01
R77_106	77	106	5.9661813168420167e+01
R77_105	77	105	1.6761141598002876e+01
R77_107	77	107	6.7017022226259272e+01
R77_137	77	137	7.8460716914026690e+01
R77_146	77	146	4.8071801027814260e+01
R77_147	77	147	4.1314352942674645e+01
R78_79	78	79	2.8758419362739893e+01
R78_118	78	118	3.0059984489325444e+01
R78_132	78	132	2.4209694871340499e+01
R78_133	78	133	2.1925854565088645e+01
R78_134	78	134	1.2695361484132349e+01
R78_135	78	135	1.1905709601844404e+01
R78_146	78	146	2.2469895441454653e+01
R78_147	78	147	2.9275720730797143e+01
R79_80	79	80	2.7505142476488679e+01
R79_118	79	118	1.9081026911288209e+01
R79_128	79	128	3.7517344466120505e+01
R79_147	79	147	4.5912301897784026e+01
R80_105	80	105	1.0714497375189346e+01
R80_107	80	107	3.8879580211991900e+01
R80_125	80	125	1.3153994506521030e+01
R80_128	80	128	1.9256530972514540e+01
R80_129	80	129	1.1585468500371702e+01
R80_130	80	130	1.3161785069869072e+01
R80_147	80	147	2.5373772210113732e+01
R81_82	81	82	4.4996322727664506e+01
R81_131	81	131	1.9609893717998094e+01
R81_90	81	90	4.1915184126399339e+01
R81_132	81	132	1.7222958648922170e+01
R81_139	81	139	4.1137148077428250e+01
R81_149	81	149	6.0000805689731919e+01
R82_83	82	83	1.6671963979821857e+01
R82_132	82	132	2.7490624608335555e+01
R82_133	82	133	1.2791216163793708e+01
R82_149	82	149	3.2176545486724955e+01
R83_117	83	117	1.0414682023980937e+01
R83_124	83	124	2.7497857641766977e+01
R83_120	83	120	2.2248738109388878e+01
R83_133	83	133	2.6932047333757112e+01
R83_148	83	148	1.3633533111664303e+01
R83_149	83	149	3.9423947582458077e+01
R83_150	83	150	3.2159046529665368e+01
R84_86	84	86	3.4986254955638303e-07
R84_88	84	88	5.7000840460477441e+01
R84_92	84	92	3.3682136044365561e-07
R84_96	84	96	4.7011668002818593e-07
R84_141	84	141	8.1140824160288023e+00
R84_142	84	142	6.9667221726150877e-07
R84_144	84	144	3.2028901192994532e+01
R84_145	84	145	3.4725806490586876e+01
R84_151	84	151	3.1745381567838439e+01
R85_87	85	87	1.4464214368949651e+01
R85_86	85	86	7.1446588406356454e+01
R85_88	85	88	1.4277060116158017e+01
R85_89	85	89	1.5172100079739815e+01
R85_131	85	131	1.7357057242739600e+01
R85_138	85	138	2.0687021592269218e+01
R85_154	85	154	3.0796641670839655e+01
R86_87	86	87	2.0422436087327347e-06
R86_88	86	88	5.3727600624670785e+01
R86_92	86	92	2.0422436291551649e-06
R86_145	86	145	9.2077759769484388e+01
R86_151	86	151	6.7111133299102150e+01
R86_154	86	154	5.2371741593562696e+01
R87_89	87	89	4.7540284810247464e+01
R87_154	87	154	7.8619016513562926e+01
R88_131	88	131	1.5253318343879533e+01
R88_136	88	136	9.4285258857958034e+00
R88_138	88	138	2.1859440259876834e+01
R88_145	88	145	9.5190038178987830e+00
R88_154	88	154	1.6709667697309847e+01
R88_155	88	155	2.3472361549036496e+01
R89_91	89	91	2.0642765290924785e+01
R89_138	89	138	1.2883149175245084e+01
R89_154	89	154	3.4871029675502797e+01
R89_157	89	157	3.6852816894438810e+01
R90_131	90	131	2.9935951845672850e+01
R90_138	90	138	1.5487884795707672e+01
R90_91	90	91	2.7489501665880656e+01
R90_139	90	139	5.1534118389369796e+00
R90_149	90	149	5.8785425179176677e+01
R90_156	90	156	5.1784416909427769e+01
R90_157	90	157	2.7641877997297996e+01
R90_158	90	158	2.5765215862984135e+01
R91_138	91	138	3.2550979440099347e+01
R91_157	91	157	3.7273463771028801e+01
R91_158	91	158	1.3469066049074064e+02
R92_93	92	93	5.9903896858776867e-07
R92_94	92	94	1.4376935102337095e-06
R92_142	92	142	3.5397089663148869e-07
R92_144	92	144	4.5011213437002326e+01
R92_151	92	151	3.7553826773533551e+01
R92_159	92	159	3.7666542838194374e+01
R93_98	93	98	1.7564110171918306e-07
R93_123	93	123	1.6206803479507516e-07
R93_95	93	95	5.3579132979658103e-07
R93_94	93	94	8.9298554966096552e-08
R93_142	93	142	2.1604221310310593e-07
R93_161	93	161	6.6973916224572626e-07
R94_142	94	142	4.2414790884009625e-07
R94_123	94	123	2.8323568057727036e-07
R94_159	94	159	4.5767855541749533e+01
R94_160	94	160	1.8660442534614816e+01
R94_161	94	161	1.1190469764402743e-06
R95_98	95	98	6.9440863705455037e-07
R95_123	95	123	3.6758421899123392e-07
R95_101	95	101	6.7718079084415826e-07
R95_161	95	161	1.6929519771103962e-07
R96_97	96	97	3.1644976908654073e-07
R96_108	96	108	7.8569753377275315e+00
R96_110	96	110	2.8684806746217567e-07
R96_141	96	141	1.1168818083712784e+01
R96_142	96	142	3.3959309275216211e-07
R96_143	96	143	2.9884197154784662e+01
R96_144	96	144	2.7422747404523761e+01
R96_162	96	162	7.0198980778630131e-07
R97_109	97	109	4.4006263622475677e-07
R97_100	97	100	5.4215267996970751e-07
R97_110	97	110	2.5190158150531825e-07
R97_142	97	142	4.9261004948594141e-07
R97_98	97	98	4.0450879472490608e-07
R97_162	97	162	5.6785122181167339e-08
R97_101	97	101	8.7205115972202152e-07
R98_123	98	123	6.8429665866884435e-08
R98_101	98	101	3.0640923501829028e-07
R98_142	98	142	2.1028216210602190e-07
R98_162	98	162	2.8842598710298078e-07
R99_109	99	109	3.7438394270986909e-07
R99_100	99	100	8.8490513196590054e-07
R99_111	99	111	2.6808019809672627e-07
R99_113	99	113	1.4748418866098332e-07
R99_164	99	164	1.1061314149573754e-06
R100_109	100	109	2.6437747529428036e-07
R100_162	100	162	3.5468016626482656e-07
R100_101	100	101	6.6705334769338911e-07
R100_164	100	164	1.1117555794889799e-07
R100_165	100	165	8.3381668461673573e-07
R101_123	101	123	1.9459191552855423e-07
R101_161	101	161	7.3214129667140991e-07
R101_162	101	162	2.8716424918019625e-07
R101_165	101	165	9.7618839556187953e-08
R102_103	102	103	8.6152879968500444e-07
R102_106	102	106	3.6858354498898912e+01
R102_110	102	110	4.5347957615638892e-07
R102_109	102	109	8.4606158085873948e-07
R102_111	102	111	3.2072648959269268e-07
R102_112	102	112	1.6850852099010165e+01
R102_114	102	114	1.6778643653057717e+01
R102_122	102	122	5.4040549232140570e+01
R102_168	102	168	2.4190666548682753e+01
R103_111	103	111	4.6696581635205079e-07
R103_116	103	116	1.5390679708179766e-06
R103_121	103	121	2.5246884139343766e+01
R103_122	103	122	4.2553778194989796e+01
R103_168	103	168	4.7722468574488559e+01
R104_106	104	106	3.8933369036802134e+01
R104_105	104	105	7.7581887023731241e+01
R104_114	104	114	4.3809104816999088e+01
R104_115	104	115	2.3269926915714962e+01
R104_137	104	137	6.9231731888091289e+01
R104_146	104	146	7.4036136304423422e+01
R104_170	104	170	3.3413483460471667e+01
R105_106	105	106	2.5713549784805537e+01
R105_107	105	107	3.7092410862978014e+01
R105_125	105	125	3.5410876517234733e+01
R105_130	105	130	1.8896784474244527e+01
R105_137	105	137	2.8912306090590384e+01
R105_147	105	147	5.8338337257973741e+01
R105_169	105	169	1.2689780847434202e+01
R105_170	105	170	2.5455672249578974e+01
R106_107	106	107	5.8132711667169650e+00
R106_114	106	114	1.9694580376489156e+01
R106_122	106	122	1.8422245316517525e+01
R106_168	106	168	2.4952740731998478e+01
R106_169	106	169	2.8170877668351984e+01
R106_170	106	170	5.8426792616063157e+00
R106_171	106	171	2.6202259289030376e+01
R107_122	107	122	6.6967673193662179e+01
R107_125	107	125	2.3684602074457473e+01
R107_169	107	169	4.2138665350260233e+01
R107_171	107	171	4.4532359722202884e+01
R108_110	108	110	6.2331943445590625e+01
R108_114	108	114	4.6335141593541493e+01
R108_115	108	115	4.0556671272885879e+01
R108_140	108	140	2.3385696917590909e+01
R108_141	108	141	8.2114057828578197e+01
R108_143	108	143	3.5636558749272048e+01
R108_144	108	144	8.7329383327771922e+01
R108_162	108	162	1.5372562475628209e+02
R108_173	108	173	4.2844876243234808e+01
R108_174	108	174	3.1406512035815826e+01
R109_110	109	110	5.4787943247786561e-07
R109_111	109	111	6.4166887447487398e-07
R109_112	109	112	1.9704325719860929e+01
R109_113	109	113	1.0878935817558322e-06
R109_162	109	162	9.5333408964070073e-07
R109_164	109	164	6.6523117808618753e-07
R109_166	109	166	2.3121453446551165e+01
R109_174	109	174	6.5447806128019053e+01
R110_112	110	112	3.5689100368895467e+01
R110_114	110	114	1.7824816817014732e+01
R110_162	110	162	7.2195711503574998e-07
R110_174	110	174	1.5933532814131508e+01
R111_112	111	112	3.5305341525418775e+01
R111_113	111	113	6.4513902987895793e-07
R111_116	111	116	1.1333572777745948e-06
R111_121	111	121	8.4657733472500226e+01
R111_168	111	168	8.3058182697865860e+01
R111_175	111	175	4.5930454180788949e+01
R112_113	112	113	6.0962334599840901e+01
R112_114	112	114	4.0288983503070867e+01
R112_166	112	166	3.4394316321961526e+01
R112_168	112	168	2.3352243833061443e+01
R112_174	112	174	4.2076306117114520e+01
R112_175	112	175	2.1662239148588359e+01
R112_176	112	176	1.7875386369651146e+01
R112_177	112	177	8.0678519674508422e+01
R113_116	113	116	1.5860675797906072e-06
R113_164	113	164	1.5860675797906072e-06
R113_166	113	166	5.1504292060875422e+01
R113_175	113	175	3.3814802379419490e+01
R113_177	113	177	3.3033235016105181e+01
R113_178	113	178	4.2774577550728075e+01
R114_115	114	115	8.0855667617470530e+00
R114_168	114	168	2.0205777237691308e+01
R114_170	114	170	1.4524440358979675e+01
R114_173	114	173	3.1179731049945410e+01
R114_174	114	174	1.0207576546435833e+01
R114_176	114	176	3.4377026502875580e+01
R114_179	114	179	1.9689148056412037e+01
R115_140	115	140	2.8274690650355655e+01
R115_137	115	137	1.2785548049879260e+01
R115_146	115	146	9.8258647006612545e+00
R115_170	115	170	1.8105582613609680e+01
R115_173	115	173	1.4427321757388043e+01
R115_179	115	179	4.1573241887672722e+01
R116_121	116	121	6.8399705777165252e+01
R116_175	116	175	6.6745111673330697e+01
R116_178	116	178	1.1513298772066949e+02
R116_182	116	182	1.1378321130648948e+02
R117_118	117	118	3.2683166398046435e+00
R117_119	117	119	8.1998216634316474e+00
R117_124	117	124	1.4794617173718640e+01
R117_120	117	120	3.4282315127380132e+00
R117_128	117	128	1.1534894537739623e+01
R117_133	117	133	1.5992198510961785e+01
R117_148	117	148	1.0532844780124414e+01
R117_184	117	184	1.4963157003508078e+01
R118_128	118	128	1.5550618098090297e+01
R118_133	118	133	1.3558084818767025e+01
R118_135	118	135	2.5547888079603656e+01
R118_147	118	147	2.8258863739463568e+01
R118_148	118	148	3.1554848304076170e+01
R118_184	118	184	1.8793641669087478e+01
R119_124	119	124	1.0375853186656741e+01
R119_120	119	120	5.9085621562088884e+00
R119_126	119	126	1.2248598715503608e+01
R119_127	119	127	4.6384136967621664e+01
R119_128	119	128	1.2581021146458399e+01
R119_183	119	183	1.9707225549867939e+01
R119_185	119	185	1.1166598932118795e+01
R120_124	120	124	1.3137436999604812e+01
R120_128	120	128	1.8475718783952363e+01
R120_148	120	148	1.1091079613966139e+01
R120_150	120	150	1.7971090639149320e+01
R120_183	120	183	2.2285156982374325e+01
R120_184	120	184	6.3065566713998562e+00
R120_185	120	185	6.3095096295061008e+00
R120_186	120	186	1.2740572871825149e+01
R121_122	121	122	5.9953137111665583e+01
R121_168	121	168	2.0387106612560139e+01
R121_175	121	175	1.6591947466991659e+01
R121_181	121	181	3.4637486418581219e+01
R121_182	121	182	3.3565050040879271e+01
R121_187	121	187	4.2184728087601663e+01
R122_168	122	168	1.1522803712124523e+01
R122_171	122	171	3.2169441037783884e+01
R122_187	122	187	6.4357061526475960e+01
R123_142	123	142	2.9453286246065710e-07
R123_160	123	160	2.0568414149841786e+01
R123_161	123	161	2.5631608686529889e-07
R123_162	123	162	2.9445342000053401e-07
R123_163	123	163	1.5693507528914314e+01
R123_165	123	165	3.5616494411021955e-07
R123_188	123	188	2.9287820162171688e+01
R124_127	124	127	6.3244033068351250e+01
R124_150	124	150	6.4352906602441834e+01
R124_185	124	185	3.2206631776263812e+01
R124_190	124	190	9.2263586679785561e+01
R125_129	125	129	4.0008693234456807e+01
R125_130	125	130	2.4061128715151405e+01
R125_169	125	169	1.4119640026075963e+01
R125_171	125	171	4.9856311455978656e+01
R125_191	125	191	4.8110143132724311e+01
R126_127	126	127	5.2093917353619808e+01
R126_128	126	128	4.6584157180714790e+01
R126_129	126	129	3.4711250949541295e+01
R126_183	126	183	2.4969498977778635e+01
R126_185	126	185	3.8378527868016768e+01
R126_192	126	192	5.3222218844164480e+01
R126_193	126	193	5.6191236494576955e+01
R126_194	126	194	5.6502114647047797e+01
R127_185	127	185	3.5946395919069850e+01
R127_190	127	190	3.5510393904601763e+01
R127_194	127	194	3.8766668245024320e+01
R127_195	127	195	1.2976150294358655e+02
R128_129	128	129	1.7250980713579597e+01
R128_130	128	130	2.3010304222187955e+01
R128_147	128	147	1.4276979769377290e+01
R128_183	128	183	7.0441311047129762e+00
R128_184	128	184	9.4446858895496923e+00
R128_199	128	199	1.6183836646191921e+01
R128_200	128	200	2.8252951619790057e+01
R129_130	129	130	3.2342764583717177e+01
R129_183	129	183	3.1821433971159664e+01
R129_191	129	191	4.4273164821424714e+01
R129_192	129	192	5.3931963978807580e+01
R129_198	129	198	6.1932552506711041e+01
R129_200	129	200	3.9414082986341306e+01
R130_147	130	147	1.5145444432117788e+01
R130_137	130	137	2.3113545668446736e+01
R130_169	130	169	6.3388193423542782e+00
R130_180	130	180	2.3489213111640186e+01
R130_172	130	172	1.3588098010971553e+01
R130_191	130	191	2.8952028685902420e+01
R130_199	130	199	2.6666797456711478e+01
R130_200	130	200	7.5247812427236518e+00
R130_203	130	203	1.1963449118988068e+01
R131_132	131	132	1.1509567778369398e+01
R131_134	131	134	2.1365809771182064e+01
R131_136	131	136	8.3635238439745976e+00
R131_138	131	138	6.1439578705672053e+00
R131_139	131	139	1.9481015306500407e+01
R131_204	131	204	2.4176611575263134e+01
R132_133	132	133	7.4529467086732932e+00
R132_134	132	134	3.6561643104361629e+01
R132_135	132	135	2.0169517243809548e+01
R132_136	132	136	4.4797890629150515e+01
R132_139	132	139	3.8091246170430352e+01
R132_149	132	149	3.8975079236200237e+01
R132_204	132	204	1.5838873428413354e+01
R133_135	133	135	2.4020107704091171e+01
R133_148	133	148	1.9324622830354805e+01
R133_149	133	149	5.1678789774547582e+01
R133_204	133	204	5.5168025927631014e+01
R134_135	134	135	2.5645045992291823e+01
R134_136	134	136	1.1847380257151427e+01
R134_140	134	140	3.8143292249968674e+01
R134_145	134	145	2.3999483664381987e+01
R134_146	134	146	2.3973498994601243e+01
R134_209	134	209	2.3607221987229916e+01
R135_136	135	136	3.9817642141711069e+01
R135_146	135	146	3.1258388573176578e+01
R135_147	135	147	1.5447690470422202e+01
R135_148	135	148	3.3498907410156001e+01
R135_184	135	184	4.0183190085676287e+01
R135_204	135	204	1.0313009577084447e+01
R135_205	135	205	1.5106564596896881e+01
R135_207	135	207	7.6309807862598378e+00
R135_209	135	209	2.5128662155193751e+01
R136_138	136	138	2.8080313924833767e+01
R136_145	136	145	1.1234431178628450e+01
R136_155	136	155	1.2369176203370952e+01
R136_204	136	204	1.1950381273618698e+01
R136_208	136	208	2.0673631740683106e+01
R136_209	136	209	2.2870392912535323e+01
R137_146	137	146	1.4351831610489580e+01
R137_147	137	147	2.2747026299798524e+01
R137_169	137	169	4.3650945794603814e+01
R137_170	137	170	1.5567056130832396e+01
R137_173	137	173	2.4097819771556374e+01
R137_179	137	179	3.6213640500214545e+01
R137_180	137	180	1.2847248239008657e+01
R137_202	137	202	1.9676943996789298e+01
R137_203	137	203	1.6021661733364180e+01
R137_210	137	210	1.3417307578251176e+01
R138_139	138	139	6.1723613860443031e+01
R138_154	138	154	1.0280060402288822e+02
R138_155	138	155	2.2189392850542710e+01
R138_157	138	157	2.8291104916784828e+01
R138_204	138	204	1.1304468070326759e+02
R138_212	138	212	1.3839670086966058e+02
R139_149	139	149	2.1458664969455473e+01
R139_156	139	156	3.1125732661241916e+01
R139_153	139	153	4.1773521616219341e+01
R139_157	139	157	4.9040309053476484e+01
R139_158	139	158	5.6912640724034567e+01
R139_204	139	204	1.6403885033722929e+01
R139_206	139	206	3.0445383545334288e+01
R139_212	139	212	1.3332649323512195e+01
R140_141	140	141	1.2365329049198561e+01
R140_143	140	143	4.1940283214397688e+01
R140_144	140	144	3.4830672241034982e+01
R140_145	140	145	3.0996812523106712e+01
R140_146	140	146	2.0219386328220455e+01
R140_173	140	173	3.6917150969593322e+01
R140_209	140	209	3.7218787053759819e+01
R140_211	140	211	1.6628022027792142e+01
R140_216	140	216	1.7963856619267819e+01
R141_142	141	142	5.1326987414496976e+01
R141_144	141	144	6.0261206893707024e+00
R141_145	141	145	1.2266087713739747e+01
R141_151	141	151	4.2663162836820121e+01
R141_216	141	216	2.5851308722478247e+01
R141_217	141	217	2.9479654121943572e+01
R142_144	142	144	1.0314321360986311e+01
R142_143	142	143	1.9478148762019231e+01
R142_159	142	159	1.8349433259217125e+01
R142_160	142	160	3.9689902524572702e+01
R142_162	142	162	3.3110232954357754e-07
R142_163	142	163	1.8783203053544050e+01
R142_218	142	218	3.1937629760549100e+01
R143_144	143	144	1.7039794533967928e+01
R143_162	143	162	3.7241326824012944e+01
R143_163	143	163	2.5153905205695438e+01
R143_167	143	167	2.0447753440761524e+01
R143_173	143	173	4.6112272522382604e+01
R143_174	143	174	4.7940354189198779e+01
R143_211	143	211	8.1784889751027208e+01
R143_215	143	215	1.8457052081236295e+01
R143_216	143	216	4.6366779290779476e+01
R143_218	143	218	3.0149376058729985e+01
R144_151	144	151	5.5941255538729749e+01
R144_159	144	159	5.0514184706834790e+01
R144_216	144	216	2.3498032944208742e+01
R144_217	144	217	2.8619503950345464e+01
R144_218	144	218	2.7715952719566811e+01
R145_151	145	151	1.0011178246964894e+02
R145_154	145	154	7.5981783851310283e+01
R145_155	145	155	1.0886652297381279e+02
R145_208	145	208	3.9031033483772269e+01
R145_209	145	209	4.5870645440988689e+01
R145_216	145	216	6.0862781679155269e+01
R145_217	145	217	5.0938881317687994e+01
R145_219	145	219	1.1743267874993890e+02
R146_147	146	147	3.3478627900730501e+01
R146_173	146	173	6.9652932635671490e+01
R146_207	146	207	6.8266047318944928e+01
R146_209	146	209	3.2906338853492322e+01
R146_210	146	210	3.2896887768373276e+01
R146_211	146	211	6.8496689762199011e+01
R146_220	146	220	1.0057557299267481e+02
R147_184	147	184	7.5711877436027351e+01
R147_199	147	199	2.5397923459873169e+01
R147_203	147	203	5.8687207813730666e+01
R147_205	147	205	1.0254752245067112e+02
R147_207	147	207	4.5315926557162449e+01
R147_210	147	210	1.2078100711169235e+02
R147_220	147	220	6.7132596108218138e+01
R148_149	148	149	1.3182781908154677e+01
R148_150	148	150	2.7570584312198275e+01
R148_184	148	184	1.8980972746205822e+01
R148_186	148	186	1.7972592204531558e+01
R148_197	148	197	3.0437687360762581e+01
R148_152	148	152	1.8204867401108217e+01
R148_204	148	204	4.1442162864444860e+01
R148_205	148	205	3.2256124406951457e+01
R148_206	148	206	2.3045414091492670e+01
R148_222	148	222	6.3593154485863330e+01
R149_150	149	150	1.8127314945188840e+02
R149_156	149	156	9.9964648594460542e+01
R149_153	149	153	5.8678376908178784e+01
R149_204	149	204	9.3580304338430253e+01
R149_206	149	206	5.5971407494126467e+01
R149_152	149	152	6.1899420594044400e+01
R149_222	149	222	9.1595027243080878e+01
R150_185	150	185	5.5007809155262642e+01
R150_186	150	186	3.6779904067095970e+01
R150_190	150	190	9.1048513491772397e+01
R150_221	150	221	3.8945511279294671e+01
R150_222	150	222	4.1166776422517380e+01
R150_223	150	223	1.2295990452487032e+02
R151_154	151	154	8.9557813333949127e+01
R151_159	151	159	6.4088361856204742e+01
R151_217	151	217	1.0911182153336140e+01
R151_224	151	224	1.0325879697013531e+02
R151_225	151	225	7.9184863038333162e+01
R152_197	152	197	4.9288308253280144e+00
R152_186	152	186	1.6147761967473375e+01
R152_206	152	206	6.4870347187920165e+00
R152_153	152	153	8.2518669526499302e+00
R152_213	152	213	1.1773041681773243e+01
R152_221	152	221	2.1232932126241561e+01
R152_222	152	222	1.0371446495047126e+01
R152_226	152	226	7.7318405601916949e+00
R153_156	153	156	9.9114391357364902e+00
R153_206	153	206	1.8862478165916023e+01
R153_212	153	212	3.1054402742098279e+01
R153_213	153	213	1.7071773773818894e+01
R153_222	153	222	2.6033205475721424e+01
R153_226	153	226	1.0175464240658973e+01
R153_228	153	228	5.3661911377051382e+01
R153_230	153	230	1.1935321319030898e+01
R154_155	154	155	1.2225870917803672e+01
R154_157	154	157	3.7334875606276412e+01
R154_208	154	208	2.7387241806840517e+01
R154_217	154	217	4.1441867767009860e+01
R154_225	154	225	3.5116957775979529e+01
R154_232	154	232	4.1707543293766669e+01
R155_157	155	157	5.9068636585985452e+01
R155_204	155	204	8.8349124640160085e+01
R155_208	155	208	4.0698027327472602e+01
R155_212	155	212	6.2022266885802779e+01
R155_232	155	232	7.9794272390616456e+01
R156_158	156	158	6.2525421188150837e+01
R156_212	156	212	5.2010402921895647e+01
R156_222	156	222	1.2233230667775746e+02
R156_228	156	228	8.9668612887840013e+01
R156_230	156	230	2.7845223723103913e+01
R156_231	156	231	7.7748884261454577e+01
R156_233	156	233	9.1373454240209824e+01
R157_158	157	158	5.7205943745500115e+01
R157_212	157	212	4.7776867988519022e+01
R157_232	157	232	9.8137567463016453e+01
R157_233	157	233	1.4682657626706666e+02
R158_212	158	212	1.4063024434827423e+02
R158_231	158	231	4.0678086284353668e+02
R158_233	158	233	1.3558685002008832e+02
R159_160	159	160	8.0798684343198062e+01
R159_163	159	163	1.5835932045327414e+02
R159_189	159	189	1.3014958562967999e+02
R159_217	159	217	1.2640021983964427e+02
R159_218	159	218	3.0731388076521448e+01
R159_224	159	224	1.5562779213632578e+02
R159_234	159	234	1.7639026968701404e+02
R160_161	160	161	1.4054667130909800e+02
R160_163	160	163	5.8182435114148802e+01
R160_188	160	188	8.1561354757539817e+01
R160_189	160	189	3.0905764191717896e+01
R160_234	160	234	1.5338856431840782e+02
R160_235	160	235	9.5138751129802301e+01
R161_165	161	165	1.8476142701488529e-06
R161_188	161	188	5.6319859672943551e+01
R161_235	161	235	1.8476142886249957e+02
R162_163	162	163	1.5759796372142311e+01
R162_164	162	164	5.2251550705092828e-07
R162_165	162	165	3.1491394664760754e-07
R162_166	162	166	1.9880360371463972e+01
R162_167	162	167	1.5086629577919481e+01
R162_174	162	174	1.8749546607742719e+01
R162_239	162	239	3.2068163513927708e+01
R163_165	163	165	3.8858508861137111e+01
R163_167	163	167	1.6782378381687423e+01
R163_188	163	188	1.4251394013219004e+01
R163_189	163	189	5.4123480777438928e+00
R163_215	163	215	1.8282651736074996e+01
R163_218	163	218	1.3696771905226493e+01
R163_238	163	238	1.4036425819266965e+01
R163_239	163	239	2.8595847167184477e+01
R164_165	164	165	2.0722259072067530e-06
R164_166	164	166	3.0364085575150597e+01
R164_177	164	177	9.0009500979861528e+01
R164_239	164	239	7.6968121284544651e+01
R165_188	165	188	4.7486074898585969e+01
R165_239	165	239	8.3648110807467035e+01
R166_167	166	167	2.0884021519613885e+01
R166_174	166	174	1.6610486419456617e+01
R166_176	166	176	2.0344921420457453e+01
R166_177	166	177	1.3087814516194173e+01
R166_239	166	239	3.2334007712679394e+01
R166_240	166	240	1.4527596693688780e+01
R167_174	167	174	1.0358920620286984e+01
R167_173	167	173	3.9543897667928867e+01
R167_215	167	215	2.2993451267571217e+01
R167_238	167	238	2.7854083177586201e+01
R167_239	167	239	2.0888034038236256e+01
R167_240	167	240	1.0450270577318705e+01
R167_242	167	242	2.0349473430527993e+01
R168_170	168	170	4.3514620402569442e+01
R168_171	168	171	6.5649462386885773e+01
R168_175	168	175	1.7847968800285638e+01
R168_176	168	176	2.6990971923298041e+01
R168_179	168	179	2.9047921720384519e+01
R168_181	168	181	1.0468731806151450e+01
R168_187	168	187	4.4632413452993248e+01
R168_245	168	245	4.0327058119272301e+01
R169_170	169	170	2.4665345421128752e+01
R169_171	169	171	1.6156963574320912e+01
R169_180	169	180	1.9671410528639619e+01
R169_172	169	172	1.3937683274116178e+01
R169_191	169	191	4.9260331443223677e+01
R169_245	169	245	5.3845258368085453e+01
R170_171	170	171	4.3899188763780295e+01
R170_179	170	179	1.5352241752244810e+01
R170_180	170	180	2.1215101324162486e+01
R170_245	170	245	3.3302361652394787e+01
R171_187	171	187	6.0959793352318918e+01
R171_191	171	191	5.3764364794217009e+01
R171_172	171	172	3.3660272038078901e+01
R171_245	171	245	1.7750303824226048e+01
R171_247	171	247	3.4901968345476575e+01
R172_180	172	180	9.4200527923387671e+00
R172_191	172	191	1.0572540751844999e+01
R172_200	172	200	1.5117404930635470e+01
R172_198	172	198	2.0504089718719879e+01
R172_203	172	203	2.2785009399389669e+01
R172_244	172	244	9.5870677469952916e+00
R172_245	172	245	1.7317691989432639e+01
R172_246	172	246	1.6011250221603888e+01
R172_247	172	247	2.8598301782418080e+01
R173_174	173	174	1.3265027227735580e+01
R173_179	173	179	1.5984416077742477e+01
R173_202	173	202	1.3180014132516325e+01
R173_210	173	210	1.5433882394353429e+01
R173_211	173	211	1.5762665906298295e+01
R173_215	173	215	3.8703539551586658e+01
R173_237	173	237	2.2111587526218756e+01
R173_242	173	242	2.4615508233641936e+01
R173_248	173	248	5.0188674719302568e+01
R174_176	174	176	8.6464417429754086e+00
R174_179	174	179	2.1376798824458017e+01
R174_240	174	240	1.8404429014409303e+01
R174_242	174	242	2.9143314700530659e+01
R174_248	174	248	2.2525520849811219e+01
R175_176	175	176	1.3650938714688722e+01
R175_177	175	177	2.5576845667246427e+01
R175_178	175	178	9.9674957431405815e+00
R175_181	175	181	8.1269593776237912e+00
R175_182	175	182	2.3747195137970415e+01
R175_251	175	251	2.5308844737935548e+01
R176_177	176	177	1.5781606943156188e+01
R176_179	176	179	1.1234096137524620e+01
R176_181	176	181	1.1003419146514323e+01
R176_240	176	240	1.9700309667951707e+01
R176_248	176	248	8.1324013859358413e+00
R176_251	176	251	3.4622784927838737e+01
R177_178	177	178	3.1850472411442908e+01
R177_239	177	239	3.8974386713048865e+01
R177_240	177	240	1.4893609373714876e+01
R177_241	177	241	2.1413494507058871e+01
R177_248	177	248	3.2608175543683885e+01
R177_251	177	251	2.6975636232060847e+01
R178_182	178	182	3.3923314653196748e+01
R178_251	178	251	3.8887152103867052e+01
R179_180	179	180	1.1488256578710212e+01
R179_181	179	181	1.4066806498917790e+01
R179_202	179	202	1.2649443915098713e+01
R179_245	179	245	1.1063874401319728e+01
R179_248	179	248	1.5142083260925327e+01
R179_252	179	252	1.4462307487612069e+01
R180_202	180	202	4.5889158741176921e+00
R180_203	180	203	7.7255633928164773e+00
R180_244	180	244	9.9423534796257762e+00
R180_245	180	245	7.9328932931194611e+00
R180_250	180	250	2.7309293836074314e+01
R180_252	180	252	3.1406505286420245e+01
R181_182	181	182	4.5260187547985517e+01
R181_187	181	187	1.1642692451991900e+01
R181_245	181	245	1.5996037561127388e+01
R181_248	181	248	3.5750466699346227e+01
R181_251	181	251	1.7977160304945919e+01
R181_252	181	252	2.2698599497455408e+01
R181_253	181	253	3.6144365900009944e+01
R182_187	182	187	4.7931279146235646e+01
R182_251	182	251	3.5229705505078492e+01
R182_254	182	254	1.3662421433650513e+02
R183_184	183	184	1.0091569651047022e+01
R183_185	183	185	1.2210042401556644e+01
R183_192	183	192	1.2484106954030345e+01
R183_193	183	193	2.0608001458893444e+01
R183_198	183	198	2.4816209234041640e+01
R183_199	183	199	1.8309584669725556e+01
R183_200	183	200	1.3380810603299095e+01
R183_201	183	201	5.6546536418752096e+00
R183_255	183	255	1.6126985921380829e+01
R184_185	184	185	2.1954374489484103e+01
R184_186	184	186	8.8371426322142703e+00
R184_197	184	197	2.5788788197861134e+01
R184_199	184	199	6.9689106949281863e+00
R184_201	184	201	1.9197723596975873e+01
R184_205	184	205	8.6944490900226405e+00
R184_255	184	255	2.4578593061189498e+01
R184_256	184	256	1.1816993446479566e+01
R185_186	185	186	1.0853600200869890e+01
R185_190	185	190	1.1291669273012017e+01
R185_193	185	193	1.0114308327110557e+01
R185_194	185	194	3.1765514018675656e+01
R185_196	185	196	1.7103015091519495e+01
R185_221	185	221	2.6366512923710573e+01
R185_255	185	255	1.3880442403427278e+01
R185_258	185	258	3.0059735433404974e+01
R186_197	186	197	6.6588581663134985e+00
R186_221	186	221	7.6422043092769636e+00
R186_222	186	222	4.1670587149822104e+01
R186_255	186	255	2.6533435191232893e+01
R186_256	186	256	2.6794330977197347e+01
R186_257	186	257	1.2108660396963163e+01
R186_258	186	258	2.9828577710925686e+01
R187_245	187	245	2.2378853401548561e+01
R187_247	187	247	5.1251689170455151e+01
R187_251	187	251	6.0569261054139481e+01
R187_253	187	253	2.4401210077822249e+01
R187_254	187	254	5.4446383711326973e+01
R187_260	187	260	8.4455230721493422e+01
R188_189	188	189	1.5913201422524001e+01
R188_235	188	235	1.8992455406854251e+01
R188_238	188	238	3.2873616403533383e+01
R188_239	188	239	3.2365503722396532e+01
R188_262	188	262	2.9584482399656217e+01
R189_218	189	218	1.3479394508317156e+01
R189_215	189	215	2.2638422279030866e+01
R189_234	189	234	5.8738506239824257e+00
R189_235	189	235	1.7977712963862942e+01
R189_238	189	238	7.6049948646473986e+00
R189_262	189	262	2.1121878696503675e+01
R190_194	190	194	4.0752068154832344e+01
R190_193	190	193	6.9057665029602305e+01
R190_195	190	195	5.0714873335156376e+01
R190_196	190	196	1.2841983327505298e+01
R190_221	190	221	6.0438604125619534e+01
R190_223	190	223	4.6373876627363657e+01
R190_263	190	263	7.3365578885978181e+01
R191_198	191	198	1.2964533885256440e+01
R191_192	191	192	1.0325060963440913e+02
R191_200	191	200	3.9741177734922537e+01
R191_246	191	246	4.2297411372140601e+01
R191_247	191	247	5.2119748133500167e+01
R191_269	191	269	6.5770827040886374e+01
R191_270	191	270	1.0373550989689177e+02
R192_193	192	193	1.1720032648957686e+01
R192_194	192	194	4.1865398437938374e+01
R192_198	192	198	1.2597809308985099e+01
R192_201	192	201	2.4585106271315716e+01
R192_255	192	255	3.2219774419443311e+01
R192_264	192	264	1.7648939528401499e+01
R192_270	192	270	2.8234557559914421e+01
R192_271	192	271	3.0608604102963767e+01
R193_194	193	194	8.0893203397429545e+00
R193_196	193	196	1.4272955962570508e+01
R193_255	193	255	9.4375403963667797e+00
R193_264	193	264	3.8838877122143288e+01
R193_265	193	265	1.0879087205193262e+01
R193_271	193	271	2.4402579722250568e+01
R193_272	193	272	5.4240398850632701e+01
R194_195	194	195	2.8777994949062677e+01
R194_196	194	196	2.4190259346107599e+01
R194_271	194	271	4.1472176819171473e+01
R194_272	194	272	3.0813962276717362e+01
R195_196	195	196	5.4435052539096546e+01
R195_263	195	263	4.5182818924202699e+01
R195_272	195	272	4.9242138420292974e+01
R195_273	195	273	1.6532295339149928e+02
R196_221	196	221	2.7970531033142798e+01
R196_223	196	223	1.8038716120073310e+01
R196_255	196	255	2.3061115838091908e+01
R196_258	196	258	5.9300444160849795e+00
R196_263	196	263	1.1852559484202295e+01
R196_265	196	265	1.7877277419706644e+01
R196_268	196	268	1.1869621721979605e+01
R196_272	196	272	1.9441486512411622e+01
R196_267	196	267	2.2246425985889815e+01
R196_275	196	275	2.4076705800383106e+01
R197_205	197	205	1.4324244473744187e+01
R197_206	197	206	1.7144042932853743e+01
R197_213	197	213	1.0342580754700540e+01
R197_214	197	214	4.7130750821263678e+00
R197_221	197	221	1.1021238103570525e+01
R197_226	197	226	1.3712264743682995e+01
R197_227	197	227	2.7752633698080530e+01
R197_256	197	256	1.8423954131707337e+01
R197_257	197	257	1.6824078789977335e+01
R197_274	197	274	3.5739812644990174e+01
R197_276	197	276	3.2167536126507095e+01
R198_200	198	200	7.5324342675853577e+00
R198_201	198	201	2.0525570888647273e+01
R198_244	198	244	3.2493805224998631e+01
R198_246	198	246	3.0824137764428556e+01
R198_259	198	259	1.9659787249104369e+01
R198_264	198	264	2.6997902579166897e+01
R198_269	198	269	7.4669966767887274e+01
R198_270	198	270	3.5381139606610354e+01
R198_279	198	279	3.2841289419297439e+01
R199_200	199	200	8.2489258065900106e+00
R199_201	199	201	9.7019826036164840e+00
R199_203	199	203	1.2571573414877298e+01
R199_205	199	205	1.6707583731044839e+01
R199_207	199	207	3.1167049887365614e+01
R199_220	199	220	1.0951700116104835e+01
R199_256	199	256	1.4650092430622776e+01
R199_279	199	279	2.0399197560873777e+01
R200_201	200	201	1.1767542071202486e+01
R200_203	200	203	1.3471238432605139e+01
R200_244	200	244	2.8358726371828052e+01
R200_279	200	279	2.1770899838587752e+01
R201_255	201	255	1.2212428354059849e+01
R201_256	201	256	2.5472773101531828e+01
R201_264	201	264	2.2473190669887295e+01
R201_279	201	279	1.1900638902568096e+01
R202_203	202	203	1.5670558838376921e+01
R202_210	202	210	1.4843206104390429e+01
R202_237	202	237	3.4705041806333895e+01
R202_242	202	242	5.8678971893591381e+01
R202_244	202	244	1.7282483026933068e+01
R202_248	202	248	5.0084229721450470e+01
R202_249	202	249	1.5290038383868225e+01
R202_250	202	250	3.5551677567232886e+01
R202_252	202	252	3.3067083774495273e+01
R202_280	202	280	2.3678704617129839e+01
R203_210	203	210	2.3602970757921582e+01
R203_220	203	220	2.8833377344137268e+01
R203_244	203	244	1.8368063952664091e+01
R203_279	203	279	3.8865695433864907e+01
R203_280	203	280	3.8707948557249395e+01
R204_205	204	205	2.0553202658070525e+01
R204_206	204	206	9.7514163297228240e+00
R204_207	204	207	2.5611533348818131e+01
R204_208	204	208	2.7809125095862495e+01
R204_209	204	209	2.6575728125307435e+01
R204_212	204	212	1.6981806174458871e+01
R204_281	204	281	2.2225773297542226e+01
R205_206	205	206	1.7205163707080690e+01
R205_207	205	207	5.5738572891192195e+00
R205_213	205	213	3.1313220269159096e+01
R205_214	205	214	1.9251183004470338e+01
R205_220	205	220	1.0862417873851484e+01
R205_256	205	256	1.2662482509926106e+01
R205_281	205	281	1.8601216724406154e+01
R206_212	206	212	1.6436916667228793e+01
R206_213	206	213	5.3535821829690935e+00
R206_281	206	281	3.4155958326260247e+01
R207_209	207	209	1.0695811235560251e+01
R207_220	207	220	5.0098578116602805e+00
R207_281	207	281	3.0676443606819070e+01
R208_209	208	209	1.3276524984077197e+01
R208_212	208	212	4.1918468184072012e+01
R208_217	208	217	3.5144201545069791e+01
R208_219	208	219	1.2210871323843413e+01
R208_225	208	225	2.0788534291031539e+01
R208_232	208	232	1.7076630432944796e+01
R208_281	208	281	1.5478646407660751e+01
R208_282	208	282	2.7477259488376440e+01
R209_211	209	211	1.1915558906826265e+01
R209_210	209	210	2.7767163465642948e+01
R209_216	209	216	3.6739606470499112e+01
R209_219	209	219	1.3645078962313969e+01
R209_220	209	220	2.0687548627780750e+01
R209_281	209	281	2.1678514688999698e+01
R209_283	209	283	2.5397152742449911e+01
R210_211	210	211	1.0459454714724192e+01
R210_220	210	220	1.5361651680270162e+01
R210_237	210	237	2.9928648351922430e+01
R210_280	210	280	1.4238929216877386e+01
R210_283	210	283	4.3178284075962843e+01
R211_215	211	215	3.3981375262849049e+01
R211_216	211	216	7.8857593409820819e+00
R211_219	211	219	9.7738733811832486e+00
R211_237	211	237	8.6403496424204480e+00
R211_280	211	280	3.1287300332446488e+01
R211_283	211	283	3.4868967902229763e+01
R212_213	212	213	1.3794202269727746e+01
R212_230	212	230	2.0479251728655630e+01
R212_229	212	229	3.6417543249810798e+01
R212_232	212	232	2.3226745238902062e+01
R212_233	212	233	1.0978778688988850e+01
R212_281	212	281	2.2773583372240843e+01
R212_285	212	285	3.4266552043998949e+01
R213_214	213	214	5.8957588018788929e+00
R213_226	213	226	7.0422067351471114e+00
R213_229	213	229	1.1668560737302473e+01
R213_230	213	230	2.1387712252583597e+01
R213_281	213	281	2.2265868797694093e+01
R213_285	213	285	2.9404117923140699e+01
R214_226	214	226	1.7711965349272187e+01
R214_227	214	227	1.9759946185526104e+01
R214_229	214	229	1.3804289405518141e+01
R214_256	214	256	1.5526233749044987e+01
R214_220	214	220	3.9285138756138416e+01
R214_257	214	257	2.7737327733823708e+01
R214_274	214	274	2.9910604481619458e+01
R214_276	214	276	2.0566580503956413e+01
R214_281	214	281	1.3463499682906470e+01
R214_284	214	284	5.6676692702709826e+00
R214_285	214	285	1.5118660050393103e+01
R214_286	214	286	1.1911013802895472e+01
R215_216	215	216	1.7272405052465842e+01
R215_218	215	218	7.7916816111129448e+00
R215_234	215	234	3.7788231401692300e+01
R215_237	215	237	1.2181448288592957e+01
R215_238	215	238	8.0345471278092244e+00
R215_242	215	242	2.1717845356149418e+01
R215_243	215	243	1.2509026107496917e+01
R215_287	215	287	8.7852292765787787e+00
R216_217	216	217	4.6637741320092578e+00
R216_218	216	218	1.4560224243904967e+01
R216_219	216	219	6.5550155537844050e+00
R216_237	216	237	2.0221590424131101e+01
R216_287	216	287	1.3462883815206542e+01
R217_218	217	218	2.1159304010536150e+01
R217_219	217	219	2.1035100849033626e+01
R217_224	217	224	1.1886313332688632e+01
R217_225	217	225	1.3942665239313996e+01
R217_287	217	287	3.9436753014167351e+01
R218_224	218	224	2.2557283781695197e+01
R218_234	218	234	1.7254115319855558e+01
R218_287	218	287	1.8760955640195402e+01
R219_225	219	225	3.9265728500779353e+01
R219_224	219	224	4.4787991008677942e+01
R219_237	219	237	1.7422181574932438e+01
R219_280	219	280	3.7779135395388209e+01
R219_281	219	281	3.0904272906374374e+01
R219_282	219	282	8.0999396780957635e+00
R219_283	219	283	1.3394849693149865e+01
R219_287	219	287	1.5297795900704520e+01
R219_288	219	288	1.8317188924211308e+01
R220_256	220	256	1.0227382348299797e+01
R220_279	220	279	2.1986558709569394e+01
R220_280	220	280	1.2399212772980579e+01
R220_281	220	281	1.5190128809121818e+01
R220_283	220	283	7.8758867671111750e+00
R220_284	220	284	2.6985394291781954e+01
R220_289	220	289	2.5002108802276375e+01
R221_222	221	222	1.1740548538152670e+01
R221_223	221	223	1.0093371604863449e+01
R221_226	221	226	2.4572543826338045e+01
R221_227	221	227	1.5703023687274364e+01
R221_257	221	257	1.8757929775585140e+01
R221_258	221	258	7.5952090557627878e+00
R221_274	221	274	1.4849649433465968e+01
R221_275	221	275	2.0594997655337142e+01
R221_276	221	276	1.6365851392752827e+01
R221_292	221	292	2.7771227752190164e+01
R222_223	222	223	8.2355812953078456e+01
R222_226	222	226	1.7075456072488684e+01
R222_227	222	227	2.9990867376549989e+01
R222_228	222	228	3.3760327158300491e+01
R222_292	222	292	5.7425130023466821e+01
R223_258	223	258	5.0355938067085276e+01
R223_263	223	263	5.8804347216741078e+01
R223_275	223	275	2.0220898957065508e+01
R223_236	223	236	8.3091157619561486e+01
R223_292	223	292	3.7180654769221931e+01
R224_225	224	225	2.0835609128608365e+01
R224_234	224	234	5.3943745178292708e+01
R224_282	224	282	5.3520868944419114e+01
R224_287	224	287	1.5505601696949750e+01
R224_291	224	291	2.9832646275335556e+01
R224_295	224	295	4.9622884837088655e+01
R224_296	224	296	4.8205334758197374e+01
R225_232	225	232	9.5157661974408711e+01
R225_282	225	282	1.1315003146611001e+02
R225_296	225	296	1.7513065900855227e+02
R226_227	226	227	7.2565274133362445e+00
R226_228	226	228	4.1027574136119988e+01
R226_229	226	229	1.5679297134693980e+01
R226_230	226	230	1.6862308521473068e+01
R226_297	226	297	5.0152557866875441e+01
R227_228	227	228	4.2418953392542761e+01
R227_229	227	229	2.3973846263794893e+01
R227_274	227	274	7.5533355013641863e+00
R227_286	227	286	4.1654604008717023e+01
R227_292	227	292	5.4236163001812024e+01
R227_293	227	293	2.4079950190888709e+01
R227_297	227	297	2.3703758792695652e+01
R227_300	227	300	3.9469073998670858e+01
R228_230	228	230	2.8219970226377384e+01
R228_231	228	231	8.0037894926927251e+01
R228_292	228	292	8.8029866729969129e+01
R228_293	228	293	5.3019247758531698e+01
R228_297	228	297	1.4226337870981073e+01
R228_298	228	298	9.0066058963569020e+01
R228_299	228	299	7.0967812151274728e+01
R228_302	228	302	8.7314686996913082e+01
R229_230	229	230	2.3854678520580116e+01
R229_233	229	233	1.6048396973000956e+02
R229_285	229	285	3.1930417780366568e+01
R229_286	229	286	5.6917042389622118e+01
R229_297	229	297	6.3129846570361714e+01
R229_300	229	300	9.5798232147945399e+01
R229_301	229	301	1.0939874808340362e+02
R229_302	229	302	7.1917468942293141e+01
R230_231	230	231	3.3859840852410656e+01
R230_233	230	233	2.6505727130031079e+01
R230_297	230	297	3.1776224299485218e+01
R230_302	230	302	2.9368183580511943e+01
R231_233	231	233	6.1241646666402218e+01
R231_299	231	299	1.9110328261275464e+02
R231_302	231	302	6.3999631442582668e+01
R232_233	232	233	1.2147790148253461e+02
R232_281	232	281	1.2034685925463938e+02
R232_282	232	282	1.0926979690280302e+02
R232_285	232	285	1.3926358530073202e+02
R232_294	232	294	1.2966820886084594e+02
R232_296	232	296	1.5207379664502469e+02
R232_303	232	303	1.4180376441165663e+02
R233_285	233	285	3.4871417247372875e+01
R233_302	233	302	3.2174643818687741e+01
R233_303	233	303	6.0014873690283430e+01
R234_235	234	235	9.3254359603539314e+01
R234_238	234	238	4.2958074514397566e+01
R234_262	234	262	6.8259283095049867e+01
R234_261	234	261	4.8587756654877090e+01
R234_287	234	287	5.7176444910826426e+01
R234_291	234	291	9.2396865505702550e+01
R234_305	234	305	1.5683999427981843e+02
R234_306	234	306	9.2805696251109111e+01
R235_262	235	262	3.7032266268392171e+01
R235_306	235	306	1.3679489695841437e+02
R236_267	236	267	1.7286577460113264e+01
R236_275	236	275	1.7016351670264019e+01
R236_263	236	263	3.3557005709401636e+01
R236_278	236	278	1.3983723892986815e+01
R236_292	236	292	4.1615954228734303e+01
R236_304	236	304	2.7868866973571031e+01
R236_307	236	307	4.0968573423054657e+01
R236_308	236	308	1.1824382040686547e+01
R236_309	236	309	6.2581763514414291e+01
R237_242	237	242	3.2229828564834584e+01
R237_243	237	243	1.5272288843246129e+01
R237_249	237	249	4.0017499195682262e+01
R237_280	237	280	1.4911726227992522e+01
R237_287	237	287	1.5425560194335654e+01
R237_288	237	288	1.9913648478717356e+01
R237_290	237	290	4.7836022225627964e+01
R237_311	237	311	2.8131230067543601e+01
R238_239	238	239	4.0014998997420484e+01
R238_240	238	240	6.9675576006679677e+01
R238_242	238	242	4.2346018503194735e+01
R238_243	238	243	2.1943741479300915e+01
R238_262	238	262	1.6127928804081986e+01
R238_261	238	261	1.5605063297989050e+01
R238_287	238	287	5.8565823337787357e+01
R238_313	238	313	4.4771361992478745e+01
R239_240	239	240	1.0996284776940630e+01
R239_241	239	241	6.6012125150772249e+01
R239_262	239	262	7.8656215773547387e+01
R239_313	239	313	6.4575141326707595e+01
R240_241	240	241	1.6769143228224547e+01
R240_242	240	242	1.7049070520119496e+01
R240_248	240	248	1.1780642749991539e+01
R240_313	240	313	3.9338746666614568e+01
R241_248	241	248	1.2742782520741411e+01
R241_251	241	251	4.6088974832881426e+01
R241_312	241	312	2.8827507860257700e+01
R241_313	241	313	3.6420940109727852e+01
R242_243	242	243	7.6237105443948749e+00
R242_248	242	248	8.4219287401328824e+00
R242_249	242	249	2.2230692699268197e+01
R242_313	242	313	3.0885990681467920e+01
R242_315	242	315	2.0020748864620774e+01
R243_249	243	249	3.2177324514602830e+01
R243_287	243	287	1.8117875277814843e+01
R243_261	243	261	1.3658756898261212e+01
R243_290	243	290	1.8532849560291066e+01
R243_311	243	311	1.7403720842654423e+01
R243_313	243	313	2.6879525179124268e+01
R243_315	243	315	9.9253800604243700e+00
R243_316	243	316	1.6326583190620966e+01
R244_245	244	245	3.5465177721034614e+01
R244_246	244	246	8.3195668582752482e+00
R244_250	244	250	1.0819201964459550e+01
R244_249	244	249	3.2753281221254547e+01
R244_259	244	259	2.0246469752641026e+01
R244_279	244	279	1.3994365805702405e+01
R244_280	244	280	2.6203029945096230e+01
R244_310	244	310	1.7246690102870151e+01
R244_317	244	317	2.1328463153335854e+01
R245_246	245	246	4.1267390529695966e+01
R245_247	245	247	1.6647669047002974e+01
R245_250	245	250	2.4404257250696102e+01
R245_252	245	252	2.3258637663184739e+01
R245_253	245	253	1.6601338354456374e+01
R245_318	245	318	3.3234280867054622e+01
R246_247	246	247	4.0852387104815669e+01
R246_250	246	250	5.3473456670809163e+01
R246_259	246	259	4.0438173393170899e+01
R246_269	246	269	1.9726055435236994e+01
R246_317	246	317	1.2894857340531136e+01
R246_318	246	318	1.9292272690195936e+01
R247_253	247	253	6.1180819537608137e+01
R247_260	247	260	6.2612610759065220e+01
R247_269	247	269	6.6036292631935424e+01
R247_318	247	318	2.9749011833737772e+01
R248_249	248	249	4.1764308563471388e+01
R248_251	248	251	4.1543529525139107e+01
R248_252	248	252	1.4793261680159123e+01
R248_312	248	312	3.1223427800159413e+01
R248_313	248	313	6.7392295896332925e+01
R248_315	248	315	5.7996223916318662e+01
R248_319	248	319	7.8775464982326938e+01
R249_250	249	250	7.3436536104941537e+00
R249_252	249	252	1.1587648005334378e+01
R249_280	249	280	2.2349054400896240e+01
R249_310	249	310	2.1178423814271508e+01
R249_311	249	311	7.5401374526133793e+00
R249_315	249	315	1.1537774876167564e+01
R249_319	249	319	5.1357805573306141e+00
R250_252	250	252	1.5536416360272900e+01
R250_253	250	253	2.5294127772737120e+01
R250_310	250	310	6.4789070605267725e+01
R250_317	250	317	4.7577500781226867e+01
R250_318	250	318	2.2283687875154151e+01
R250_319	250	319	2.3640616086891427e+01
R250_320	250	320	1.9874094334113806e+01
R251_252	251	252	3.9389873171850098e+01
R251_253	251	253	4.7282310789918753e+01
R251_254	251	254	5.3380437969141731e+01
R251_312	251	312	3.8704786646867738e+01
R251_321	251	321	5.2611936604779935e+01
R252_253	252	253	6.9356922319409424e+00
R252_312	252	312	2.4477411577206617e+01
R252_319	252	319	1.0757983478375090e+01
R252_321	252	321	3.1297764590418922e+01
R253_254	253	254	5.9181189226610947e+01
R253_260	253	260	2.0168926894626743e+01
R253_318	253	318	1.0999190437174750e+01
R253_319	253	319	6.5617975961218022e+01
R253_320	253	320	3.4842692224051241e+01
R253_321	253	321	3.6715223133972302e+01
R253_322	253	322	3.3878919694903225e+01
R254_260	254	260	7.2280638424893240e+01
R254_321	254	321	6.5468931690571367e+01
R254_322	254	322	7.9796432350695540e+01
R254_323	254	323	1.0676875861632867e+02
R255_256	255	256	1.6944639268573045e+01
R255_257	255	257	8.1929217394293268e+00
R255_258	255	258	1.2391543433177594e+01
R255_264	255	264	1.0158220154106827e+01
R255_265	255	265	6.8464188031902307e+00
R255_266	255	266	9.8117100190643445e+00
R255_279	255	279	3.2467015155305319e+01
R255_324	255	324	2.2741748928969400e+01
R256_257	256	257	6.0362213413997328e+00
R256_279	256	279	9.8062871864827343e+00
R256_284	256	284	1.0852087686650844e+01
R256_289	256	289	1.8137853623394729e+01
R256_324	256	324	1.8234246216809566e+01
R257_258	257	258	1.2860790443362989e+01
R257_266	257	266	1.4408283582739724e+01
R257_276	257	276	1.2015495372431657e+01
R257_284	257	284	3.9027772901554904e+01
R257_324	257	324	2.9281455517068995e+01
R258_265	258	265	4.6982079995365581e+01
R258_266	258	266	1.1617071971927544e+01
R258_268	258	268	2.0433463881509038e+01
R258_275	258	275	1.9344196153030140e+01
R258_276	258	276	2.4151694171898271e+01
R258_326	258	326	4.5259570143100468e+01
R259_269	259	269	2.1999794252629272e+01
R259_264	259	264	7.5535089761613063e+00
R259_270	259	270	1.4189479822534787e+01
R259_279	259	279	1.3063785435837882e+01
R259_310	259	310	2.5379206974819962e+01
R259_317	259	317	6.2945908134677584e+00
R259_327	259	327	4.6668621911587209e+00
R259_328	259	328	1.7799831792550393e+01
R259_329	259	329	9.6031423310257225e+00
R260_318	260	318	2.0265382761630740e+01
R260_269	260	269	1.0482555102110153e+02
R260_322	260	322	2.7323199919143494e+01
R260_323	260	323	1.0770523723892862e+02
R260_330	260	330	7.2618172390118289e+01
R261_262	261	262	2.3857361590268862e+01
R261_287	261	287	4.7009277958796240e+01
R261_290	261	290	2.8010547312029743e+01
R261_291	261	291	7.9853820217196500e+01
R261_305	261	305	2.8950550629243391e+01
R261_306	261	306	4.6212018456902165e+01
R261_313	261	313	3.8583808561599824e+01
R261_316	261	316	1.5276245744899297e+01
R261_331	261	331	2.1354608857812650e+01
R262_306	262	306	3.0868599249227188e+01
R262_313	262	313	5.1463998786212017e+01
R262_331	262	331	7.1705359216755738e+01
R263_272	263	272	5.0372021398383005e+01
R263_267	263	267	1.3626400256395955e+01
R263_273	263	273	6.5088552417362067e+01
R263_275	263	275	7.6784115401816294e+01
R263_307	263	307	6.7402356733739225e+01
R263_334	263	334	3.8311930671753579e+01
R264_265	264	265	2.9551140199779272e+01
R264_266	264	266	8.2548786622294699e+01
R264_270	264	270	4.7484179174172773e+01
R264_271	264	271	5.8873073466126819e+01
R264_279	264	279	3.1869185105810061e+01
R264_324	264	324	4.7015927000674189e+01
R264_327	264	327	4.3703808833033619e+01
R264_328	264	328	4.8463185473145650e+01
R264_336	264	336	3.2208728688739455e+01
R265_266	265	266	1.3820075780637165e+01
R265_268	265	268	9.2281280294891754e+00
R265_271	265	271	1.8843100496799259e+01
R265_272	265	272	4.5757291595710512e+01
R265_333	265	333	2.5894673374422585e+01
R265_336	265	336	1.0759929856799657e+01
R266_268	266	268	1.2103310049788750e+01
R266_276	266	276	1.7638254761109632e+01
R266_324	266	324	1.0481849477347065e+01
R266_326	266	326	1.0246572639170804e+01
R266_336	266	336	1.3018872101781174e+01
R267_272	267	272	3.2869245679327889e+01
R267_268	267	268	2.0206166498401821e+01
R267_275	267	275	2.8997736567537018e+01
R267_277	267	277	2.7209150701811687e+01
R267_278	267	278	4.1846065290962144e+01
R267_307	267	307	2.6889243077667949e+01
R267_308	267	308	1.6567862424127288e+01
R267_333	267	333	3.8243592637918780e+01
R267_334	267	334	6.5309616964915920e+00
R267_338	267	338	1.3125773279199965e+01
R268_272	268	272	5.7710026260662232e+01
R268_275	268	275	3.4679483492737333e+01
R268_277	268	277	1.0955804689569478e+01
R268_326	268	326	2.4226186902129225e+01
R268_333	268	333	1.2319983097159152e+01
R268_336	268	336	1.4261062264580287e+01
R268_338	268	338	3.3643222025001059e+01
R268_339	268	339	3.7826506751364263e+01
R269_270	269	270	3.5095052063457260e+01
R269_317	269	317	1.8833473066595758e+01
R269_318	269	318	1.8377387050533677e+01
R269_329	269	329	3.1116653052078739e+01
R269_330	269	330	3.6470026262541204e+01
R269_340	269	340	7.3710562360216556e+01
R270_271	270	271	4.5615341670783458e+01
R270_328	270	328	1.7352707361321318e+01
R270_329	270	329	3.6806406348744247e+01
R270_340	270	340	4.5269117458353556e+01
R270_342	270	342	7.2454082358692830e+01
R271_272	271	272	3.7650043737557034e+01
R271_328	271	328	4.1027841760782486e+01
R271_333	271	333	2.4326564748490640e+01
R271_336	271	336	3.8551118640439434e+01
R271_341	271	341	3.4712676921942148e+01
R271_342	271	342	4.5152287885448807e+01
R271_343	271	343	5.2765368382578544e+01
R272_273	272	273	4.8313802659266059e+01
R272_333	272	333	1.5439648424035973e+01
R272_334	272	334	2.3204171795800530e+01
R272_343	272	343	6.7962495091286087e+01
R272_344	272	344	5.0683807993846393e+01
R273_334	273	334	2.3376634544098792e+01
R273_307	273	307	8.6969220939156571e+01
R273_335	273	335	1.0219264195775389e+02
R273_344	273	344	9.0661434617374624e+01
R274_276	274	276	4.0773514825784076e+00
R274_275	274	275	1.8072062204555124e+01
R274_286	274	286	1.1408164757671139e+01
R274_292	274	292	3.2981792333254454e+01
R274_293	274	293	9.8142797196018794e+00
R274_300	274	300	1.4678170362511960e+01
R274_346	274	346	2.4672992231265994e+01
R274_347	274	347	2.3324788841829129e+01
R275_276	275	276	2.4529735289484893e+01
R275_277	275	277	3.2459329265337331e+01
R275_278	275	278	1.2094102422096691e+01
R275_292	275	292	1.8532818986679914e+01
R275_293	275	293	5.2446037410059446e+01
R275_326	275	326	3.4535346632032315e+01
R275_347	275	347	1.8299782038448015e+01
R275_348	275	348	2.9484943221978121e+01
R276_284	276	284	3.1507139499486073e+01
R276_286	276	286	1.7448485384482101e+01
R276_324	276	324	4.8744623805457685e+01
R276_325	276	325	2.2562637327978450e+01
R276_326	276	326	1.4712682693820511e+01
R276_346	276	346	2.2222269098573324e+01
R276_347	276	347	5.9185993818143587e+01
R276_348	276	348	4.5912685154176778e+01
R277_278	277	278	2.1521471918056303e+01
R277_308	277	308	4.3599621585265254e+01
R277_326	277	326	1.2485460234151811e+01
R277_332	277	332	1.0047346798675697e+01
R277_336	277	336	3.9187467539308798e+01
R277_338	277	338	1.2485460234151812e+01
R277_339	277	339	1.6787412828767287e+01
R277_345	277	345	1.1745675294366336e+01
R277_348	277	348	1.3394068071501263e+01
R278_292	278	292	3.7199638495378252e+01
R278_304	278	304	2.0026597963371227e+01
R278_308	278	308	1.1031871398224286e+01
R278_332	278	332	1.3345604654154288e+01
R278_347	278	347	1.0333769849272004e+01
R278_348	278	348	1.6104281827270921e+01
R278_350	278	350	1.6589952821092101e+01
R278_351	278	351	1.5335265540367274e+01
R278_352	278	352	1.0864489103886896e+01
R279_280	279	280	3.1910019502030121e+01
R279_289	279	289	1.9337273863214246e+01
R279_310	279	310	2.1595678715812657e+01
R279_324	279	324	1.5896630282700301e+01
R279_327	279	327	3.1814489194887965e+01
R279_353	279	353	4.8944710148844187e+01
R280_283	280	283	1.5903087875170389e+01
R280_288	280	288	1.8415389289891827e+01
R280_289	280	289	2.8935314723725668e+01
R280_310	280	310	3.5936422715354510e+01
R280_311	280	311	3.8699176829285264e+01
R280_354	280	354	5.6329982292207902e+01
R281_282	281	282	1.4423611797102593e+01
R281_283	281	283	1.0819457280411083e+01
R281_284	281	284	2.5747050802290673e+01
R281_285	281	285	1.9342945893460342e+01
R281_294	281	294	3.1354633701777367e+01
R281_355	281	355	5.1988338662763866e+01
R282_283	282	283	1.8519305360423861e+01
R282_287	282	287	5.0244475789636319e+01
R282_288	282	288	1.7981932569743652e+01
R282_294	282	294	1.3649684790563501e+01
R282_295	282	295	9.9791989990559085e+00
R282_296	282	296	1.9288041182691792e+01
R282_355	282	355	1.8819797582229988e+01
R283_284	283	284	3.1947734472825005e+01
R283_288	283	288	1.5721083007561919e+01
R283_289	283	289	2.3323319993627521e+01
R283_355	283	355	2.1548566937747225e+01
R284_285	284	285	2.8104638189982179e+01
R284_286	284	286	1.7753267317792751e+01
R284_289	284	289	8.4558817495080110e+00
R284_294	284	294	5.4821927753078228e+01
R284_324	284	324	3.5609838095055352e+01
R284_325	284	325	1.5854260914685236e+01
R284_355	284	355	2.9647926521210366e+01
R284_356	284	356	1.7177349492699616e+01
R285_286	285	286	2.2756983274620030e+01
R285_294	285	294	1.0630181018586910e+01
R285_301	285	301	1.6181109526032746e+01
R285_302	285	302	5.5652315737861741e+01
R285_303	285	303	1.7447478002399684e+01
R285_356	285	356	2.2149876095216243e+01
R286_300	286	300	1.6870045691917603e+01
R286_301	286	301	1.6486319308277398e+01
R286_325	286	325	2.2623089737585360e+01
R286_346	286	346	1.4475412114683058e+01
R286_356	286	356	1.6622689177991802e+01
R287_288	287	288	2.9618765672437956e+01
R287_290	287	290	2.7338960534521220e+01
R287_291	287	291	2.3676457202205082e+01
R287_295	287	295	3.5739198714589556e+01
R287_357	287	357	6.0962312544131407e+01
R288_289	288	289	5.3594576235413086e+01
R288_290	288	290	2.9478037025523751e+01
R288_295	288	295	2.6407272039724916e+01
R288_311	288	311	4.0867227602449056e+01
R288_354	288	354	2.6183232039190884e+01
R288_355	288	355	1.4581210512958574e+01
R288_357	288	357	1.5694142542467782e+01
R289_310	289	310	4.4333560595628981e+01
R289_324	289	324	2.0716302403698702e+01
R289_325	289	325	2.2226123265993969e+01
R289_353	289	353	2.2022538686387541e+01
R289_354	289	354	2.4668340197377642e+01
R289_355	289	355	1.8783936972574029e+01
R289_356	289	356	4.4556037235316744e+01
R289_359	289	359	2.6838000567466572e+01
R290_291	290	291	4.0060433303264318e+01
R290_305	290	305	3.5948529723547757e+01
R290_311	290	311	1.9751396461544719e+01
R290_316	290	316	1.1294858512547084e+01
R290_314	290	314	2.9526216161917620e+01
R290_354	290	354	4.3859682953842089e+01
R290_357	290	357	1.6945325360203103e+01
R290_358	290	358	2.5339585688716795e+01
R290_360	290	360	3.4486984049567688e+01
R290_361	290	361	4.3380343059991574e+01
R291_295	291	295	2.0678622479025172e+01
R291_296	291	296	6.0956225862032916e+01
R291_305	291	305	3.6510040431790465e+01
R291_357	291	357	4.1135591419182084e+01
R291_361	291	361	2.6540917596220808e+01
R292_293	292	293	8.0444375453019461e+00
R292_298	292	298	2.6434605965963748e+01
R292_304	292	304	4.8848352444390379e+01
R292_347	292	347	2.8593744915385891e+01
R292_351	292	351	3.9185106079648776e+01
R292_362	292	362	4.4359553977436320e+01
R293_297	293	297	7.4112691679903575e+00
R293_298	293	298	1.6958666273246834e+01
R293_300	293	300	9.0887658500951307e+00
R293_347	293	347	1.2085811539533339e+01
R293_362	293	362	1.4161440315964981e+01
R294_296	294	296	2.6603355656698238e+01
R294_295	294	295	2.8543693977564999e+01
R294_303	294	303	1.6635953753393490e+01
R294_301	294	301	4.3440369286942882e+01
R294_355	294	355	1.3311918501418566e+01
R294_356	294	356	2.0432828439461133e+01
R294_365	294	365	1.6871617955704753e+01
R295_296	295	296	9.2441087190739086e+00
R295_355	295	355	2.2780895274904516e+01
R295_357	295	357	7.4438673985936079e+00
R295_361	295	361	2.7709552592888407e+01
R295_365	295	365	3.7138079805227314e+01
R296_303	296	303	1.5359508924804294e+02
R296_361	296	361	1.3933962826988156e+02
R296_365	296	365	1.0091084254427707e+02
R297_298	297	298	2.4631304376605826e+01
R297_299	297	299	3.1957014633579224e+01
R297_300	297	300	9.3676479836253339e+00
R297_302	297	302	1.7923616609374548e+01
R297_362	297	362	3.9283054018068114e+01
R297_369	297	369	3.1823938714587495e+01
R298_299	298	299	7.3708128321770459e+01
R298_304	298	304	1.2023535363866662e+02
R298_351	298	351	5.7448856367150533e+01
R298_362	298	362	1.1663654106017809e+01
R298_363	298	363	7.8984567368222187e+01
R298_364	298	364	6.2847938308313857e+01
R298_369	298	369	7.6080624993306856e+01
R299_302	299	302	8.4893442196372220e+01
R299_364	299	364	2.6895581128144534e+02
R299_369	299	369	8.6031805979591610e+01
R300_301	300	301	2.9442484970113366e+01
R300_302	300	302	1.1528794926224768e+02
R300_346	300	346	2.6170313449226786e+01
R300_347	300	347	5.7632696134630116e+01
R300_362	300	362	5.8949628597117069e+01
R300_367	300	367	5.6875205618615524e+01
R300_368	300	368	9.0696548955459690e+01
R300_369	300	369	5.9691890478295065e+01
R300_370	300	370	5.7891256022848388e+01
R301_302	301	302	9.0215752345603590e+01
R301_303	301	303	1.0726204271093805e+02
R301_346	301	346	1.1384429379064393e+02
R301_356	301	356	2.3997001386944568e+01
R301_365	301	365	1.3239965888406607e+02
R301_366	301	366	1.1310557552626932e+02
R301_368	301	368	1.0357737882055982e+02
R301_369	301	369	1.9499231280709992e+02
R301_370	301	370	4.7927795568432686e+01
R301_371	301	371	3.1699061558707871e+01
R302_303	302	303	5.6038003847303770e+01
R302_369	302	369	4.0955028271345462e+01
R302_371	302	371	7.3844174030724986e+01
R303_365	303	365	4.4938726072905851e+01
R303_371	303	371	7.8116257146275174e+01
R304_308	304	308	3.7030703260047140e+01
R304_309	304	309	5.4915949500801979e+01
R304_351	304	351	9.2404612465585476e+00
R304_352	304	352	1.6929706747415700e+01
R304_363	304	363	6.4827648472877897e+01
R304_372	304	372	4.8774136684264121e+01
R305_306	305	306	7.2289605372913854e+01
R305_316	305	316	7.1936388726140649e+01
R305_331	305	331	5.3742579531628465e+01
R305_358	305	358	4.1309251786597258e+01
R305_361	305	361	7.0690293890078863e+01
R305_375	305	375	1.0181694537234465e+02
R305_376	305	376	6.0749855273678691e+01
R306_331	306	331	6.2534609185557073e+01
R306_376	306	376	2.0712023391480986e+02
R307_308	307	308	2.2968990044444411e+01
R307_309	307	309	4.0642781004040600e+01
R307_334	307	334	1.2805480003244350e+01
R307_335	307	335	5.5278802503052376e+01
R307_379	307	379	1.8436187159072098e+01
R307_380	307	380	8.7327715578938339e+01
R308_309	308	309	2.0608936227036679e+01
R308_332	308	332	3.1693591223211207e+01
R308_334	308	334	8.5115286781001842e+01
R308_338	308	338	3.1497998253924973e+01
R308_352	308	352	3.2605159099097264e+01
R308_379	308	379	5.0283508829733030e+01
R308_382	308	382	3.2892538920734154e+01
R308_383	308	383	5.6114463779536756e+01
R309_352	309	352	5.0138817509618363e+01
R309_372	309	372	4.2245635100358925e+01
R309_379	309	379	3.8200601794288438e+01
R309_380	309	380	7.0335025208228942e+01
R309_382	309	382	4.6059706929250943e+01
R309_383	309	383	4.4184820862406660e+01
R309_386	309	386	3.3704772409091142e+01
R309_384	309	384	1.3324912451174487e+02
R310_311	310	311	2.5581643079525406e+01
R310_317	310	317	1.5922514347752472e+01
R310_319	310	319	2.9715055480210403e+01
R310_320	310	320	2.6167670340797809e+01
R310_327	310	327	1.5836161238614293e+01
R310_353	310	353	1.2834849677686243e+01
R310_354	310	354	1.2661171852495658e+01
R310_387	310	387	2.4286458639964845e+01
R310_388	310	388	2.1212595558589211e+01
R310_389	310	389	1.1652325266483452e+01
R310_390	310	390	2.6400270719961501e+01
R311_315	311	315	6.3135652233949475e+00
R311_316	311	316	1.4957781415260387e+01
R311_314	311	314	7.7321333914800636e+00
R311_319	311	319	1.4839883612109547e+01
R311_354	311	354	8.6381610035820628e+00
R311_390	311	390	2.4200963258460387e+01
R312_313	312	313	2.5215286542137079e+01
R312_315	312	315	2.9034012635422890e+01
R312_319	312	319	1.7259754881567691e+01
R312_321	312	321	1.6360592387589229e+01
R312_391	312	391	1.8741233289232579e+01
R313_315	313	315	1.2272054900324829e+01
R313_316	313	316	2.5169168273864575e+01
R313_331	313	331	4.3066617061621344e+01
R313_391	313	391	7.8227820927082959e+01
R313_393	313	393	5.6934574290920288e+01
R314_315	314	315	1.6362364811346417e+01
R314_316	314	316	1.0948536066135750e+01
R314_319	314	319	4.2293307935247782e+01
R314_354	314	354	2.6572091115313295e+01
R314_358	314	358	1.6425869508013601e+01
R314_360	314	360	2.9047096353774201e+01
R314_388	314	388	4.5523450284530490e+01
R314_390	314	390	1.0603471629285156e+01
R314_391	314	391	4.5736929264262756e+01
R314_392	314	392	1.6362364811346417e+01
R314_393	314	393	1.2987704346721575e+01
R315_316	315	316	1.1490285815455886e+01
R315_319	315	319	2.0995780923640385e+01
R315_391	315	391	3.8709698173866904e+01
R315_393	315	393	4.9956513094481934e+01
R316_331	316	331	1.2061765428941024e+01
R316_358	316	358	1.4361167377019155e+01
R316_393	316	393	1.9217743211170028e+01
R317_318	317	318	2.2699388457544419e+01
R317_320	317	320	2.8707428214024223e+01
R317_327	317	327	3.4049082686316595e+01
R317_329	317	329	1.5466631155000639e+01
R317_330	317	330	8.3765834632288460e+01
R317_389	317	389	2.3348486576427550e+01
R317_394	317	394	4.7678378150565855e+01
R318_320	318	320	1.3820011185041443e+01
R318_322	318	322	2.1676166090563662e+01
R318_330	318	330	3.5254626534199460e+01
R318_394	318	394	4.2558832287817012e+01
R319_320	319	320	9.2748521425194799e+00
R319_321	319	321	2.9197728593605422e+01
R319_390	319	390	1.5757114367045675e+01
R319_391	319	391	1.7527611092075183e+01
R319_395	319	395	5.9543574995059735e+01
R320_321	320	321	8.8929149422366265e+01
R320_322	320	322	2.8129967686461839e+01
R320_389	320	389	3.0287470805052408e+01
R320_390	320	390	5.8127018659954182e+01
R320_394	320	394	2.0898468189430986e+01
R320_395	320	395	6.8065144041916184e+01
R321_322	321	322	4.3824546836763353e+01
R321_323	321	323	1.7017805916341155e+02
R321_391	321	391	1.7389433210234458e+02
R321_395	321	395	8.6127642004883839e+01
R322_323	322	323	1.6980457877336807e+01
R322_330	322	330	2.6367331442083032e+01
R322_394	322	394	1.8064620618617685e+01
R322_395	322	395	2.4638715875230304e+01
R322_396	322	396	7.7087388721940044e+01
R323_330	323	330	9.4214130942476942e+01
R323_395	323	395	9.5151373288152087e+01
R323_396	323	396	9.6723900751717238e+01
R324_325	324	325	1.8462352663035041e+01
R324_326	324	326	2.8537147023969823e+01
R324_327	324	327	3.1200102884382520e+01
R324_336	324	336	1.6829972160816588e+01
R324_337	324	337	3.3577182239659017e+01
R324_353	324	353	1.5254951657522129e+01
R324_397	324	397	2.7196436979654255e+01
R325_326	325	326	1.6964625384543879e+01
R325_346	325	346	1.0921119613503596e+01
R325_349	325	349	9.6491687898845164e+00
R325_353	325	353	3.8780192988717154e+01
R325_356	325	356	1.1313058217251392e+01
R325_359	325	359	1.2354466827490169e+01
R325_366	325	366	3.6090307329959302e+01
R325_368	325	368	3.6018377461210093e+01
R325_397	325	397	2.1761849136721136e+01
R326_336	326	336	2.3943883409816884e+01
R326_345	326	345	1.5797138541353423e+01
R326_346	326	346	2.6733006624404283e+01
R326_348	326	348	6.2813957931986542e+00
R326_349	326	349	1.3636590190012129e+01
R326_397	326	397	2.8839623016598498e+01
R327_328	327	328	6.4130324034810995e+00
R327_329	327	329	3.5425654955221644e+00
R327_336	327	336	2.5139529483900407e+01
R327_337	327	337	5.6423246339105715e+00
R327_353	327	353	1.3767120879280341e+01
R327_387	327	387	5.7028210984064422e+00
R327_389	327	389	1.6624947041911287e+01
R327_400	327	400	1.3788810376717656e+01
R328_329	328	329	8.1379815113084621e+00
R328_336	328	336	1.6813766455177511e+01
R328_337	328	337	1.2263243692730171e+01
R328_340	328	340	1.6156635185448799e+01
R328_341	328	341	1.5653125020412729e+01
R328_342	328	342	8.4834150842928828e+00
R328_400	328	400	5.3537807270450344e+00
R329_330	329	330	4.0681248668363587e+01
R329_340	329	340	1.1089128651281708e+01
R329_389	329	389	1.8182659659829032e+01
R329_387	329	387	2.2456778241214490e+01
R329_394	329	394	4.1176190832939795e+01
R329_400	329	400	1.3249763163216421e+01
R329_402	329	402	2.0042454710161792e+01
R330_340	330	340	5.8834463487010716e+01
R330_394	330	394	1.6074446777514943e+01
R330_396	330	396	4.3618133771874525e+01
R330_402	330	402	4.6732477000454324e+01
R330_401	330	401	9.0453527302088219e+01
R331_358	331	358	6.0568163748285386e+01
R331_376	331	376	6.4217056560802888e+01
R331_393	331	393	8.1091399135204512e+01
R331_406	331	406	1.3716303450967064e+02
R332_338	332	338	3.6031860802864593e+01
R332_339	332	339	8.6949317010783929e+01
R332_345	332	345	5.1778993054950504e+01
R332_348	332	348	5.0134146418693199e+01
R332_350	332	350	2.0244994130572607e+01
R332_352	332	352	4.9649287776851359e+01
R332_382	332	382	5.1962317760693843e+01
R332_383	332	383	3.5101355053132011e+01
R332_407	332	407	2.4593312522545201e+01
R333_334	333	334	4.3176009275904732e+01
R333_336	333	336	3.0348390654748954e+01
R333_338	333	338	3.0866630141277923e+01
R333_339	333	339	2.0121521202602437e+01
R333_341	333	341	2.5653310061610249e+01
R333_343	333	343	1.5995861167030860e+01
R333_344	333	344	7.2521715459323460e+01
R333_410	333	410	3.7638645098011779e+01
R334_335	334	335	1.2375536889436310e+02
R334_338	334	338	4.0099893563503471e+01
R334_344	334	344	3.1567198414582080e+01
R334_379	334	379	4.5218704603294299e+01
R334_410	334	410	8.0361974510606245e+01
R335_344	335	344	4.0274643814255526e+01
R335_379	335	379	2.7188630217734705e+01
R335_380	335	380	3.7497930732531628e+01
R335_409	335	409	1.2742343067877708e+02
R335_411	335	411	3.6509110161320613e+01
R336_337	336	337	1.4120907522633701e+01
R336_339	336	339	2.1074946009533168e+01
R336_341	336	341	1.5735862815687955e+01
R336_345	336	345	2.5596987707337227e+01
R336_397	336	397	3.8815797507491190e+01
R336_412	336	412	3.8984140951083702e+01
R337_341	337	341	3.2945090039574310e+01
R337_353	337	353	1.7919546472953996e+01
R337_387	337	387	1.6469833449983390e+01
R337_397	337	397	2.0674390398898776e+01
R337_400	337	400	1.0031449977289816e+01
R337_403	337	403	1.6365660883974126e+01
R337_412	337	412	2.0860859049072857e+01
R338_339	338	339	9.3812049794309917e+00
R338_379	338	379	2.5409121340345376e+01
R338_382	338	382	1.3487512487472173e+01
R338_407	338	407	3.0634144615605361e+01
R338_410	338	410	1.2073104192770751e+01
R338_413	338	413	2.9370565898087449e+01
R339_341	339	341	1.1636474041120600e+01
R339_343	339	343	3.2987790057338032e+01
R339_345	339	345	6.5016094419876138e+00
R339_407	339	407	2.1239059648549048e+01
R339_410	339	410	1.5760019726479646e+01
R339_412	339	412	1.5637826524854292e+01
R339_413	339	413	6.6770061655784287e+00
R339_414	339	414	1.2669096615057546e+01
R340_342	340	342	3.8587791414344906e+01
R340_400	340	400	1.4145688740397548e+01
R340_401	340	401	4.0897714780688872e+01
R340_402	340	402	3.5143214020502676e+01
R340_419	340	419	6.2856807116334572e+01
R341_342	341	342	1.8411226593303869e+01
R341_343	341	343	2.0983219985951560e+01
R341_400	341	400	5.0833471700371582e+01
R341_412	341	412	1.8223373254475092e+01
R341_414	341	414	3.2469943316366148e+01
R341_419	341	419	9.8944021687870830e+01
R341_420	341	420	4.3660282996432819e+01
R342_343	342	343	8.1500132066195860e+01
R342_400	342	400	3.5548373944029507e+01
R342_419	342	419	5.5795258983507942e+01
R342_420	342	420	9.5804827253142889e+01
R343_344	343	344	3.8608708283920549e+01
R343_410	343	410	1.8556097187001999e+01
R343_414	343	414	2.2583622174883402e+01
R343_420	343	420	4.6547984093208491e+01
R343_422	343	422	4.4493197304971773e+01
R344_379	344	379	4.6556704191056966e+01
R344_410	344	410	1.7720060952164719e+01
R344_411	344	411	5.8750980523991110e+01
R344_422	344	422	8.9599891909636213e+01
R345_348	345	348	9.7287288309086879e+00
R345_349	345	349	1.7736884744546725e+01
R345_350	345	350	2.3832920131038332e+01
R345_397	345	397	1.2557271948715194e+01
R345_407	345	407	9.2884856934869315e+00
R345_412	345	412	1.8233043075214727e+01
R345_408	345	408	1.5220255990995904e+01
R345_413	345	413	2.0684988442639135e+01
R345_424	345	424	1.1334792785820127e+01
R346_347	346	347	1.5867544447881675e+01
R346_348	346	348	1.4782530962958916e+01
R346_349	346	349	1.1857873847925465e+01
R346_356	346	356	3.3786634053337714e+01
R346_367	346	367	3.2454777025910815e+01
R346_368	346	368	7.6257043219791969e+00
R346_425	346	425	1.5027398834757777e+01
R347_348	347	348	6.8070324113322984e+00
R347_350	347	350	9.9146656672421614e+00
R347_351	347	351	6.2453422803324914e+00
R347_362	347	362	1.0121607213799606e+01
R347_367	347	367	8.9285076142168709e+00
R347_425	347	425	1.7887753139149922e+01
R348_349	348	349	1.6425488582723904e+01
R348_350	348	350	8.3339853359694640e+00
R348_424	348	424	2.7619149320013477e+01
R348_425	348	425	1.6291163466887525e+01
R349_359	349	359	3.7580930933161738e+01
R349_366	349	366	4.5877327004055033e+01
R349_368	349	368	1.8636962271303329e+01
R349_397	349	397	1.1373508407911869e+01
R349_399	349	399	1.9067562879928051e+01
R349_424	349	424	1.3888225041432495e+01
R349_425	349	425	2.7194833158834484e+01
R350_351	350	351	2.5890213229565138e+01
R350_352	350	352	1.8347677745769843e+01
R350_367	350	367	3.6857848965629373e+01
R350_383	350	383	2.6879296961757973e+01
R350_407	350	407	2.7208186232918091e+01
R350_424	350	424	2.1479848908489068e+01
R350_425	350	425	1.3068401819308871e+01
R350_426	350	426	8.8034570781298118e+00
R351_352	351	352	8.4097434495324315e+00
R351_362	351	362	1.2706840991719446e+01
R351_363	351	363	2.0778337402723853e+01
R351_367	351	367	1.4393292824049817e+01
R351_372	351	372	5.2442975028143351e+01
R351_373	351	373	1.1855473539335263e+01
R351_426	351	426	3.5932574993811187e+01
R352_372	352	372	2.2396979192498645e+01
R352_373	352	373	1.5565244506566000e+01
R352_383	352	383	3.2700795784062811e+00
R352_426	352	426	2.1347702364247201e+01
R353_354	353	354	3.6573079977482905e+01
R353_359	353	359	2.7607800314853517e+01
R353_387	353	387	1.8392375759067512e+01
R353_388	353	388	2.7494059639191889e+01
R353_397	353	397	1.6071041139651232e+01
R353_398	353	398	2.1051997806390148e+01
R353_403	353	403	5.4636323535384577e+01
R353_427	353	427	3.5849371943651207e+01
R354_355	354	355	1.9472941146417654e+01
R354_357	354	357	2.6385152073769071e+01
R354_359	354	359	2.0490607104432009e+01
R354_360	354	360	8.1378543102153724e+00
R354_388	354	388	1.1524927403202993e+01
R354_390	354	390	3.5017841202379415e+01
R354_427	354	427	2.9641347793926865e+01
R355_356	355	356	1.2450546462363718e+01
R355_357	355	357	9.4295574955161729e+00
R355_359	355	359	2.4293959825248585e+01
R355_360	355	360	3.3177048496838090e+01
R355_365	355	365	2.8260388100513275e+01
R355_428	355	428	2.6564478927668890e+01
R356_359	356	359	3.3538282759593073e+01
R356_365	356	365	4.3626309955249539e+01
R356_366	356	366	2.5085079373210085e+01
R356_368	356	368	5.9542703268516483e+01
R356_428	356	428	5.9287606256129898e+01
R357_360	357	360	2.4130673201662894e+01
R357_361	357	361	1.8198302213377044e+01
R357_365	357	365	6.1259019069654407e+01
R357_428	357	428	6.1423719839728101e+01
R358_360	358	360	2.4741621098418474e+01
R358_361	358	361	8.4739197938508823e+01
R358_375	358	375	2.0640126158145122e+01
R358_376	358	376	7.7633461362263859e+01
R358_392	358	392	2.3810031483614026e+01
R358_393	358	393	5.8725291119539484e+01
R358_406	358	406	2.7950184951059281e+01
R358_405	358	405	4.8191020754413351e+01
R358_429	358	429	6.0366433971892107e+01
R359_360	359	360	6.4517540748172891e+01
R359_366	359	366	1.9086675520729791e+01
R359_397	359	397	2.8800505856872448e+01
R359_399	359	399	4.4771892667197932e+01
R359_427	359	427	1.6891733391033355e+01
R359_428	359	428	2.2567800662725386e+01
R359_430	359	430	3.9939149494477029e+01
R360_361	360	361	3.0808592673166533e+01
R360_375	360	375	5.3572491563804910e+01
R360_388	360	388	3.9188654180899974e+01
R360_392	360	392	3.0014293317870415e+01
R360_427	360	427	3.1819341158174531e+01
R360_428	360	428	1.2188008224793560e+01
R360_429	360	429	7.8142255618447223e+00
R360_431	360	431	4.5664716836805219e+01
R361_365	361	365	3.6273355996294129e+01
R361_375	361	375	4.9872269851881427e+01
R361_428	361	428	6.1812450440240745e+01
R361_431	361	431	5.2752420627513793e+01
R362_363	362	363	6.6983525791760684e+01
R362_364	362	364	1.0648616107876772e+02
R362_367	362	367	2.5541172344842124e+01
R362_369	362	369	6.6288097397491853e+01
R362_435	362	435	1.2552283086981780e+02
R363_364	363	364	6.7111707568527393e+01
R363_367	363	367	5.5601862409443768e+01
R363_372	363	372	6.7263701710902723e+01
R363_373	363	373	2.9764527177538554e+01
R363_377	363	377	5.9469412512744697e+01
R363_374	363	374	5.4112944854454931e+01
R363_434	363	434	3.9445099626546764e+01
R363_435	363	435	5.4467521239431377e+01
R364_369	364	369	2.2993751548121004e+01
R364_374	364	374	7.4319913323313756e+01
R364_435	364	435	2.3045287449453191e+01
R365_366	365	366	3.5842112964473728e+01
R365_371	365	371	4.1503407702231819e+01
R365_428	365	428	1.8227023272386280e+01
R365_431	365	431	6.6101073561493351e+01
R365_438	365	438	4.5789502644547518e+01
R366_368	366	368	6.7049378748946227e+00
R366_370	366	370	2.4727490642211677e+01
R366_371	366	371	4.3296810757319577e+01
R366_399	366	399	1.8120989185680777e+01
R366_428	366	428	1.0758668205736413e+01
R366_430	366	430	9.5570421657223772e+00
R366_437	366	437	3.1102317341610640e+01
R366_438	366	438	1.1986887645970425e+01
R367_368	367	368	1.0385476931145419e+01
R367_369	367	369	1.8004084669739616e+01
R367_370	367	370	1.7158989378836136e+01
R367_373	367	373	1.0174594566031903e+01
R367_425	367	425	5.1902916566931774e+00
R367_426	367	426	8.7198789298353852e+00
R367_434	367	434	1.1780844266030119e+01
R367_435	367	435	1.2189115541254974e+01
R367_436	367	436	4.4327295327929308e+00
R367_439	367	439	1.6896504075416523e+01
R368_370	368	370	6.9518490117185001e+00
R368_399	368	399	2.1813967504735089e+01
R368_424	368	424	2.7764583572055098e+01
R368_425	368	425	8.7770840455448162e+00
R368_436	368	436	1.2570230548676474e+01
R368_437	368	437	1.1286241046236331e+01
R368_438	368	438	4.1187111758325322e+01
R368_439	368	439	2.5577788510138646e+01
R369_370	369	370	4.1565285232716974e+01
R369_371	369	371	7.7251351550765747e+01
R369_435	369	435	7.5691579572591820e+01
R369_439	369	439	7.2801606331582661e+01
R370_371	370	371	1.5571084388651650e+01
R370_438	370	438	4.6135283405155171e+01
R370_439	370	439	1.7708329946390368e+01
R371_438	371	438	3.7001486239546722e+01
R371_439	371	439	5.3718019112613646e+01
R372_373	372	373	5.3613933317761166e+01
R372_377	372	377	9.8210927244662614e+01
R372_383	372	383	6.3920656533131698e+01
R372_384	372	384	1.7305704809201066e+02
R372_385	372	385	6.6203206399800010e+01
R372_386	372	386	6.4117868170362314e+01
R372_440	372	440	7.6680201924180565e+01
R373_377	373	377	6.9864842989779433e+01
R373_383	373	383	3.1853303759937958e+01
R373_426	373	426	1.1564928040478394e+01
R373_434	373	434	1.4463355910879926e+01
R373_440	373	440	2.1450306000814852e+01
R374_377	374	377	4.6443025288828942e+01
R374_434	374	434	4.9202942445334408e+01
R374_435	374	435	5.1495274542829875e+01
R374_442	374	442	4.9472062822118637e+01
R374_443	374	443	1.5916952716971429e+02
R375_376	375	376	7.7978192384397644e+01
R375_406	375	406	7.4730628097197197e+01
R375_405	375	405	3.6329249416370786e+01
R375_429	375	429	8.9076536362582175e+01
R375_431	375	431	5.9952514730162441e+01
R375_445	375	445	1.2135404329198720e+02
R375_446	375	446	7.2343376908590812e+01
R376_406	376	406	8.1176820423915800e+01
R376_446	376	446	2.6687294185108385e+02
R377_434	377	434	5.6036675377326318e+01
R377_385	377	385	5.5690782509440929e+01
R377_440	377	440	5.8509319602276982e+01
R377_441	377	441	5.1457147980664857e+01
R377_442	377	442	9.2260993665180052e+01
R377_443	377	443	5.5641746622479083e+01
R377_447	377	447	4.2672416976164520e+01
R377_448	377	448	1.3064116804093717e+02
R378_451	378	451	1.6426787930150574e+01
R378_381	378	381	7.5179290623072305e+01
R378_409	378	409	9.8912306676471204e+01
R378_417	378	417	1.0546830695235258e+02
R378_452	378	452	4.4380720054380461e+01
R378_453	378	453	3.0946792477406088e+01
R378_416	378	416	1.9782461335294184e+02
R379_380	379	380	1.5625785982873305e+01
R379_382	379	382	9.9431732609271606e+00
R379_386	379	386	3.1994543037235665e+01
R379_410	379	410	2.0164594690895559e+01
R379_411	379	411	2.6593033452815323e+01
R379_415	379	415	1.6790758631671860e+01
R379_454	379	454	5.3532118631400365e+01
R380_384	380	384	5.9078323342080381e+01
R380_386	380	386	5.9485963054258121e+01
R380_409	380	409	6.3867301644160378e+01
R380_411	380	411	6.6160186503913650e+01
R380_454	380	454	2.9143883719087651e+01
R380_381	380	381	1.0199887838955024e+02
R381_451	381	451	7.4630765775483479e+00
R381_409	381	409	3.2937654028220415e+01
R381_453	381	453	4.8055485230548882e+01
R381_450	381	450	5.1056861910643548e+01
R381_454	381	454	1.9729460626467397e+01
R381_384	381	384	5.8989934465164815e+01
R381_455	381	455	3.9463653561178170e+01
R382_383	382	383	1.1215775761359406e+01
R382_386	382	386	1.7173646678529735e+01
R382_407	382	407	2.1489857581683967e+01
R382_410	382	410	3.7701476533238385e+01
R382_413	382	413	4.9320265186412556e+01
R382_415	382	415	1.9591520630364265e+01
R382_418	382	418	4.4596894763858550e+01
R382_457	382	457	2.3108798083253525e+01
R383_386	383	386	1.7784660689697702e+01
R383_407	383	407	2.4035292621976811e+01
R383_426	383	426	1.2930928753777682e+01
R383_440	383	440	2.6510995812577097e+01
R383_457	383	457	1.9972170363609525e+01
R384_385	384	385	6.2566449280693192e+01
R384_386	384	386	2.3448275533532470e+01
R384_454	384	454	4.2472352834363022e+01
R384_455	384	455	4.5139277248181806e+01
R384_450	384	450	1.4125594652234136e+02
R384_449	384	449	6.0573213586870523e+01
R384_459	384	459	3.7510786790207362e+01
R385_386	385	386	8.3988259088028954e+01
R385_440	385	440	6.0333150047473772e+01
R385_447	385	447	2.8719183103205427e+01
R385_448	385	448	7.7602031103570681e+01
R385_449	385	449	3.4675073303924201e+01
R385_459	385	459	4.6146466302453454e+01
R386_415	386	415	2.2613331436918578e+01
R386_440	386	440	2.4679771669825321e+01
R386_454	386	454	1.8675017007811249e+01
R386_457	386	457	1.4330828224537317e+01
R386_458	386	458	1.9910169197334010e+01
R386_459	386	459	1.4854022787627983e+01
R386_460	386	460	3.3884098451795737e+01
R387_388	387	388	1.8515426353019176e+01
R387_389	387	389	1.1145744120134131e+01
R387_398	387	398	1.9986846438067925e+01
R387_400	387	400	1.9195996033650896e+01
R387_402	387	402	2.1567580808344200e+01
R387_403	387	403	1.1976663639607972e+01
R387_463	387	463	2.0307819025892371e+01
R388_389	388	389	2.4378039017989416e+01
R388_390	388	390	1.6954838911112009e+01
R388_392	388	392	1.8655265277938408e+01
R388_398	388	398	7.0982228203570488e+00
R388_427	388	427	1.1723643158781243e+01
R388_404	388	404	1.3958708552322227e+01
R388_429	388	429	3.8575330247903018e+01
R388_463	388	463	1.3540731868873017e+01
R388_464	388	464	1.3505269483622980e+01
R389_390	389	390	1.5116757088270136e+01
R389_394	389	394	8.0056305272521371e+00
R389_402	389	402	1.4820058807312453e+01
R389_463	389	463	2.3831464511904290e+01
R389_464	389	464	3.5096400110448627e+01
R389_465	389	465	1.6046920309413277e+01
R390_391	390	391	3.1277710125140946e+01
R390_392	390	392	4.7865321977646872e+01
R390_393	390	393	3.7405883810013634e+01
R390_394	390	394	6.8331902814699646e+01
R390_395	390	395	4.8747115253106188e+01
R390_464	390	464	1.4775739119269774e+01
R390_465	390	465	2.5922322307813069e+01
R390_466	390	466	2.6913390577116463e+01
R391_393	391	393	5.2230361075244709e+01
R391_395	391	395	9.0236289521767645e+01
R391_466	391	466	1.2253263052892704e+02
R392_393	392	393	4.1779162896729893e+01
R392_406	392	406	4.4107070135447806e+01
R392_405	392	405	2.4538433940521184e+01
R392_404	392	404	2.1147608243047149e+01
R392_429	392	429	2.6667454883541634e+01
R392_464	392	464	2.3290749468760730e+01
R392_467	392	467	1.9579449586769851e+01
R392_468	392	468	4.6553415470956757e+01
R393_406	393	406	4.5443003719655401e+01
R393_464	393	464	6.6816466540610747e+01
R393_466	393	466	6.6199110537165865e+01
R393_468	393	468	6.4853037785169377e+01
R394_395	394	395	2.4507340828917336e+01
R394_396	394	396	6.1264338839441798e+01
R394_402	394	402	2.4226566711681802e+01
R394_465	394	465	2.8026916389243659e+01
R394_471	394	471	8.5649804978957889e+01
R395_396	395	396	1.2614276266888245e+02
R395_465	395	465	6.5414738582201352e+01
R395_466	395	466	9.6771953838266725e+01
R395_471	395	471	1.2262689400018354e+02
R396_401	396	401	1.1792500562007378e+02
R396_402	396	402	1.6484812223584635e+02
R396_471	396	471	8.8569648169660937e+01
R396_473	396	473	3.5881577709166885e+02
R397_399	397	399	1.9861063611796617e+01
R397_398	397	398	3.4517657864503086e+01
R397_403	397	403	2.8570669477538772e+01
R397_408	397	408	2.3547386799646613e+01
R397_412	397	412	5.3830210053738270e+01
R397_424	397	424	4.2612777903475830e+01
R397_427	397	427	3.3055760072699691e+01
R397_475	397	475	4.3060308042447346e+01
R398_403	398	403	1.7023440586539483e+01
R398_427	398	427	1.2388284088599930e+01
R398_404	398	404	3.7486972023689376e+01
R398_463	398	463	1.9894374849524993e+01
R398_475	398	475	2.3396460492937038e+01
R399_424	399	424	1.4757218947213772e+01
R399_408	399	408	5.2487995151688466e+01
R399_427	399	427	5.8953756681255371e+01
R399_430	399	430	1.3504047735268724e+01
R399_437	399	437	2.5711020651523729e+01
R399_475	399	475	3.8241216284020403e+01
R399_476	399	476	2.5098024321966207e+01
R400_402	400	402	2.6679595581362396e+01
R400_401	400	401	8.4223241674720413e+01
R400_403	400	403	3.3807898105867004e+01
R400_412	400	412	4.0950648656061574e+01
R400_419	400	419	2.9431553879260608e+01
R400_477	400	477	4.1791917160530517e+01
R401_402	401	402	3.4285095367913726e+01
R401_419	401	419	7.6742722716356809e+01
R401_471	401	471	1.2428163986121439e+02
R401_470	401	470	5.3841649468287521e+01
R401_472	401	472	1.6513587084831394e+02
R401_473	401	473	1.0851542464510484e+02
R401_477	401	477	1.3081804979055082e+02
R402_403	402	403	3.1841141377201897e+01
R402_463	402	463	2.2812052992683828e+01
R402_465	402	465	1.8975351792126258e+01
R402_471	402	471	2.8176020502512714e+01
R402_470	402	470	3.6939772639952416e+01
R402_477	402	477	2.6908394574619646e+01
R402_479	402	479	2.0995712237587437e+01
R403_412	403	412	2.0033200360420171e+01
R403_408	403	408	2.2360855297325180e+01
R403_463	403	463	1.2797896042070024e+01
R403_475	403	475	2.5164502570696278e+01
R403_477	403	477	1.4600566757973166e+01
R403_478	403	478	1.2919002828324412e+01
R403_479	403	479	3.3821982299988008e+01
R403_482	403	482	3.0479900208649770e+01
R404_427	404	427	1.1498812240296369e+01
R404_429	404	429	1.0481141497971290e+01
R404_405	404	405	2.5186170602692396e+01
R404_432	404	432	8.5813871053589779e+00
R404_463	404	463	2.9781968056651035e+01
R404_464	404	464	2.3040129013815907e+01
R404_467	404	467	9.5823435335803122e+00
R404_469	404	469	1.8380119304456066e+01
R404_475	404	475	1.6908400572291967e+01
R404_483	404	483	4.5256365085484866e+01
R405_406	405	406	2.5333418375024376e+01
R405_429	405	429	8.3095578433545203e+00
R405_431	405	431	4.6012458853228956e+01
R405_432	405	432	1.4801871598582347e+01
R405_433	405	433	2.6559426513273781e+01
R405_445	405	445	1.1436779072037803e+01
R405_446	405	446	4.1616929711693970e+01
R405_467	405	467	1.2309949236207173e+01
R405_484	405	484	3.8966537847080161e+01
R405_485	405	485	2.4921465643887178e+01
R406_446	406	446	2.7311189064942941e+01
R406_467	406	467	3.6824107034442761e+01
R406_468	406	468	4.2215593469043959e+01
R406_485	406	485	4.0509109139187586e+01
R407_413	407	413	1.0154845063069878e+01
R407_408	407	408	3.3210933045074128e+01
R407_418	407	418	2.5661233495577893e+01
R407_424	407	424	2.3390323083546850e+01
R407_426	407	426	2.9955996647955168e+01
R407_457	407	457	1.3352008488193592e+01
R407_461	407	461	2.9405804687532061e+01
R407_462	407	462	1.3006448098224034e+01
R407_496	407	496	2.4729093596879238e+01
R408_412	408	412	1.9054803295712276e+01
R408_413	408	413	5.5466504788969047e+01
R408_424	408	424	2.5210149351996630e+01
R408_462	408	462	2.6507483706625571e+01
R408_475	408	475	4.0623925973810231e+01
R408_476	408	476	1.5302588274204130e+01
R408_478	408	478	3.7105916841776349e+01
R408_482	408	482	2.2133625432617794e+01
R408_496	408	496	1.9235662010767001e+01
R408_497	408	497	2.0108112467723586e+01
R409_411	409	411	4.8376128593845145e+01
R409_451	409	451	4.1269569042803269e+01
R409_417	409	417	6.6390072491259346e+01
R409_454	409	454	5.5406889668856181e+01
R409_498	409	498	7.5255261151529609e+01
R410_411	410	411	5.0852251122942931e+01
R410_413	410	413	1.8319797592925372e+01
R410_414	410	414	2.1507293080451941e+01
R410_415	410	415	3.3087015350504032e+01
R410_418	410	418	4.4002357810322543e+01
R410_421	410	421	3.7188213568198485e+01
R410_422	410	422	1.7456127156010968e+01
R410_499	410	499	4.0735172919153840e+01
R411_415	411	415	2.6138084849456693e+01
R411_422	411	422	4.2088091262813656e+01
R411_454	411	454	3.3434983569558206e+01
R411_498	411	498	4.1475301503294290e+01
R411_417	411	417	7.8533479916960545e+01
R411_499	411	499	3.1912138293093623e+01
R411_500	411	500	3.4566662162010722e+01
R411_501	411	501	2.2661718066607655e+01
R412_413	412	413	1.4219730320527891e+01
R412_414	412	414	1.0638274810397899e+01
R412_419	412	419	2.9073447651969023e+01
R412_420	412	420	3.1573257999085882e+01
R412_474	412	474	1.9451483397853760e+01
R412_477	412	477	2.6486959946193110e+01
R412_481	412	481	2.2460893648781823e+01
R412_482	412	482	1.6728557920260645e+01
R412_496	412	496	3.1977972447983021e+01
R412_502	412	502	1.9914042156121507e+01
R413_414	413	414	2.1956450798934942e+01
R413_418	413	418	2.2028302496849108e+01
R413_421	413	421	5.0377732604850813e+01
R413_496	413	496	5.1622186241007910e+01
R413_502	413	502	5.1739532201986634e+01
R414_420	414	420	1.3001093917829467e+01
R414_421	414	421	8.6187628402373626e+00
R414_422	414	422	2.9639595825351925e+01
R414_474	414	474	2.4230370583170700e+01
R414_502	414	502	3.6843756478863050e+01
R415_418	415	418	1.2366859580450315e+01
R415_454	415	454	1.7617695186948659e+01
R415_457	415	457	2.6707145001099363e+01
R415_458	415	458	1.3803883028389157e+01
R415_499	415	499	1.1639506285822392e+01
R415_500	415	500	1.2377501215168989e+01
R415_503	415	503	2.7624574828005311e+01
R416_453	416	453	7.8170782033250674e+01
R416_452	416	452	8.5637127839244201e+01
R416_456	416	456	2.5739057490146880e-06
R416_486	416	486	1.6086911092210915e-06
R416_495	416	495	7.2858027799512038e-07
R416_423	416	423	3.2173822184421823e-07
R416_505	416	505	2.5739057490146880e-06
R417_451	417	451	3.0599839408814553e+01
R417_452	417	452	4.9473800448472154e+01
R417_498	417	498	7.8672475609236745e+00
R417_501	417	501	9.6084944322959743e+01
R417_506	417	506	1.0429391712518726e+02
R417_507	417	507	9.6180033563066544e+01
R418_421	418	421	1.5727152072549639e+01
R418_457	418	457	2.4474080556883649e+01
R418_458	418	458	3.7922215640848464e+01
R418_461	418	461	8.9902171654990504e+00
R418_496	418	496	2.3379342338602981e+01
R418_499	418	499	1.3406079640199197e+01
R418_502	418	502	1.1861679386802445e+01
R418_503	418	503	1.0793498439731614e+01
R418_508	418	508	4.0331530445305482e+01
R419_420	419	420	6.5374064572769896e+01
R419_472	419	472	7.8214943008803999e+01
R419_470	419	470	7.9639140251277951e+01
R419_474	419	474	8.9788476925402620e+01
R419_477	419	477	4.2350302505061407e+01
R419_480	419	480	7.6033324675429370e+01
R419_481	419	481	6.8242881652118641e+01
R419_509	419	509	6.3877000700758323e+01
R420_421	420	421	6.3641279170358260e+01
R420_422	420	422	1.1692606968750695e+02
R420_474	420	474	2.8944330902392977e+01
R420_509	420	509	1.8031586947929227e+02
R420_510	420	510	1.4897948773566202e+02
R421_422	421	422	2.4240332743665608e+01
R421_474	421	474	1.4868468644166517e+01
R421_499	421	499	1.7410216979748267e+01
R421_502	421	502	1.9246474155121280e+01
R421_508	421	508	2.2789420133812779e+01
R421_510	421	510	2.6290190768929012e+01
R422_499	422	499	1.7374400818209015e+01
R422_501	422	501	4.5057853721145278e+01
R422_510	422	510	4.9846999834316144e+01
R423_495	423	495	3.7044524824116442e-07
R423_486	423	486	8.4253970509441687e-07
R423_505	423	505	1.0531746313680213e-06
R423_511	423	511	8.6932606702646395e-07
R423_512	423	512	8.4253970509441814e-07
R424_425	424	425	1.4418111393803828e+01
R424_426	424	426	5.1642633874839248e+01
R424_437	424	437	6.3735284253405410e+01
R424_462	424	462	4.3482477260544989e+01
R424_476	424	476	6.1625608579990896e+01
R424_514	424	514	5.4621732609676293e+01
R425_426	425	426	2.6234199490966500e+01
R425_436	425	436	1.3219151460509245e+01
R425_437	425	437	5.3863441962145004e+01
R425_514	425	514	5.8516110125446410e+01
R426_434	426	434	3.1218526525620053e+01
R426_436	426	436	4.0440988509954948e+01
R426_440	426	440	2.3228352342432483e+01
R426_457	426	457	4.5249674786948326e+01
R426_462	426	462	4.6670220690641770e+01
R426_514	426	514	1.8784579122249937e+01
R426_515	426	515	5.9944311347473281e+01
R426_516	426	516	5.9661605675969646e+01
R427_428	427	428	6.7825586083413313e+01
R427_429	427	429	2.5437689587622810e+01
R427_430	427	430	2.7589109308968780e+01
R427_432	427	432	6.6282619823503325e+01
R427_475	427	475	2.0095645858438129e+01
R427_517	427	517	9.3468817120819537e+01
R428_429	428	429	1.4214339059605852e+01
R428_430	428	430	1.7802828375192679e+01
R428_431	428	431	1.7349110223229648e+01
R428_433	428	433	3.5488795299155100e+01
R428_438	428	438	2.7171147229884262e+01
R428_517	428	517	4.3082899697227219e+01
R429_430	429	430	9.8175115811475393e+01
R429_431	429	431	5.5069598151464760e+01
R429_432	429	432	2.9841023588759217e+01
R429_433	429	433	3.3142904025787061e+01
R429_517	429	517	6.2592019827041156e+01
R430_437	430	437	2.0245395194112849e+01
R430_438	430	438	4.3583576715019483e+01
R430_475	430	475	1.9013285489748014e+01
R430_476	430	476	4.0266431680557808e+01
R430_517	430	517	6.6817660478436522e+00
R430_519	430	519	3.2311466164969097e+01
R431_433	431	433	2.2401574637213173e+01
R431_438	431	438	7.1107940069813381e+01
R431_445	431	445	7.0602130703055678e+01
R431_520	431	520	1.1958498127334805e+02
R432_433	432	433	3.6583605276160640e+01
R432_445	432	445	1.2478377506667064e+02
R432_467	432	467	7.2975741242656269e+01
R432_475	432	475	6.7365648368682002e+01
R432_483	432	483	5.9661984389481667e+01
R432_484	432	484	5.1181805436013001e+01
R432_517	432	517	4.1663126807741087e+01
R432_518	432	518	9.3689004046705350e+01
R432_521	432	521	4.8679133086248576e+01
R433_438	433	438	5.3996401210728770e+01
R433_445	433	445	1.8502607298666664e+01
R433_517	433	517	8.4019048556075120e+00
R433_520	433	520	1.2429132409458942e+01
R433_521	433	521	3.3636934182536606e+01
R434_435	434	435	1.7745575660774861e+01
R434_436	434	436	3.6301896348136502e+01
R434_440	434	440	2.1294690792929845e+01
R434_441	434	441	1.6213061805492455e+01
R434_442	434	442	2.2116912241188647e+01
R434_514	434	514	5.6638648678098122e+01
R434_516	434	516	3.1717297572187707e+01
R434_522	434	522	2.7074551680091190e+01
R435_436	435	436	4.1944522070340490e+01
R435_439	435	439	3.5897784949676989e+01
R435_442	435	442	5.7810720124891908e+01
R435_522	435	522	3.7284558803681804e+01
R436_437	436	437	1.3366096717899065e+01
R436_439	436	439	2.5225516032635220e+01
R436_514	436	514	2.2690836878759708e+01
R436_522	436	522	4.0775699902661202e+01
R437_438	437	438	3.7368578084073185e+01
R437_439	437	439	3.6497138548247975e+01
R437_476	437	476	4.3713714701246069e+01
R437_514	437	514	1.4953426895688848e+01
R437_517	437	517	3.5883150153231568e+01
R437_519	437	519	2.2118421419180148e+01
R437_522	437	522	4.5812581612744829e+01
R437_523	437	523	2.1242449690749471e+01
R437_524	437	524	2.2195590662272771e+01
R438_439	438	439	3.7178418566744256e+01
R438_517	438	517	2.6805525128513384e+01
R438_520	438	520	4.7427668186002371e+01
R438_524	438	524	5.4432672005704212e+01
R439_522	439	522	1.0703089347595269e+02
R439_524	439	524	1.7077315193590178e+02
R440_441	440	441	1.9302514313698314e+01
R440_447	440	447	1.6265308048815502e+01
R440_457	440	457	4.2617546356923476e+01
R440_459	440	459	5.5391560108387097e+01
R440_460	440	460	1.7998655973043046e+01
R440_515	440	515	2.6042121409340957e+01
R440_516	440	516	2.2099898633169424e+01
R440_525	440	525	3.6809154040008885e+01
R441_442	441	442	2.2215868096144998e+01
R441_443	441	443	9.1841671369049379e+01
R441_447	441	447	3.0052641802901451e+01
R441_492	441	492	8.6744635729860647e+01
R441_516	441	516	4.1636144252571633e+01
R441_522	441	522	1.1491993558972236e+02
R441_525	441	525	2.2874140123431804e+01
R441_526	441	526	5.2939085276419533e+01
R441_527	441	527	7.2879934252715856e+01
R442_443	442	443	1.2148764379124981e+02
R442_522	442	522	1.0817743368447387e+02
R442_526	442	526	1.1214348349532887e+02
R442_527	442	527	1.9346737675118922e+02
R443_447	443	447	9.6141138167007639e+01
R443_448	443	448	8.5188492930216952e+01
R443_492	443	492	6.5236138284122134e+01
R443_444	443	444	1.2550077285267167e+02
R443_527	443	527	8.7503523208088382e+01
R444_448	444	448	8.3286524988451120e+01
R444_492	444	492	3.3745037174760419e+01
R444_490	444	490	3.3766249215340807e+01
R444_527	444	527	8.6013074522670038e+01
R444_528	444	528	3.4222731552047478e+01
R444_513	444	513	1.6316461491875438e+02
R445_446	445	446	4.3132938579848336e+01
R445_484	445	484	2.7359716604025284e+01
R445_485	445	485	4.5184772426812970e+01
R445_520	445	520	4.4055252024939406e+01
R445_521	445	521	3.7565181744306727e+01
R445_529	445	529	4.3252475244667160e+01
R445_530	445	530	4.1113877876720494e+01
R446_485	446	485	6.4142525959919695e+01
R446_530	446	530	1.8714228776036362e+02
R447_448	447	448	1.6313311322352462e+01
R447_449	447	449	3.8953751644123102e+01
R447_459	447	459	2.5256946234092606e+01
R447_460	447	460	2.5045054638309729e+01
R447_492	447	492	1.5904754924929772e+01
R447_525	447	525	1.7129477319999609e+01
R447_532	447	532	1.4093545223284409e+01
R448_449	448	449	1.7968641659991640e+01
R448_492	448	492	1.0086733573567702e+01
R448_490	448	490	1.9858898849660555e+01
R448_532	448	532	8.2904417756207422e+00
R448_489	448	489	3.6236265708820184e+01
R449_455	449	455	1.9238960430178953e+01
R449_450	449	450	2.1642929619501945e+01
R449_459	449	459	9.1448969557135555e+00
R449_532	449	532	8.5961925936219128e+00
R449_489	449	489	1.2858643521880721e+01
R449_533	449	533	7.3821528371682188e+00
R450_451	450	451	5.1580320093722754e+01
R450_453	450	453	4.7914256446421632e+01
R450_455	450	455	9.7821429886671663e+00
R450_488	450	488	1.6905914920534350e+01
R450_487	450	487	8.9923227614634740e+01
R450_456	450	456	6.4864043989524177e+01
R450_489	450	489	5.1373916845722377e+01
R450_533	450	533	2.6503366229601919e+01
R450_535	450	535	3.9273076105228121e+01
R451_452	451	452	2.0641535491475345e+01
R451_453	451	453	1.1857386438992389e+01
R451_454	451	454	2.7907185406901746e+01
R451_455	451	455	4.4619141671878275e+01
R451_498	451	498	1.6299018756900534e+01
R451_535	451	535	1.9095677109123802e+01
R452_453	452	453	1.8777384531979223e+01
R452_495	452	495	2.1779219096490081e+01
R452_498	452	498	2.5248018549884815e+01
R452_505	452	505	1.6487891770546621e+01
R452_507	452	507	1.8983536048425670e+01
R452_535	452	535	1.5532525815153834e+01
R453_456	453	456	2.3386182384455164e+01
R453_495	453	495	2.4846743733612229e+01
R453_535	453	535	2.0035588292581021e+01
R454_455	454	455	1.5789259623184849e+01
R454_458	454	458	2.0532506551670345e+01
R454_459	454	459	3.1455117466690862e+01
R454_498	454	498	1.1158999120583161e+01
R454_500	454	500	1.7569067369146293e+01
R454_535	454	535	4.9254401926401556e+01
R454_538	454	538	1.5028663557804153e+01
R455_459	455	459	1.0299145305415797e+01
R455_533	455	533	8.3563526224140023e+00
R455_488	455	488	1.8419238193447278e+01
R455_535	455	535	1.4050094608041526e+01
R455_537	455	537	1.9818361774944833e+01
R455_538	455	538	1.0745453933444802e+01
R455_539	455	539	1.9109915646323195e+01
R456_488	456	488	5.0554602678880578e+01
R456_487	456	487	1.4936236385870495e-06
R456_486	456	486	1.2446863903829353e-07
R456_495	456	495	3.9554063354394860e-07
R456_535	456	535	4.0334338492401344e+01
R456_540	456	540	3.6352592627009765e-07
R456_493	456	493	9.3351479278720152e-07
R457_458	457	458	8.8233832202534419e+00
R457_460	457	460	1.9743054502731248e+01
R457_461	457	461	7.0776271878670460e+00
R457_462	457	462	1.9267489111988361e+01
R457_515	457	515	1.9668646740282625e+01
R457_541	457	541	3.2509987747038053e+01
R458_459	458	459	3.5576889048242514e+01
R458_460	458	460	3.5215978490686084e+01
R458_461	458	461	3.8414348788364364e+01
R458_500	458	500	2.4244761107338569e+01
R458_503	458	503	1.5119249218136327e+01
R458_536	458	536	2.1052554114929759e+01
R458_537	458	537	2.5259969378471038e+01
R458_538	458	538	2.2897377873737003e+01
R458_541	458	541	2.5434349800289318e+01
R459_460	459	460	2.3654316557757856e+01
R459_532	459	532	7.4536593819497128e+01
R459_533	459	533	4.6196684033442018e+01
R459_537	459	537	3.8944093216225099e+01
R459_538	459	538	1.0464695533031802e+02
R459_542	459	542	9.6767215979541106e+01
R460_515	460	515	1.7519275651792807e+01
R460_525	460	525	4.2506893669544041e+01
R460_532	460	532	6.4217093482814022e+01
R460_537	460	537	3.3552810827120787e+01
R460_541	460	541	3.1271295744807482e+01
R460_542	460	542	1.6443964299627577e+01
R461_462	461	462	2.8425999304114619e+01
R461_496	461	496	1.3934919266096829e+01
R461_502	461	502	4.6191643417970262e+01
R461_503	461	503	2.8425999304114619e+01
R461_504	461	504	2.5225834036429152e+01
R461_515	461	515	1.1094949033641504e+02
R461_541	461	541	4.7523781454426278e+01
R461_543	461	543	5.5852258365769110e+01
R462_476	462	476	1.2550885042655905e+01
R462_496	462	496	6.5455446777956796e+00
R462_497	462	497	1.5826296522313298e+01
R462_514	462	514	1.2608244024818729e+01
R462_515	462	515	2.2541070526572351e+01
R462_543	462	543	5.9804975262652116e+00
R463_464	463	464	1.2745310921413980e+01
R463_465	463	465	2.2633939355082919e+01
R463_469	463	469	1.3343248344930284e+01
R463_475	463	475	4.0827039406772187e+01
R463_478	463	478	3.7690339760088953e+01
R463_479	463	479	1.4457520575135328e+01
R463_547	463	547	5.6164038840991843e+01
R464_465	464	465	1.4391865147819898e+01
R464_466	464	466	1.6704678132117742e+01
R464_467	464	467	2.8039984867545876e+01
R464_468	464	468	1.5642342603349265e+01
R464_469	464	469	1.2822315918931452e+01
R464_547	464	547	3.5968470411649676e+01
R465_466	465	466	1.4660959213762878e+01
R465_471	465	471	2.0063427148860200e+01
R465_479	465	479	4.7613770893796719e+01
R465_547	465	547	4.1336037271738952e+01
R466_468	466	468	3.8073811083390559e+01
R466_471	466	471	5.9541809463782030e+01
R466_547	466	547	4.0952235021345416e+01
R467_468	467	468	6.1551825625201557e+00
R467_469	467	469	8.1792485973511333e+00
R467_483	467	483	1.6865253844195827e+01
R467_484	467	484	1.0761360793061037e+01
R467_485	467	485	8.1511594877969138e+00
R467_548	467	548	1.7276121113679739e+01
R468_469	468	469	2.6507385704370037e+01
R468_485	468	485	5.4297899717076106e+01
R468_547	468	547	5.1350647410628383e+01
R468_548	468	548	4.9933063023111103e+01
R469_475	469	475	3.9663795212776783e+01
R469_478	469	478	2.8797956836264941e+01
R469_479	469	479	2.7279644559692031e+01
R469_483	469	483	1.8062164265152383e+01
R469_547	469	547	1.4826040179246402e+01
R469_548	469	548	1.9885200675495959e+01
R469_549	469	549	2.4035560142570802e+01
R470_471	470	471	4.0775546965427431e+01
R470_472	470	472	1.2628166987030747e+01
R470_473	470	473	4.4028754332672399e+01
R470_477	470	477	1.0021897733416127e+01
R470_479	470	479	1.5563446298963603e+01
R470_480	470	480	1.0048809231933186e+01
R470_550	470	550	1.5915754652851930e+01
R470_552	470	552	3.3482516066210010e+01
R470_553	470	553	1.9228034906350580e+01
R471_473	471	473	3.2531949854033925e+01
R471_479	471	479	2.0278844187058709e+01
R471_547	471	547	2.4906877509460145e+01
R471_553	471	553	3.1287238389460946e+01
R472_473	472	473	3.3731569031690064e+01
R472_480	472	480	1.0755354446505891e+01
R472_509	472	509	4.9557985122403643e+01
R472_551	472	551	3.3362588902271739e+01
R472_552	472	552	2.1440652721713917e+01
R472_553	472	553	3.6869917377703764e+01
R472_554	472	554	3.3731569031690043e+01
R473_553	473	553	2.2349386719912196e+01
R473_554	473	554	7.2032408415551686e+01
R474_481	474	481	1.1588273961584513e+01
R474_502	474	502	9.9025249286570762e+00
R474_508	474	508	1.4687216320259580e+01
R474_509	474	509	1.2093480677487182e+01
R474_510	474	510	2.5185385273914612e+01
R474_556	474	556	2.3945796937837972e+01
R475_476	475	476	1.5281737056272183e+01
R475_478	475	478	1.3600487047157072e+01
R475_483	475	483	3.1258910247638294e+01
R475_517	475	517	3.5825014672444738e+01
R475_518	475	518	2.0435797367781461e+01
R475_519	475	519	4.4300508664468545e+01
R475_557	475	557	5.2277251790207956e+01
R476_478	476	478	1.5167467637417332e+01
R476_497	476	497	4.6243113783700176e+00
R476_514	476	514	1.5248215000432847e+01
R476_519	476	519	3.4030335733174200e+00
R476_518	476	518	1.2042531074252976e+01
R476_543	476	543	1.0211859282188980e+01
R476_546	476	546	5.2910804086082699e+00
R476_557	476	557	1.4517699878202608e+01
R477_479	477	479	1.1618930539367373e+01
R477_478	477	478	2.6844446856809160e+01
R477_480	477	480	1.4124896073785802e+01
R477_481	477	481	1.5706273589988466e+01
R477_482	477	482	1.8405296084851845e+01
R477_550	477	550	3.2245239132161274e+01
R477_558	477	558	2.1054499566840821e+01
R478_479	478	479	1.6810679054603909e+01
R478_482	478	482	1.0560924373067277e+01
R478_483	478	483	4.1306007800428354e+01
R478_497	478	497	3.0148890502905807e+01
R478_549	478	549	1.7943587779790008e+01
R478_557	478	557	1.2861506911125822e+01
R478_558	478	558	2.2685322799127512e+01
R479_547	479	547	1.1611414492784766e+01
R479_549	479	549	1.1257141660386759e+01
R479_550	479	550	1.1798059744199069e+01
R479_553	479	553	2.8163483373590090e+01
R479_558	479	558	3.3104699143562065e+01
R480_481	480	481	1.1897372958017611e+01
R480_509	480	509	2.2232819443316721e+01
R480_550	480	550	1.0159866215651347e+01
R480_551	480	551	2.7486607875179072e+01
R480_552	480	552	7.0376292791042712e+00
R480_555	480	555	9.2295319441371415e+00
R480_558	480	558	1.1854972297224743e+01
R481_482	481	482	8.9442197104862426e+00
R481_502	481	502	1.6082767856484789e+01
R481_509	481	509	1.4338435342108825e+01
R481_555	481	555	1.3679670330711827e+01
R481_556	481	556	1.1668935263518661e+01
R481_558	481	558	1.4284888467215046e+01
R481_559	481	559	1.2751730975556494e+01
R482_496	482	496	2.3560760465857026e+01
R482_497	482	497	8.0274803936952512e+00
R482_502	482	502	3.2782476257644490e+01
R482_557	482	557	5.6598048790544603e+01
R482_558	482	558	1.3189532348688930e+01
R482_559	482	559	1.4500153256181159e+01
R483_484	483	484	1.8354024832782709e+01
R483_518	483	518	3.0939045701555038e+01
R483_521	483	521	6.1864648815706396e+01
R483_548	483	548	3.0939045701555052e+01
R483_549	483	549	4.9293239246532735e+01
R483_557	483	557	3.5435683217651693e+01
R483_560	483	560	4.4491897821791952e+01
R483_561	483	561	1.8856124623315544e+01
R483_562	483	562	6.4430133991841231e+01
R484_485	484	485	1.4014169678891191e+01
R484_521	484	521	1.9436265541514544e+01
R484_529	484	529	2.8427812788842800e+01
R484_530	484	530	3.7753474533395803e+01
R484_548	484	548	3.3250135930217787e+01
R484_560	484	560	2.9229053341162739e+01
R484_562	484	562	1.2101437209771936e+01
R485_530	485	530	5.1258307340383553e+01
R485_548	485	548	6.9103903142557627e+01
R485_562	485	562	9.7387024173875588e+01
R486_495	486	495	4.9780702349721213e-07
R486_511	486	511	4.9513778354277880e-07
R486_540	486	540	6.2583888771478605e-07
R486_493	486	493	1.5962742122257873e-06
R486_563	486	563	1.2589730516872566e-06
R487_488	487	488	1.7179878765412141e+01
R487_489	487	489	3.6938738763973490e+01
R487_493	487	493	1.0361596670737889e-07
R487_540	487	540	4.3583039372448560e-07
R487_491	487	491	1.2433915880546309e-06
R487_494	487	494	7.7711975030534183e-07
R487_564	487	564	2.9899853378244657e-07
R488_489	488	489	2.6849409713230745e+01
R488_533	488	533	1.1570558287547449e+01
R488_535	488	535	2.6164075829952630e+01
R488_539	488	539	6.4995355745067238e+00
R488_540	488	540	1.1570558287547403e+01
R488_564	488	564	2.0098986700333398e+01
R488_565	488	565	5.4020246806596504e+01
R489_532	489	532	2.1745609036215168e+01
R489_490	489	490	3.9091257180242550e+01
R489_533	489	533	1.9851954350537113e+01
R489_564	489	564	5.5740657235894901e+01
R489_491	489	491	5.5521039292911738e+01
R489_565	489	565	2.1294213729146531e+01
R490_492	490	492	2.8147735016470861e+01
R490_528	490	528	2.7927503357617915e+01
R490_513	490	513	4.4284451951341417e+01
R490_532	490	532	3.0451118132890386e+01
R490_565	490	565	9.6250318954873535e+00
R490_491	490	491	2.4420327457586129e+01
R490_566	490	566	2.9764508564484455e+01
R491_494	491	494	1.2584901119880024e-07
R491_564	491	564	6.1981626384717323e-07
R491_565	491	565	2.7721089839948181e+01
R491_513	491	513	1.5101881192837217e-06
R491_531	491	531	9.4386758399100199e-07
R491_566	491	566	2.5507278522225849e-07
R492_525	492	525	2.5898238041886206e+01
R492_527	492	527	1.3453347158340000e+01
R492_528	492	528	4.0317080503489493e+01
R492_532	492	532	1.5695571684729995e+01
R492_534	492	534	1.3776175104546786e+01
R492_565	492	565	3.0934464058072809e+01
R492_567	492	567	5.0810060152061737e+01
R493_540	493	540	3.8683509378458891e-07
R493_563	493	563	4.4960424409014087e-07
R493_564	493	564	3.9512289347617764e-07
R493_494	493	494	1.0168794273901222e-06
R493_568	493	568	7.8337421566946323e-07
R494_564	494	564	1.7651045414732612e-07
R494_566	494	566	1.8709428597381930e-07
R494_531	494	531	4.9449794586304912e-07
R494_568	494	568	3.8366385915380679e-07
R494_569	494	569	1.6161199163126877e-07
R495_505	495	505	2.6136194144325854e-07
R495_511	495	511	7.3949178714901240e-08
R495_512	495	512	2.8314036950130501e-07
R495_535	495	535	1.5733751546309380e+01
R495_540	495	540	3.4018870257558767e-07
R495_570	495	570	3.4197786651176490e-07
R496_497	496	497	9.2513006670684472e+00
R496_502	496	502	5.6118152378738433e+00
R496_504	496	504	2.2391805563146679e+01
R496_543	496	543	2.6061736843905773e+01
R496_559	496	559	1.6162128223620901e+01
R496_571	496	571	3.8008826927252976e+01
R497_543	497	543	1.6658943494660285e+01
R497_546	497	546	8.6535361358392766e+00
R497_557	497	557	1.5916196583774509e+01
R497_558	497	558	2.6511275070498314e+01
R497_559	497	559	9.0625465841991648e+00
R497_571	497	571	1.5914272502991164e+01
R497_572	497	572	8.6060082908470417e+00
R498_500	498	500	8.3107328059368353e+00
R498_501	498	501	3.0268576769629206e+01
R498_506	498	506	1.9423869849640919e+01
R498_507	498	507	2.2780096843033171e+01
R498_535	498	535	1.4332162414673038e+01
R498_536	498	536	2.1523329448313781e+01
R498_538	498	538	1.3894204519966143e+01
R498_573	498	573	2.0603099342472216e+01
R499_500	499	500	6.7385222854821007e+00
R499_501	499	501	7.0252459145682256e+00
R499_503	499	503	9.3713431363835937e+00
R499_508	499	508	1.4514453019531119e+01
R499_510	499	510	1.4903988209229118e+01
R499_574	499	574	1.4401412723907823e+01
R500_501	500	501	1.7124190776622434e+01
R500_503	500	503	1.2774555076732769e+01
R500_506	500	506	3.3363980452530186e+01
R500_536	500	536	1.0382766836527777e+01
R500_538	500	538	2.8383904461979309e+01
R500_574	500	574	2.3961831867976429e+01
R501_506	501	506	2.1634768462690754e+01
R501_510	501	510	3.9330527933766099e+01
R501_574	501	574	3.8530702088239579e+01
R502_503	502	503	2.1329117337612921e+01
R502_504	502	504	2.6348568754394133e+01
R502_508	502	508	9.6063192349579207e+00
R502_556	502	556	1.8863590956459049e+01
R502_559	502	559	9.1545406504143259e+00
R502_575	502	575	2.4363217445641894e+01
R503_504	503	504	1.8336451281889584e+01
R503_508	503	508	2.8141723521598148e+01
R503_536	503	536	1.4137787558092636e+01
R503_541	503	541	3.2513414595252335e+01
R503_574	503	574	1.5298912540535643e+01
R503_575	503	575	3.6557313976780812e+01
R503_576	503	576	2.9720280182989040e+01
R504_541	504	541	1.0461983226796233e+01
R504_543	504	543	2.9430747079735589e+01
R504_544	504	544	3.0009677667907884e+01
R504_559	504	559	3.8866462975827929e+01
R504_571	504	571	1.1512686947609959e+01
R504_575	504	575	1.4818794512623652e+01
R504_576	504	576	3.2412022830676342e+01
R504_577	504	577	1.2934396763664614e+01
R505_512	505	512	1.4342012955272088e-07
R505_535	505	535	6.1993918729286627e+01
R505_507	505	507	4.6184081372265645e+01
R505_570	505	570	8.3697048316411662e-07
R505_578	505	578	1.7210415374222365e-06
R506_507	506	507	3.7093310634464849e+01
R506_536	506	536	4.0351138074192249e+01
R506_573	506	573	1.6488401605943672e+01
R506_574	506	574	1.1404974326210821e+01
R506_510	506	510	6.3313071160563069e+01
R506_581	506	581	2.5212290503482269e+01
R506_582	506	582	5.4510743021011940e+01
R507_535	507	535	2.5496952478569149e+01
R507_570	507	570	3.2596787382305664e+01
R507_573	507	573	1.0554964949984885e+01
R507_578	507	578	2.6692387879019254e+01
R507_582	507	582	4.2405594979786166e+01
R508_510	508	510	3.6807654718589076e+00
R508_509	508	509	2.2896436990882897e+01
R508_556	508	556	5.1887313249777147e+00
R508_574	508	574	4.8675599262711549e+00
R508_575	508	575	1.1754220769863323e+01
R508_580	508	580	1.1363228978278496e+01
R508_581	508	581	1.9559484627284402e+01
R508_583	508	583	1.6875664682286139e+01
R509_510	509	510	5.1603230910588074e+01
R509_551	509	551	5.0839634584278336e+01
R509_555	509	555	3.1092579900966573e+01
R509_556	509	556	2.3092930674062139e+01
R509_583	509	583	3.8739894499264551e+01
R510_574	510	574	1.6587667793535534e+01
R510_581	510	581	3.4523172816564752e+01
R510_583	510	583	6.8095805159132894e+01
R511_512	511	512	2.8819944713419348e-07
R511_540	511	540	1.8411194011004117e-07
R511_563	511	563	3.5672914949603512e-07
R511_570	511	570	2.7676408370334454e-07
R511_584	511	584	3.2084628566729831e-07
R512_570	512	570	3.0990348462640953e-07
R512_578	512	578	9.5052114547961387e-07
R512_584	512	584	9.5688144753947765e-07
R512_585	512	585	7.6041691638369101e-07
R513_528	513	528	4.0729699884558556e+01
R513_531	513	531	1.6959964161086259e-07
R513_566	513	566	6.0349346662714768e-07
R513_589	513	589	1.3567971193189324e-06
R514_515	514	515	2.1195872139305770e+01
R514_516	514	516	1.3065558585468125e+01
R514_519	514	519	3.0179665125151317e+01
R514_522	514	522	2.7660430115983750e+01
R514_523	514	523	1.9134959603214718e+01
R514_543	514	543	1.2812279948785468e+01
R514_590	514	590	1.7976073480912255e+01
R515_516	515	516	7.3150951697038842e+00
R515_525	515	525	2.3931542600661729e+01
R515_541	515	541	1.9521602956330725e+01
R515_542	515	542	2.7380675857947988e+01
R515_543	515	543	2.0312789806031031e+01
R515_544	515	544	2.0835011177685516e+01
R515_590	515	590	2.7674086588180142e+01
R515_591	515	591	1.5787874314412644e+01
R516_522	516	522	3.4300696415607277e+01
R516_525	516	525	1.6039659347790142e+01
R516_526	516	526	2.5935876253337476e+01
R516_590	516	590	1.6992822839664964e+01
R516_591	516	591	2.1337898144736357e+01
R517_518	517	518	2.3103339021552486e+01
R517_519	517	519	1.9307653125940082e+01
R517_520	517	520	1.2999187369057671e+01
R517_521	517	521	1.9507391880994142e+01
R517_523	517	523	5.2611325233230879e+01
R517_524	517	524	3.9681464110421679e+01
R517_592	517	592	3.9818874923076436e+01
R518_519	518	519	6.8813876056422298e+00
R518_521	518	521	6.6691557348123816e+00
R518_546	518	546	1.7621688842075017e+01
R518_545	518	545	8.7764011338086618e+00
R518_557	518	557	1.2145789496582312e+01
R518_560	518	560	2.0713280183888021e+01
R518_561	518	561	2.3512181870780822e+01
R518_592	518	592	3.7257266110088466e+01
R519_523	519	523	7.0853350563959037e+00
R519_543	519	543	2.0155203649103875e+01
R519_545	519	545	1.2558559900447127e+01
R519_546	519	546	1.4602806321963723e+01
R519_592	519	592	3.5961090391740818e+01
R520_521	520	521	1.4203792171918423e+01
R520_524	520	524	4.9678258309162835e+01
R520_529	520	529	4.0824747909079285e+01
R520_592	520	592	3.2201220782658588e+01
R521_529	521	529	7.2250281373780396e+00
R521_560	521	560	7.6576080563449098e+00
R521_545	521	545	2.9890247330003788e+01
R521_592	521	592	1.4736847398876984e+01
R521_594	521	594	2.3895456491365753e+01
R522_523	522	523	3.4003208999764134e+01
R522_524	522	524	3.7117115624364772e+01
R522_526	522	526	2.1589351760626130e+01
R522_590	522	590	3.5334832022390792e+01
R522_595	522	595	4.6312034698559884e+01
R523_524	523	524	1.5472067903760260e+01
R523_543	523	543	3.5317722952111566e+01
R523_545	523	545	2.7178306643634151e+01
R523_590	523	590	1.3077125077001449e+01
R523_592	523	592	1.9008423791666214e+01
R523_593	523	593	2.1399246078717209e+01
R523_595	523	595	2.1081249474526512e+01
R524_592	524	592	4.6514877960145164e+01
R524_595	524	595	7.9896280485676101e+01
R525_526	525	526	1.4798397356226912e+01
R525_527	525	527	1.6767580580782024e+01
R525_532	525	532	2.9214554055890432e+01
R525_534	525	534	1.5211813617190073e+01
R525_542	525	542	2.0501218790753196e+01
R525_591	525	591	1.1452318921327326e+01
R525_596	525	596	3.1688570818043761e+01
R525_597	525	597	2.1998566733463360e+01
R526_527	526	527	4.0257141355830022e+01
R526_590	526	590	2.7997279192569767e+01
R526_591	526	591	3.3360026299571778e+01
R526_595	526	595	5.1253337873774100e+01
R526_597	526	597	2.0077258056844649e+01
R527_528	527	528	3.2327395268109555e+01
R527_534	527	534	2.2413347421303733e+01
R527_567	527	567	3.6693015458786206e+01
R527_597	527	597	4.6126240813337816e+01
R527_598	527	598	4.3949882881717002e+01
R528_565	528	565	4.0363958333774363e+01
R528_566	528	566	3.0586583442250507e+01
R528_567	528	567	8.3395182849374958e+00
R528_589	528	589	2.8264292617005392e+01
R528_598	528	598	6.3857031132465266e+01
R529_530	529	530	5.4158865785101078e+01
R529_560	529	560	1.9205629142038863e+01
R529_562	529	562	5.6185604792569464e+01
R529_592	529	592	5.1598701979569590e+01
R529_594	529	594	5.1792086774143229e+01
R529_601	529	601	5.9611539641164583e+01
R529_602	529	602	5.4158865785101099e+01
R530_562	530	562	4.2335775338965107e+01
R530_602	530	602	1.2676817818158679e+02
R531_566	531	566	2.1505200525710831e-07
R531_569	531	569	5.6489144827597888e-07
R531_589	531	589	7.0766526444708952e-07
R531_603	531	603	5.6613221155767085e-07
R532_533	532	533	9.8827317947033411e+00
R532_534	532	534	1.6288605346926271e+01
R532_542	532	542	2.4154471666507593e+01
R532_565	532	565	1.0885820474650281e+01
R532_604	532	604	4.4159553723822000e+01
R533_537	533	537	3.0124349780070300e+01
R533_539	533	539	1.1682339681383445e+01
R533_542	533	542	3.0557580425119376e+01
R533_565	533	565	2.9014231753687323e+01
R533_604	533	604	5.3293947633602379e+01
R534_542	534	542	3.1429975129790886e+01
R534_565	534	565	1.5114155179067149e+01
R534_567	534	567	1.1311705863363869e+01
R534_596	534	596	2.2694325347114503e+01
R534_597	534	597	5.7627461307390980e+01
R534_598	534	598	2.5518777400136234e+01
R534_604	534	604	1.1042620391519637e+01
R535_538	535	538	1.0168594285689853e+01
R535_539	535	539	1.7565067701079240e+01
R535_540	535	540	1.7207814851487843e+01
R535_570	535	570	1.0319562977774023e+01
R535_573	535	573	1.7191991628676124e+01
R535_579	535	579	4.1923708067957840e+01
R535_605	535	605	2.6839905711879595e+01
R536_538	536	538	4.6511818506450204e+00
R536_537	536	537	1.3031996825599959e+01
R536_541	536	541	2.1662292148164116e+01
R536_573	536	573	7.8715648381802046e+00
R536_574	536	574	1.4454192939186349e+01
R536_576	536	576	6.0371919185940373e+00
R536_605	536	605	2.7679960593983566e+01
R537_538	537	538	8.3661538511633307e+00
R537_539	537	539	1.9034904915898302e+01
R537_541	537	541	1.4336893510990592e+01
R537_542	537	542	1.0570275650807218e+01
R537_576	537	576	5.3931489442645130e+01
R537_605	537	605	2.2138864434750467e+01
R538_539	538	539	2.5153708408057298e+01
R538_573	538	573	2.3730244284118275e+01
R538_605	538	605	2.1965893952150012e+01
R539_540	539	540	2.0947175227191895e+01
R539_542	539	542	2.6183969033989875e+01
R539_564	539	564	2.0343647957921203e+01
R539_565	539	565	4.3234242124846638e+01
R539_570	539	570	5.8379346272074947e+01
R539_604	539	604	1.6997986591510017e+01
R539_605	539	605	1.1781196895504472e+01
R539_606	539	606	1.4991576340908050e+01
R540_563	540	563	3.9606605174006503e-08
R540_564	540	564	2.7530339139325575e-07
R540_570	540	570	3.3131125033966911e-07
R540_584	540	584	2.9305463280073970e-07
R540_606	540	606	2.7345843617705022e-07
R541_542	541	542	1.7155283988571295e+01
R541_543	541	543	5.4892195087910544e+01
R541_544	541	544	1.3055190918982154e+01
R541_576	541	576	1.8312956392397357e+01
R541_577	541	577	2.9160825741087894e+01
R541_605	541	605	5.8860526625551444e+01
R541_607	541	607	2.7144200807326460e+01
R542_544	542	544	6.2482003539604328e+01
R542_591	542	591	5.4250290435321993e+01
R542_596	542	596	4.5454403048064165e+01
R542_604	542	604	1.9282981071876574e+01
R542_605	542	605	5.8529178107145839e+01
R542_607	542	607	3.4365187845867155e+01
R543_544	543	544	3.8565502334855360e+01
R543_545	543	545	7.0002608229205521e+01
R543_546	543	546	2.8312232145104765e+01
R543_571	543	571	2.8187179609423172e+01
R543_587	543	587	6.7512941755061590e+01
R543_590	543	590	4.2896687603338314e+01
R543_593	543	593	7.1845252282732588e+01
R543_608	543	608	7.1150901642188586e+01
R544_571	544	571	3.2979861764203378e+01
R544_577	544	577	3.4887832751960090e+01
R544_590	544	590	6.7516278478926253e+01
R544_591	544	591	2.8317228222180500e+01
R544_607	544	607	1.6758868655050243e+01
R544_608	544	608	1.8553368205390413e+01
R544_610	544	610	4.2177852814858142e+01
R545_546	545	546	1.5523041420767246e+01
R545_557	545	557	6.1856227104148708e+01
R545_560	545	560	4.6898545253912808e+01
R545_561	545	561	7.1918321125595327e+01
R545_587	545	587	2.1813007060128299e+01
R545_592	545	592	3.7982448765333494e+01
R545_593	545	593	1.3851620432138525e+01
R545_594	545	594	1.6258553804063652e+01
R545_600	545	600	2.7154828555256426e+01
R545_611	545	611	2.3059566748161302e+01
R546_557	546	557	2.2244731681429453e+01
R546_571	546	571	3.6304924191726208e+01
R546_572	546	572	9.6788990358611144e+00
R546_587	546	587	2.9080868567867665e+01
R546_611	546	611	5.5520456629108871e+01
R547_548	547	548	3.1063002526168976e+01
R547_549	547	549	2.4796349331535101e+01
R547_550	547	550	5.1710425770380041e+01
R547_553	547	553	4.8918249711573310e+01
R547_614	547	614	5.1279530600990050e+01
R548_549	548	549	4.0338830289509019e+01
R548_561	548	561	7.9235524068184176e+01
R548_562	548	562	5.6467123874464257e+01
R548_612	548	612	7.8546885165531037e+01
R548_614	548	614	1.3292857116136628e+02
R549_550	549	550	2.0884549817490232e+01
R549_557	549	557	2.4428778608941524e+01
R549_558	549	558	3.0412523556211980e+01
R549_561	549	561	7.4392471291140836e+01
R549_612	549	612	5.3374360244326773e+01
R549_614	549	614	2.3556883048525805e+01
R549_616	549	616	4.0763917480009518e+01
R550_552	550	552	1.4402596471364987e+01
R550_553	550	553	3.2955408483214264e+01
R550_558	550	558	2.7462840402678538e+01
R550_614	550	614	4.7139955928407687e+01
R550_616	550	616	6.4506214053439393e+01
R551_552	551	552	6.1352149646447323e+01
R551_554	551	554	1.2075700719374099e+02
R551_555	551	555	5.1829795266451569e+01
R551_583	551	583	1.0654476619678539e+02
R551_615	551	615	1.8331261459136240e+02
R551_617	551	617	3.3620099895758486e+01
R551_586	551	586	1.8282178587033744e+02
R552_553	552	553	3.2647061811635382e+01
R552_554	552	554	4.7426211275509438e+01
R552_555	552	555	2.9391896619883411e+01
R552_558	552	558	5.5110458349267184e+01
R552_614	552	614	8.0174184163411311e+01
R552_616	552	616	3.6930858433936635e+01
R552_617	552	617	3.5532732750714523e+01
R552_618	552	618	2.1943861004888678e+01
R553_554	553	554	1.0280426545608603e+02
R553_614	553	614	8.8167650601579027e+01
R553_618	553	618	1.5190744804933061e+02
R554_615	554	615	9.1806451249955103e+01
R554_617	554	617	7.2306118352243416e+01
R554_618	554	618	5.4268738430503198e+01
R555_556	555	556	8.8227338697023558e+00
R555_558	555	558	7.5669010532128622e+00
R555_559	555	559	2.2519159212449591e+01
R555_583	555	583	2.3746301339751380e+01
R555_616	555	616	2.4463536876624005e+01
R555_617	555	617	9.9951543100123423e+00
R555_619	555	619	7.1200523357332690e+00
R556_559	556	559	1.1737649747768602e+01
R556_575	556	575	1.5064366928892019e+01
R556_580	556	580	1.6765539826458451e+01
R556_583	556	583	1.7870299017116139e+01
R556_619	556	619	1.1845370063393128e+01
R557_558	557	558	1.8193240697282153e+01
R557_561	557	561	1.3252958831752869e+01
R557_572	557	572	1.2753923297047125e+01
R557_611	557	611	1.8714132490322012e+01
R557_612	557	612	5.3999817800108140e+01
R557_613	557	613	3.5732251082969000e+01
R557_616	557	616	3.4217234072184802e+01
R557_620	557	620	4.3766144368690249e+01
R558_559	558	559	9.1295268795913262e+00
R558_572	558	572	2.2082132401419301e+01
R558_616	558	616	7.7569217888411002e+00
R558_619	558	619	2.7742426471674897e+01
R558_620	558	620	2.0560422948950794e+01
R559_571	559	571	2.7273340537104996e+01
R559_572	559	572	3.1631725066907492e+01
R559_575	559	575	1.7371233927981667e+01
R559_619	559	619	3.5638540937425461e+01
R559_620	559	620	7.3565981181649349e+01
R559_621	559	621	3.5297281398642255e+01
R560_561	560	561	9.5003355598860679e+00
R560_562	560	562	2.6418407795435144e+01
R560_594	560	594	1.6900753210947713e+01
R560_601	560	601	3.2984784430905968e+01
R560_588	560	588	2.7166454567574760e+01
R560_602	560	602	5.6223745692583776e+01
R560_611	560	611	5.6323189808661269e+01
R560_623	560	623	4.0435055439187693e+01
R561_562	561	562	2.4175055635830049e+01
R561_588	561	588	1.2758065992643163e+01
R561_611	561	611	2.0364234013053025e+01
R561_612	561	612	1.3272060965516129e+01
R561_613	561	613	4.0410314082472581e+01
R561_623	561	623	3.6063322190893430e+01
R562_602	562	602	4.8148916110824537e+01
R562_612	562	612	9.4866441032029982e+01
R562_623	562	623	5.8006002644184697e+01
R563_564	563	564	4.9240938309193599e-07
R563_568	563	568	5.5276845211343014e-07
R563_584	563	584	6.5700385349548190e-07
R563_606	563	606	4.0452412170101457e-07
R563_627	563	627	1.0580225536083391e-06
R564_565	564	565	1.7647146890235593e+01
R564_566	564	566	4.1286064424828316e-07
R564_568	564	568	7.0089706224000331e-08
R564_569	564	569	3.7002937058741907e-07
R564_604	564	604	4.8654173443839525e+01
R564_606	564	606	4.0818453442985639e-07
R564_628	564	628	5.9027387288637738e-07
R565_566	565	566	9.7733105944960119e+00
R565_567	565	567	1.1813573389952941e+01
R565_604	565	604	1.6593721817526056e+01
R565_628	565	628	3.9794774739699427e+01
R566_567	566	567	2.4616538924924530e+01
R566_569	566	569	9.9810477484145982e-08
R566_589	566	589	3.9716639071459276e-07
R566_603	566	603	4.2063329417271622e-07
R566_628	566	628	5.2731516991501823e-07
R567_589	567	589	1.8154845591322164e+01
R567_598	567	598	1.4045712912426778e+01
R567_604	567	604	4.2790477982759967e+01
R567_628	567	628	2.6215161004110801e+01
R568_569	568	569	2.6400686320572079e-07
R568_606	568	606	2.8626888055121907e-07
R568_627	568	627	7.2272103497434649e-07
R568_628	568	628	4.3687729163548832e-07
R568_630	568	630	4.4016086755335203e-07
R569_603	569	603	4.0470791724821463e-07
R569_628	569	628	3.5694819288382878e-07
R569_630	569	630	6.5430694389413054e-07
R570_573	570	573	4.5309553074366626e+01
R570_578	570	578	5.1803635393882803e-07
R570_579	570	579	1.4761337648949553e+01
R570_584	570	584	5.8504192376002664e-08
R570_585	570	585	4.8383679141567652e-07
R570_605	570	605	3.6173426625508256e+01
R570_606	570	606	1.0282092291063768e-06
R570_626	570	626	6.2578877907216462e-07
R570_632	570	632	5.1361570473017548e-07
R571_572	571	572	1.0005042289127333e+01
R571_575	571	575	2.5211466535486004e+01
R571_577	571	577	1.4689907500603487e+01
R571_587	571	587	1.2029315149787697e+01
R571_608	571	608	3.7513222964354689e+01
R571_610	571	610	1.5383895891614825e+01
R571_621	571	621	1.1706715145374034e+01
R571_633	571	633	2.9978054137878075e+01
R572_587	572	587	2.1527731698090339e+01
R572_611	572	611	1.9738009377582006e+01
R572_620	572	620	2.1772109163274159e+01
R572_621	572	621	3.4493589314013335e+01
R572_633	572	633	3.6580609892706569e+01
R573_574	573	574	3.0842092068418133e+01
R573_576	573	576	2.1121462799209322e+01
R573_578	573	578	6.1491314012158192e+01
R573_579	573	579	1.0151263200064074e+01
R573_581	573	581	5.9832306516043396e+01
R573_582	573	582	2.2419064123767050e+01
R573_605	573	605	3.8990398528491880e+01
R573_635	573	635	3.1365036296341781e+01
R574_575	574	575	2.9425795130226291e+01
R574_576	574	576	3.1949923410886164e+01
R574_580	574	580	3.3388259242534808e+01
R574_581	574	581	1.5204976383262922e+01
R574_635	574	635	3.6418383179359992e+01
R575_576	575	576	3.2915051175036112e+01
R575_577	575	577	2.0602282945548190e+01
R575_580	575	580	2.2030649496019564e+01
R575_619	575	619	2.4652904509158667e+01
R575_621	575	621	9.0005733560288483e+00
R575_634	575	634	4.0311061058226208e+01
R575_635	575	635	4.8024427587761224e+01
R575_636	575	636	2.5799202479286400e+01
R576_577	576	577	1.0009416183540782e+01
R576_605	576	605	1.0280566322560896e+01
R576_579	576	579	1.8989248391905274e+01
R576_607	576	607	3.9248794148269226e+01
R576_609	576	609	9.6037382497732953e+00
R576_635	576	635	1.5496306651678312e+01
R576_636	576	636	2.3806455994548642e+01
R577_607	577	607	1.8014836815594602e+01
R577_609	577	609	1.9589195650124172e+01
R577_610	577	610	3.8578515428947338e+00
R577_621	577	621	1.3839391011072617e+01
R577_636	577	636	9.4803197747074268e+00
R578_579	578	579	5.4583584923685912e+01
R578_582	578	582	3.3312323224084210e+01
R578_585	578	585	1.3588461990755432e-07
R578_632	578	632	6.3242726164332530e-07
R578_637	578	637	1.6306154225844952e-06
R579_582	579	582	4.5679855439278455e+01
R579_605	579	605	1.0324359816402207e+01
R579_609	579	609	2.0128452304797143e+01
R579_626	579	626	1.1598819805152317e+01
R579_632	579	632	1.2472551594788547e+01
R579_635	579	635	2.1480996427025076e+01
R579_638	579	638	2.4733397461761687e+01
R580_581	580	581	1.0425814712939223e+01
R580_583	580	583	4.9669392712462228e+00
R580_619	580	619	1.3032268391174039e+01
R580_634	580	634	1.0414933300816960e+01
R580_635	580	635	1.9304740097125308e+01
R580_639	580	639	2.6081027376701009e+01
R581_582	581	582	5.5545767701347771e+01
R581_583	581	583	6.2516626292331914e+01
R581_635	581	635	4.7058332944623693e+01
R581_639	581	639	8.4779980330588018e+01
R582_632	582	632	5.6823811286813275e+01
R582_635	582	635	2.1938789550744993e+01
R582_637	582	637	6.1924780331752039e+01
R582_639	582	639	1.0026863011007340e+02
R583_617	583	617	6.4643856590949468e+01
R583_586	583	586	6.2002625657898541e+01
R583_619	583	619	3.4980940923530994e+01
R583_634	583	634	5.2490059424203949e+01
R583_639	583	639	9.9443600681517736e+01
R583_640	583	640	9.3477635151637841e+01
R584_585	584	585	6.3580929444071416e-07
R584_606	584	606	4.2225727852760634e-07
R584_626	584	626	2.3161854080678115e-07
R584_627	584	627	5.9029479444675932e-07
R584_631	584	631	5.8787338370348842e-07
R584_632	584	632	4.7877430221649202e-07
R584_641	584	641	5.2296487427426849e-07
R585_632	585	632	4.1365047923111256e-07
R585_637	585	637	8.4018618498841215e-07
R585_641	585	641	6.0164722040688092e-07
R585_642	585	642	2.0164468439721902e-06
R586_617	586	617	3.4262729649426426e+01
R586_615	586	615	4.8083654719769953e+01
R586_634	586	634	4.3605839451866821e+01
R586_639	586	639	9.6392090120667390e+01
R586_640	586	640	1.2193890503256064e+01
R586_643	586	643	3.5993681736033636e+01
R586_644	586	644	7.7473816856599981e+01
R587_593	587	593	1.6497344086523331e+01
R587_600	587	600	8.8972625413125943e+00
R587_608	587	608	7.7002781084125909e+00
R587_610	587	610	2.6097813383384505e+01
R587_611	587	611	1.0348144948598334e+01
R587_633	587	633	1.4393101808437894e+01
R587_647	587	647	2.0343868257757975e+01
R587_648	587	648	2.4632607616526048e+01
R588_594	588	594	2.5484482469772946e+01
R588_601	588	601	4.3030080763173615e+01
R588_611	588	611	8.4010024950526372e+00
R588_600	588	600	3.8729375141257570e+01
R588_613	588	613	1.6476754335234713e+01
R588_612	588	612	2.6599886452383885e+01
R588_622	588	622	9.2224852168771196e+00
R588_623	588	623	8.4010024950526372e+00
R588_624	588	624	1.3526034018119287e+01
R588_648	588	648	2.2471935119979175e+01
R589_598	589	598	4.4493696822114813e+01
R589_603	589	603	1.3555462870785005e-07
R589_628	589	628	8.6706968922177089e-07
R589_649	589	649	1.6266555282276469e-06
R590_591	590	591	1.1983267367378087e+01
R590_593	590	593	1.4645117043353725e+01
R590_595	590	595	1.5766626894180325e+01
R590_597	590	597	7.0843080188223809e+01
R590_608	590	608	2.6381822220635193e+01
R590_651	590	651	5.7247307240097150e+01
R591_596	591	596	1.3879636252166707e+01
R591_597	591	597	1.4466749022846928e+01
R591_599	591	599	7.8191188601953989e+00
R591_607	591	607	2.1555059264443500e+01
R591_608	591	608	1.3055421374873756e+01
R591_651	591	651	3.3306476165873541e+01
R592_593	592	593	3.8915823880733448e+01
R592_594	592	594	1.5893659379963772e+01
R592_595	592	595	5.6824641437352390e+01
R592_601	592	601	8.3171460071160411e+01
R592_652	592	652	5.5539992033266387e+01
R593_594	593	594	2.5760853406959335e+01
R593_595	593	595	1.9768361963280764e+01
R593_600	593	600	8.1957069113967709e+00
R593_608	593	608	6.7121486118651568e+00
R593_651	593	651	2.8407148205240468e+01
R593_652	593	652	2.0699248412344133e+01
R594_600	594	600	1.0800362221975622e+01
R594_601	594	601	1.2490386090026965e+01
R594_611	594	611	3.8981367383039199e+01
R594_622	594	622	3.5212473162322041e+01
R594_652	594	652	2.4096808164152193e+01
R595_597	595	597	6.5780857027355253e+01
R595_651	595	651	3.7276880583218500e+01
R595_652	595	652	6.7624326663376891e+01
R596_597	596	597	1.9595889897410153e+01
R596_598	596	598	2.1337686714582045e+01
R596_599	596	599	9.7031766463541658e+00
R596_604	596	604	1.3686355400957943e+01
R596_607	596	607	1.9725227345182887e+01
R596_625	596	625	9.9898934568091722e+00
R596_628	596	628	4.7336381822901942e+01
R596_649	596	649	6.0412685045318867e+01
R596_653	596	653	2.6735395389523799e+01
R597_598	597	598	3.9838478817886397e+01
R597_599	597	599	3.1801121707366178e+01
R597_651	597	651	2.2640443207356853e+01
R597_653	597	653	4.2909437377349192e+01
R598_604	598	604	4.8865728854825875e+01
R598_628	598	628	3.3945259628172153e+01
R598_649	598	649	3.0177036495294562e+01
R598_653	598	653	5.5647245158591325e+01
R599_607	599	607	1.8048901298286580e+01
R599_608	599	608	1.4373550819166995e+01
R599_625	599	625	3.3701943841970284e+01
R599_647	599	647	6.3550673678475505e+01
R599_650	599	650	1.1197222459232743e+01
R599_651	599	651	2.4284379921286934e+01
R599_653	599	653	3.5867030683384051e+01
R600_608	600	608	2.0369980651770852e+01
R600_611	600	611	2.3046330453877054e+01
R600_622	600	622	2.5234906001499972e+01
R600_647	600	647	4.9594489095718423e+01
R600_648	600	648	1.8899863060422849e+01
R600_651	600	651	6.2987751346063312e+01
R600_652	600	652	1.9356813560761811e+01
R600_654	600	654	1.3914314782266796e+01
R601_602	601	602	5.7170327864982958e+01
R601_622	601	622	2.1775867739175546e+01
R601_623	601	623	4.4622761585618093e+01
R601_652	601	652	5.1064306383701933e+01
R601_655	601	655	8.2120092616718850e+01
R601_656	601	656	5.1471545529606473e+01
R602_623	602	623	9.8265840603839777e+01
R602_656	602	656	3.2020502710161139e+02
R603_628	603	628	5.3087091533215235e-07
R603_630	603	630	1.3257959633078534e-06
R603_649	603	649	1.5126520293268011e-06
R603_657	603	657	1.2101216234614399e-06
R604_605	604	605	4.7445605804206608e+01
R604_606	604	606	4.3700186888157361e+01
R604_607	604	607	4.7729839534676415e+01
R604_625	604	625	3.4596767122485119e+01
R604_628	604	628	1.5035910682756107e+01
R604_629	604	629	3.5460350661109224e+01
R604_658	604	658	6.8665264274045981e+01
R605_606	605	606	4.1198273760198127e+01
R605_607	605	607	8.0072087338523730e+01
R605_609	605	609	3.5879341902020734e+01
R605_626	605	626	4.4339236564046807e+01
R605_629	605	629	1.1520228004165190e+02
R605_658	605	658	7.3557588326500650e+01
R605_659	605	659	6.6885809725362265e+01
R606_626	606	626	8.3628866188700485e-07
R606_627	606	627	1.1190079215894039e-07
R606_628	606	628	1.1007695521866005e-06
R606_629	606	629	6.1107083317356725e-07
R606_630	606	630	9.6292513651453381e-07
R606_659	606	659	1.3426574201540439e-06
R607_608	607	608	5.3445567612798506e+01
R607_609	607	609	5.7509424009985736e+01
R607_610	607	610	2.7822772916876445e+01
R607_625	607	625	3.0092226982273957e+01
R607_647	607	647	4.2453225247034048e+01
R607_650	607	650	6.8921610308585755e+01
R607_658	607	658	1.6528992177813763e+01
R607_660	607	660	7.2657122892771881e+01
R608_610	608	610	4.7874758064924933e+01
R608_647	608	647	2.2138598513864473e+01
R608_650	608	650	4.3037988759136248e+01
R608_651	608	651	3.8254823445367961e+01
R608_654	608	654	5.9577988629530239e+01
R608_661	608	661	1.0157788295233503e+02
R609_610	609	610	1.8619393579040356e+01
R609_626	609	626	1.7870186380108272e+01
R609_635	609	635	2.9056578147689361e+01
R609_636	609	636	1.0678454175267653e+01
R609_638	609	638	8.2998840836683652e+00
R609_658	609	658	1.2715434491236135e+01
R609_659	609	659	1.6892955704253396e+01
R609_662	609	662	1.9813874587662792e+01
R609_663	609	663	8.2644871729353007e+00
R610_621	610	621	2.5276025045813405e+01
R610_633	610	633	1.0467469285909180e+01
R610_636	610	636	1.7658799697848899e+01
R610_647	610	647	1.3880326639243540e+01
R610_658	610	658	3.8248266038349321e+01
R610_663	610	663	2.0289094586885369e+01
R611_613	611	613	8.7258340896889859e+00
R611_620	611	620	2.0513927174602088e+01
R611_633	611	633	2.3860267038160085e+01
R611_648	611	648	1.0082197878739938e+01
R611_664	611	664	2.2989864714858356e+01
R612_613	612	613	1.4769284842062666e+01
R612_614	612	614	2.5182825034242125e+01
R612_616	612	616	2.8702069509080093e+01
R612_623	612	623	3.6535801188755443e+01
R612_624	612	624	2.6481621560751009e+01
R612_665	612	665	4.1404013414014834e+01
R613_616	613	616	2.4591993140092953e+01
R613_620	613	620	1.9228222607223703e+01
R613_624	613	624	1.6776633307522175e+01
R613_648	613	648	4.3789670545168569e+01
R613_664	613	664	1.3824914884606093e+01
R613_665	613	665	1.7852904676753678e+01
R614_616	614	616	3.0795955708811636e+01
R614_618	614	618	8.8009896888290243e+01
R614_665	614	665	1.4425896772245775e+02
R615_617	615	617	4.4246991235169375e+01
R615_618	615	618	1.5297505272975738e+02
R615_640	615	640	6.9755498552561676e+01
R615_644	615	644	1.5752666104025496e+02
R615_666	615	666	7.7245014735878996e+01
R616_617	616	617	2.8010764108155229e+01
R616_618	616	618	2.3226123764339860e+01
R616_619	616	619	3.5459828396867771e+01
R616_620	616	620	1.1545789711819186e+01
R616_665	616	665	1.3430085642700723e+01
R616_667	616	667	1.8492379329658181e+01
R617_618	617	618	3.3619404743790106e+01
R617_619	617	619	2.9091948667074568e+01
R617_640	617	640	1.2045246010461732e+01
R617_666	617	666	6.2558721196345346e+01
R617_667	617	667	3.1896954511548547e+01
R618_665	618	665	6.3132221675119823e+01
R618_666	618	666	6.1502120764330762e+01
R618_667	618	667	4.5529883027353534e+01
R619_620	619	620	1.6741678343191879e+01
R619_621	619	621	1.7191974137507589e+01
R619_634	619	634	7.6173783267289483e+00
R619_640	619	640	2.0227082838514310e+01
R619_667	619	667	1.7086176182640731e+01
R619_668	619	668	2.9535017429547182e+01
R620_621	620	621	2.4479458311432737e+01
R620_633	620	633	2.7461864098474209e+01
R620_664	620	664	1.8503791357850695e+01
R620_665	620	665	6.7542860955531737e+01
R620_667	620	667	2.8643650863084886e+01
R620_668	620	668	2.2312548645486054e+01
R621_633	621	633	2.4334385358712474e+01
R621_634	621	634	9.6448810145323108e+01
R621_636	621	636	2.8628079212062620e+01
R621_668	621	668	3.2093102715142656e+01
R622_623	622	623	3.0603689746301839e+01
R622_624	622	624	4.7421219478324097e+01
R622_648	622	648	2.1113130992374902e+01
R622_652	622	652	6.2950172350297805e+01
R622_654	622	654	3.0603689746301878e+01
R622_655	622	655	2.7695553499980662e+01
R622_656	622	656	3.7332499192864262e+01
R622_672	622	672	2.4896016184109950e+01
R622_673	622	673	6.2662813354536979e+01
R622_674	622	674	2.9028443728826204e+01
R623_624	623	624	3.0608069208362998e+01
R623_656	623	656	4.0919671035477094e+01
R623_674	623	674	7.2697033011458828e+01
R624_648	624	648	6.8268092394812257e+01
R624_664	624	664	5.1522560768946214e+01
R624_665	624	665	6.9083266492049532e+01
R624_670	624	670	3.6689333800457916e+01
R624_673	624	673	5.5906309354911478e+01
R624_674	624	674	6.5137683278677400e+01
R625_628	625	628	6.1195790032102849e+01
R625_629	625	629	3.5088152902703364e+01
R625_649	625	649	1.0590703338073256e+02
R625_650	625	650	2.6841013447200211e+01
R625_653	625	653	6.1235682808615877e+01
R625_658	625	658	2.5782919843203224e+01
R625_660	625	660	2.4351290765901261e+01
R625_675	625	675	1.5473472202174831e+01
R625_676	625	676	4.3780880409670367e+01
R626_627	626	627	2.4887832899164208e-07
R626_631	626	631	6.7578250792060064e-08
R626_632	626	632	2.3897138543912080e-07
R626_638	626	638	2.5350663248313605e+01
R626_641	626	641	2.4254337123180332e-07
R626_659	626	659	1.8819037018024629e-07
R626_662	626	662	1.7894533472369104e-07
R626_677	626	677	1.6235364638957852e-07
R627_630	627	630	4.8499641590110682e-07
R627_629	627	629	1.5641242335173804e-07
R627_631	627	631	2.8795267643539945e-07
R627_659	627	659	2.9924466664815582e-07
R627_677	627	677	2.1694121282682458e-07
R627_678	627	678	2.5347312933854840e-07
R627_679	627	679	4.1759852881771056e-07
R628_629	628	629	5.7013608980572135e-07
R628_630	628	630	9.9526526487115350e-08
R628_649	628	649	7.1837242471169032e-07
R628_657	628	657	8.9192883131035273e-07
R628_675	628	675	1.5094079045120390e-06
R628_680	628	680	5.6460107426526345e-07
R629_630	629	630	2.4234590933494195e-07
R629_658	629	658	1.6919413709240619e+01
R629_659	629	659	1.9384960657511650e-07
R629_675	629	675	3.9343370282414684e-07
R629_676	629	676	5.4338725457133904e-08
R629_677	629	677	1.9466960971432299e-07
R629_678	629	678	2.1833108648352131e-07
R629_679	629	679	7.7448316175404127e-08
R629_680	629	680	1.7444222300529942e-07
R630_657	630	657	8.0753007209478333e-07
R630_679	630	679	5.8556546092655157e-07
R630_680	630	680	4.7297788309818355e-07
R630_681	630	681	1.2103989048683148e-06
R631_641	631	641	5.0163053896257313e-07
R631_662	631	662	4.9219227168415364e-07
R631_677	631	677	2.1321494918190469e-07
R631_678	631	678	4.3314006776834327e-07
R631_682	631	682	4.4960007605697208e-07
R632_635	632	635	4.4561573352459881e+01
R632_637	632	637	4.8156019710347291e-07
R632_638	632	638	1.5448150004594147e+01
R632_641	632	641	7.4086136654996625e-08
R632_662	632	662	7.3537812062859111e-07
R632_683	632	683	9.2652459483020166e-07
R633_636	633	636	2.2673951214645516e+01
R633_647	633	647	1.5408834073152702e+01
R633_648	633	648	2.3924731358610543e+01
R633_663	633	663	3.1581607464573853e+01
R633_664	633	664	1.7145063226937967e+01
R633_668	633	668	8.2355157267366490e+00
R633_671	633	671	1.4084770056408439e+01
R633_684	633	684	3.0344604026567907e+01
R633_687	633	687	3.7368169749608249e+01
R634_635	634	635	1.8772544713762880e+01
R634_636	634	636	1.4672917368378524e+01
R634_639	634	639	1.2035371281778207e+01
R634_640	634	640	9.9436260111844277e+00
R634_643	634	643	3.6801258757836315e+01
R634_667	634	667	3.0625924262616017e+01
R634_668	634	668	1.4057649203093195e+01
R634_684	634	684	2.5624147362595995e+01
R634_685	634	685	2.1941852237713260e+01
R634_686	634	686	8.8550497285418874e+00
R634_688	634	688	8.5734396195545539e+00
R635_636	635	636	2.4482874546902337e+01
R635_637	635	637	6.3957367062326355e+01
R635_638	635	638	1.4764222318152166e+01
R635_639	635	639	3.3133332023021005e+01
R635_688	635	688	2.8809732859096311e+01
R636_638	636	638	1.2359975054341390e+01
R636_663	636	663	1.1636903064680212e+01
R636_668	636	668	1.2446931162022961e+01
R636_684	636	684	7.1836830285785895e+00
R636_688	636	688	2.0356037793358496e+01
R637_638	637	638	4.5394109962699304e+01
R637_639	637	639	3.1088658717525753e+01
R637_641	637	641	3.3902476001649320e-07
R637_642	637	642	9.9504531394577046e-08
R637_683	637	683	3.9251850798249406e-07
R637_645	637	645	1.1940543528538401e-06
R637_685	637	685	4.7643633264875639e+01
R637_688	637	688	3.3804512649765819e+01
R638_662	638	662	7.5677560808265305e+00
R638_663	638	663	2.3502521229294540e+01
R638_683	638	683	1.5787879162666446e+01
R638_684	638	684	1.7813749991189361e+01
R638_688	638	688	1.4741397729422596e+01
R639_643	639	643	2.3641918990172385e+01
R639_685	639	685	1.4977185211681210e+01
R639_645	639	645	5.0986672119348221e+01
R639_688	639	688	1.5597677614238460e+01
R640_643	640	643	3.8542399569420496e+01
R640_644	640	644	3.9973335311002110e+01
R640_666	640	666	1.1881722176823397e+01
R640_667	640	667	1.3363694470700677e+01
R640_685	640	685	6.3767112905554512e+01
R640_686	640	686	2.6063636680406585e+01
R640_689	640	689	3.9858315185093645e+01
R641_642	641	642	3.3058146089942785e-07
R641_662	641	662	1.8202132201042360e-07
R641_682	641	682	4.4671316024471754e-07
R641_683	641	683	2.7749660137944471e-07
R641_691	641	691	3.7350741108162988e-07
R642_683	642	683	5.6247263527271185e-07
R642_645	642	645	1.4218992537070428e-06
R642_646	642	646	1.1375194029656332e-06
R642_691	642	691	1.1851989364133871e-06
R643_644	643	644	3.7462392553961813e+01
R643_685	643	685	1.6095833346284536e+01
R643_645	643	645	7.7517553323244371e+01
R643_689	643	689	4.8155005241323252e+01
R643_693	643	693	7.7384127506590104e+01
R644_666	644	666	4.0847938033394165e+01
R644_689	644	689	1.6076326763134805e+01
R644_693	644	693	1.0246066850431355e+02
R645_646	645	646	7.9207903078734408e-08
R645_683	645	683	2.3553383756461939e-07
R645_685	645	685	7.7360115318481775e+00
R645_690	645	690	2.8333438957447963e-07
R645_692	645	692	1.6292826067161664e-07
R645_693	645	693	4.7524741371993302e-07
R645_694	645	694	5.9405927309050909e-07
R646_683	646	683	3.0420713203687888e-07
R646_691	646	691	5.0965882531432387e-07
R646_692	646	692	1.9838272945543536e-07
R646_694	646	694	9.8036054016707870e-07
R647_648	647	648	2.1515654141236894e+01
R647_650	647	650	2.5289350357315875e+01
R647_654	647	654	4.6259444113038789e+01
R647_658	647	658	4.9572326594766459e+01
R647_660	647	660	1.9958170402944152e+01
R647_661	647	661	8.7863003498818006e+00
R647_663	647	663	2.6278661281943684e+01
R647_669	647	669	1.6945421117646625e+01
R647_671	647	671	4.1086065062024041e+01
R647_687	647	687	4.7497079837499548e+01
R647_695	647	695	3.3152273773414912e+01
R648_654	648	654	2.7531509641148851e+01
R648_661	648	661	8.5466348586320336e+01
R648_664	648	664	2.4212021598527624e+01
R648_671	648	671	4.5803433575768850e+01
R648_672	648	672	5.1347437322009206e+01
R648_673	648	673	2.1608263400710186e+01
R648_695	648	695	3.2493638073735362e+01
R649_653	649	653	3.1355359271148050e+01
R649_657	649	657	1.3043924924768622e-07
R649_675	649	675	8.5080595036208970e-07
R649_680	649	680	3.8405971480616242e-07
R649_696	649	696	7.8263549157293925e-07
R650_651	650	651	3.6322400919553424e+01
R650_653	650	653	2.3805860533454467e+01
R650_654	650	654	6.1267698117310800e+01
R650_660	650	660	1.6292809412896020e+01
R650_661	650	661	1.5706996691009987e+01
R650_675	650	675	5.4466421388047799e+01
R650_696	650	696	6.0464624109684870e+01
R650_697	650	697	4.0343636110158990e+01
R651_652	651	652	1.5636656321379855e+01
R651_653	651	653	1.9033503124643499e+01
R651_654	651	654	2.4506526492835924e+01
R651_697	651	697	2.9789221852667055e+01
R652_654	652	654	1.4104497471172481e+01
R652_655	652	655	3.3489750534160464e+01
R652_697	652	697	6.0471356263807422e+01
R653_675	653	675	3.2275802909033182e+01
R653_696	653	696	2.6490628176264998e+01
R653_697	653	697	5.0390517085793498e+01
R654_655	654	655	1.2452657921855046e+01
R654_661	654	661	7.6856915233000160e+00
R654_672	654	672	1.3827892711951568e+01
R654_695	654	695	2.3912565478281227e+01
R654_697	654	697	1.1734232906585731e+01
R654_698	654	698	1.0332253197546825e+01
R655_656	655	656	1.7768950029739919e+01
R655_672	655	672	6.5949479996066076e+00
R655_697	655	697	2.2600458656756366e+01
R655_698	655	698	1.4376052980313778e+01
R655_699	655	699	1.6879339645416895e+01
R655_700	655	700	2.6651913294892839e+01
R656_672	656	672	3.2444576627250726e+01
R656_674	656	674	2.8865906150731004e+01
R656_700	656	700	4.4725609793180745e+01
R657_680	657	680	3.0013000891080236e-07
R657_681	657	681	3.7468501844191960e-07
R657_696	657	696	6.2564558438165437e-07
R657_701	657	701	1.5015494025159680e-06
R658_659	658	659	1.3515827556261204e+01
R658_660	658	660	1.3449298836794730e+01
R658_663	658	663	1.3564029153085469e+01
R658_676	658	676	1.2549399476948823e+01
R658_702	658	702	2.9707509957802081e+01
R659_662	659	662	1.8514383069470336e-07
R659_663	659	663	1.7187604379565844e+01
R659_676	659	676	8.6948439687195365e-08
R659_677	659	677	9.0009578969209166e-09
R659_702	659	702	2.4563650901998363e-07
R660_661	660	661	8.8707159650974816e+00
R660_663	660	663	1.6900658778479148e+01
R660_669	660	669	8.4790584142115684e+00
R660_675	660	675	6.6947071814858177e+00
R660_676	660	676	1.2484453745942192e+01
R660_696	660	696	3.2737040198189561e+01
R660_702	660	702	6.2736973899482029e+00
R660_703	660	703	1.0601521105451054e+01
R661_669	661	669	2.4371934028937311e+01
R661_695	661	695	1.0397551262600190e+01
R661_696	661	696	8.3114275263931049e+01
R661_697	661	697	2.7525569873556719e+01
R661_698	661	698	1.8809655879803891e+01
R661_703	661	703	2.5583340020837795e+01
R662_663	662	663	1.8181764707504321e+01
R662_677	662	677	1.5229602272341365e-07
R662_682	662	682	7.2327587577582735e-08
R662_683	662	683	4.6472811162880262e-07
R662_684	662	684	4.6285743697598505e+01
R662_691	662	691	4.4080044374357454e-07
R662_702	662	702	4.4522557295428378e-07
R662_704	662	704	2.6068453986993225e-07
R663_669	663	669	2.7783390982513318e+01
R663_684	663	684	1.8581925819056721e+01
R663_687	663	687	1.4082725638690434e+01
R663_702	663	702	1.6133119698047373e+01
R663_704	663	704	3.3007060418240428e+01
R664_665	664	665	5.6982462499752849e+01
R664_667	664	667	7.2167627157865581e+01
R664_668	664	668	5.8399980880419470e+01
R664_670	664	670	5.6217179290793098e+01
R664_671	664	671	2.4644574830336950e+01
R664_673	664	673	4.3284829545211736e+01
R664_705	664	705	9.9793272309894334e+01
R665_667	665	667	1.0870828050099863e+01
R665_666	665	666	6.8541708141699885e+01
R665_670	665	670	3.8109138034005561e+01
R665_705	665	705	4.3321761018049628e+01
R666_667	666	667	8.0211366990552904e+00
R666_686	666	686	2.7182992091410750e+01
R666_689	666	689	1.7127651580530522e+01
R666_705	666	705	2.9198552170647208e+01
R667_668	667	668	2.5242045940542866e+01
R667_671	667	671	8.5296889486841110e+01
R667_686	667	686	3.3387111360569449e+01
R667_705	667	705	3.9227198797234038e+01
R667_706	667	706	7.3719199998171945e+01
R668_671	668	671	2.2969229240615643e+01
R668_684	668	684	1.7727969215520556e+01
R668_686	668	686	3.5831786912125224e+01
R668_706	668	706	4.1587700669709101e+01
R669_687	669	687	6.4460791075021664e+00
R669_671	669	671	2.7066370501446315e+01
R669_695	669	695	8.3489787267218247e+00
R669_702	669	702	1.6959137445346890e+01
R669_703	669	703	2.4610250676893546e+01
R669_707	669	707	2.0921790557970155e+01
R669_709	669	709	1.7368229451059857e+01
R670_673	670	673	1.6888070247817140e+01
R670_674	670	674	7.3065701057299719e+01
R670_705	670	705	6.5799466429607207e+01
R670_710	670	710	7.0906434616795138e+01
R671_673	671	673	1.1864155051595345e+01
R671_684	671	684	2.3062375203508193e+01
R671_687	671	687	7.6455936892661773e+00
R671_695	671	695	1.5805232383190241e+01
R671_705	671	705	2.9163528508990339e+01
R671_706	671	706	5.8313816139026908e+00
R671_707	671	707	7.3462070801928956e+00
R671_710	671	710	2.9786259648693161e+01
R671_711	671	711	3.3503481396780643e+01
R672_673	672	673	1.8729962973783547e+01
R672_674	672	674	1.9867001283369607e+01
R672_695	672	695	2.6036887027917409e+01
R672_698	672	698	1.9867001283369593e+01
R672_699	672	699	2.7751183450557601e+01
R672_700	672	700	3.0875812485090048e+01
R672_711	672	711	1.9050121902059036e+01
R672_712	672	712	2.2667752535635330e+01
R673_674	673	674	1.3290104321596313e+01
R673_695	673	695	1.9989110208651205e+01
R673_705	673	705	5.4788959005838393e+01
R673_710	673	710	1.0640797380732096e+01
R673_711	673	711	1.2277303146239120e+01
R673_712	673	712	3.4158662136770040e+01
R674_700	674	700	1.3713014492764788e+02
R674_710	674	710	1.4401850379686030e+02
R674_712	674	712	7.0787766674754948e+01
R675_676	675	676	1.6498457025779264e-07
R675_680	675	680	1.0656327204451616e-08
R675_696	675	696	5.9508377931821244e-07
R675_702	675	702	5.1199429949398718e-07
R675_703	675	703	3.6494486315444820e-07
R675_713	675	713	2.6605334421087397e-07
R676_677	676	677	1.2951638196587285e-07
R676_678	676	678	2.5297712111656594e-07
R676_679	676	679	1.8100479623982166e-07
R676_680	676	680	2.8517221879769694e-07
R676_702	676	702	2.8067854686737504e-07
R676_713	676	713	1.8453962186662240e-07
R677_678	677	678	2.6020293876465779e-08
R677_682	677	682	1.6989725351453916e-07
R677_702	677	702	2.5124225634460270e-07
R677_713	677	713	2.8760813260708844e-07
R678_679	678	679	1.3113752299969349e-07
R678_682	678	682	3.1480705404653695e-07
R678_713	678	713	2.5435327069508434e-07
R679_680	679	680	3.2624663476348015e-07
R679_681	679	681	1.0166520362584317e-06
R679_713	679	713	6.6722574513726608e-07
R680_681	680	681	5.1931400883769883e-08
R680_696	680	696	5.6692920120746428e-07
R680_703	680	703	9.0889076891171499e-07
R680_713	680	713	4.7088560321437190e-07
R680_714	680	714	9.2008414539077660e-07
R681_696	681	696	8.7116248391635654e-07
R681_701	681	701	1.2870131199631853e-06
R681_713	681	713	1.6972720250959596e-06
R681_714	681	714	1.1354768129167263e-06
R682_691	682	691	7.5230448234865468e-07
R682_702	682	702	5.2499096080583229e-07
R682_704	682	704	4.6643067458104193e-07
R682_713	682	713	7.4164240430761622e-07
R682_715	682	715	3.8398085408351512e-07
R683_684	683	684	3.1677020476963317e+01
R683_685	683	685	2.1467778300798638e+01
R683_688	683	688	1.5534140610477097e+01
R683_690	683	690	6.2296072209763446e-07
R683_691	683	691	5.9881565827697544e-08
R683_692	683	692	3.4031131263885835e-07
R683_704	683	704	6.5316020271761573e-07
R683_716	683	716	5.6108729934794419e-07
R684_686	684	686	2.2061590763215179e+01
R684_687	684	687	1.6058735510457012e+01
R684_688	684	688	1.9316555669170494e+01
R684_704	684	704	3.0629965851178827e+01
R684_706	684	706	2.6365347494487718e+01
R684_716	684	716	3.9918359087414160e+01
R685_686	685	686	1.8850907762271031e+01
R685_688	685	688	1.3591984280042201e+01
R685_689	685	689	3.8593812495974369e+01
R685_690	685	690	1.2774010777792787e+01
R685_693	685	693	7.9944068275495326e+01
R685_708	685	708	2.8951757675768452e+01
R685_716	685	716	5.4765747217958271e+01
R686_688	686	688	3.1501723441401978e+01
R686_689	686	689	6.0091277404212981e+01
R686_705	686	705	6.4956207482529251e+01
R686_706	686	706	2.5776043198684700e+01
R686_708	686	708	2.5547903697027166e+01
R686_716	686	716	6.6927071893349037e+01
R687_702	687	702	4.3579574690564236e+01
R687_704	687	704	1.9270198806647130e+01
R687_706	687	706	2.7790897810708778e+01
R687_707	687	707	1.2849242703739311e+01
R687_709	687	709	2.5325831533873394e+01
R687_716	687	716	4.0317966584617650e+01
R688_716	688	716	6.4539977716979550e+01
R689_690	689	690	7.0591888926365272e+01
R689_693	689	693	6.9398279928266930e+01
R689_705	689	705	7.9313579817491899e+01
R689_708	689	708	2.3820908196901563e+01
R689_717	689	717	6.5815774759817643e+01
R690_692	690	692	1.2519846290218608e-07
R690_693	690	693	1.1349962264502285e-06
R690_708	690	708	2.3000331568567468e+01
R690_716	690	716	7.6544019684713070e-07
R690_717	690	717	6.5702461136308442e-07
R691_692	691	692	7.5350353168983662e-07
R691_704	691	704	4.7741684581969240e-07
R691_715	691	715	1.1967147741537428e-06
R691_716	691	716	8.8894722843798134e-07
R691_718	691	718	9.9415265766351738e-07
R692_693	692	693	3.3316724573769563e-07
R692_694	692	694	4.3362360028049445e-07
R692_716	692	716	2.0969105518847413e-07
R692_717	692	717	2.7628581933973096e-07
R692_718	692	718	5.2307388427665911e-07
R692_719	692	719	1.8504446237798219e-07
R693_694	693	694	2.3652424355962870e-07
R693_717	693	717	9.4609696950803072e-07
R693_719	693	719	1.1826212177981436e-06
R694_719	694	719	1.4527063720083982e-06
R695_698	695	698	1.4924005381772806e+01
R695_703	695	703	3.6331363568445390e+01
R695_707	695	707	2.8476642633227204e+01
R695_709	695	709	3.0941725051040631e+01
R695_711	695	711	6.1710943713574524e+00
R695_720	695	720	4.0954733690131008e+01
R696_697	696	697	3.2979033032662237e+01
R696_701	696	701	1.0613586509935309e-07
R696_703	696	703	3.5277564635478716e-07
R696_714	696	714	2.5045872315176248e-07
R696_721	696	721	6.3681518741203941e-07
R697_698	697	698	1.8825834718499991e+01
R697_699	697	699	1.2321635246553774e+02
R697_703	697	703	1.0257136503443179e+02
R697_721	697	721	1.0302113546487932e+02
R698_699	698	699	1.2781723376057919e+01
R698_703	698	703	3.4486075732725112e+01
R698_711	698	711	3.0809029182527642e+01
R698_720	698	720	2.9535039025479776e+01
R698_721	698	721	3.7726461563118043e+01
R699_700	699	700	2.1506292148814193e+01
R699_711	699	711	3.4315971565984093e+01
R699_712	699	712	2.0776418047917801e+01
R699_720	699	720	2.2769453312670393e+01
R699_721	699	721	2.3901375115901864e+01
R699_722	699	722	3.4196752714454604e+01
R700_712	700	712	4.6302729982702068e+01
R700_722	700	722	2.4995095864834545e+02
R701_714	701	714	3.9669635221147543e-07
R701_721	701	721	1.0143994727711701e-06
R701_723	701	723	1.6230391564338720e-06
R702_703	702	703	6.7795470856809392e-07
R702_704	702	704	3.8229515263831621e-07
R702_709	702	709	1.2186262625476458e-06
R702_713	702	713	9.3311596916371037e-08
R702_715	702	715	4.8330536877805120e-07
R702_724	702	724	5.0015709864117568e-07
R703_709	703	709	9.0009827943451940e-07
R703_713	703	713	3.7712563346160514e-07
R703_714	703	714	7.6091901976515197e-08
R703_720	703	720	3.5214087945664381e-07
R703_721	703	721	7.5452201110149726e-07
R703_724	703	724	3.6047279757181948e-07
R704_709	704	709	5.8662586420317095e-07
R704_715	704	715	7.2143858485348160e-08
R704_716	704	716	2.1690642753595021e-07
R704_718	704	718	2.8740995916510908e-07
R704_724	704	724	2.5602571179424633e-07
R705_706	705	706	1.0706094365483846e+01
R705_708	705	708	1.8753278276898946e+01
R705_710	705	710	3.6290040350458113e+01
R705_717	705	717	7.9151839996023540e+01
R705_725	705	725	4.8667847692466005e+01
R706_707	706	707	1.0520932192723977e+01
R706_708	706	708	1.9368989002076031e+01
R706_710	706	710	4.2398611136275825e+01
R706_716	706	716	1.3853827822186997e+01
R706_725	706	725	3.0080219926266885e+01
R707_709	707	709	9.4954030121484010e+00
R707_710	707	710	2.8986939453246720e+01
R707_711	707	711	2.9717283868144300e+01
R707_716	707	716	4.4390539633569475e+01
R707_725	707	725	4.4053089947652012e+01
R708_716	708	716	1.2438809332034591e+01
R708_717	708	717	1.2674900661408351e+01
R708_725	708	725	5.2520295453999402e+01
R709_711	709	711	3.2658099825042321e+01
R709_710	709	710	7.1768369941522892e+01
R709_716	709	716	1.1261676789582930e-06
R709_720	709	720	8.6937658335474657e-07
R709_724	709	724	2.0503275551050307e-08
R709_725	709	725	1.1057630600037906e-06
R709_726	709	726	1.2080999923438474e-06
R710_711	710	711	1.3723218129373635e+01
R710_712	710	712	3.3200383461921270e+01
R710_725	710	725	3.4049876419423008e+01
R710_726	710	726	3.7278048021872486e+01
R711_712	711	712	2.5049307487223992e+01
R711_720	711	720	2.7781328951886902e+01
R711_726	711	726	5.5607113494218794e+01
R712_720	712	720	3.5610241012492821e+01
R712_722	712	722	4.1690074989920348e+01
R712_726	712	726	2.6281359542750991e+01
R713_714	713	714	2.9156319771988812e-07
R713_715	713	715	3.2692707833980825e-07
R713_724	713	724	3.2609107366086522e-07
R713_728	713	728	8.0184301734765850e-07
R714_721	714	721	4.4346423671858441e-07
R714_720	714	720	3.7106439087996382e-07
R714_723	714	723	5.5568432762022265e-07
R714_724	714	724	4.8777145147881820e-07
R714_727	714	727	5.3095610460095409e-07
R714_728	714	728	1.0445457859442940e-06
R715_718	715	718	3.0046908757651054e-07
R715_724	715	724	2.4971729801440452e-07
R715_728	715	728	6.7249627667851221e-07
R716_717	716	717	5.8569093113025979e-07
R716_718	716	718	1.3746676918052152e-07
R716_719	716	719	7.8846169538070522e-07
R716_724	716	724	7.2233647357684597e-07
R716_725	716	725	8.4250011775351784e-07
R716_729	716	729	6.6771668644970392e-07
R717_719	717	719	3.2615971378828906e-07
R717_725	717	725	3.9139164871811415e-06
R717_729	717	729	2.4461978534121668e-06
R718_719	718	719	1.3787474722050435e-06
R718_724	718	724	6.7235275024855253e-07
R718_728	718	728	1.8166932039995663e-06
R718_729	718	729	8.4000081941925570e-07
R719_729	719	729	9.7896256134440603e-07
R720_721	720	721	3.5830766104013144e-07
R720_722	720	722	1.3756226687512179e-06
R720_723	720	723	5.2818734376661830e-07
R720_724	720	724	4.3300085149731315e-07
R720_726	720	726	4.4461855044896134e-07
R720_727	720	727	1.4062268281483094e-07
R720_730	720	730	6.8615281978556667e-07
R721_722	721	722	1.8398328144850070e-06
R721_723	721	723	1.5331940274027792e-07
R721_730	721	730	1.1498955205520845e-06
R722_726	722	726	1.3636370445449184e-06
R722_730	722	730	1.7045463227266116e-07
R723_727	723	727	3.1041313973476539e-07
R723_730	723	730	6.1337013167721289e-07
R724_725	724	725	2.7852214870106883e-07
R724_726	724	726	2.8938633053070691e-07
R724_727	724	727	2.3232482855579684e-07
R724_728	724	728	1.2398072007779951e-08
R724_729	724	729	2.7852214870106920e-07
R724_731	724	731	2.8938633053070680e-07
R725_726	725	726	9.5702270730862874e-07
R725_729	725	729	1.5950378534895720e-07
R725_731	725	731	1.1962783901171777e-06
R726_727	726	727	4.1025154352046214e-07
R726_730	726	730	8.2307110919382043e-07
R726_731	726	731	1.6461422183876376e-07
R727_728	727	728	4.7927195450609046e-07
R727_730	727	730	3.7230195176101061e-07
R727_731	727	731	2.5872456298829820e-07
R728_729	728	729	8.6742806522218490e-07
R728_731	728	731	7.8125395448890136e-07
R729_731	729	731	8.1379429927753364e-07
R730_731	730	731	1.4972600526841500e-06
.control
quit 13

.endc
.end
.END
