Simul16-Dec-2025_13-16-58.cir
********************************************************************************
*
*                        Spice Netlist Generated by
*
*                              BIOCAD Program
*                               Release 1.0
*
*   Authors: Vincent Senez
*
*   Release 1.0 : January 2019
*
********************************************************************************
.CONTROL
  DESTROY ALL
  AC DEC 9.000000 1000.000000 10000000000.000000
  WRITE Simul16-Dec-2025_13-16-58.spi vdb(671,15)-vdb(15)-66 vp(671,15)-vp(15)
  DESTROY ALL
  AC DEC 1 1000.000000 1000.000000
  WRITE Simul16-Dec-2025_13-16-58_1000Hz.spi_cou all
  DESTROY ALL
  AC DEC 1 50000000.000000 50000000.000000
  WRITE Simul16-Dec-2025_13-16-58_50000000Hz.spi_cou all
  DESTROY ALL
  AC DEC 1 10000000000.000000 10000000000.000000
  WRITE Simul16-Dec-2025_13-16-58_10000000000Hz.spi_cou all
.ENDC
Vin	671	0	DC 0 AC 0.025000
Rg	15	0	50e-5
R1_6	1	6	1.2080234219841790e-05
C1_6	1	6	7.3294835645297276e-12
R1_3	1	3	1.9468021932516920e-05
C1_3	1	3	4.5480675169217297e-12
R1_4	1	4	1.0859742061210775e-05
C1_4	1	4	8.1532211051547106e-12
R1_7	1	7	2.4335027415646156e-05
C1_7	1	7	3.6384540135373834e-12
R1_9	1	9	3.2446703220861532e-06
C1_9	1	9	2.7288405101530378e-11
R1_2	1	2	3.8936043865033785e-05
C1_2	1	2	2.2740337584608681e-12
R2_9	2	9	2.7754685324205268e-05
C2_9	2	9	3.1901596842382972e-12
R2_4	2	4	8.9399107627443171e-06
C2_4	2	4	9.9041120789465214e-12
R2_19	2	19	3.7006247098940398e-06
C2_19	2	19	2.3926197631787204e-11
R2_13	2	13	4.4407496518728547e-05
C2_13	2	13	1.9938498026489307e-12
R2_12	2	12	2.4422866868400488e-05
C2_12	2	12	3.6253679245395984e-12
R3_6	3	6	1.0226673316126184e-06
C3_6	3	6	8.6579355214545211e-11
R3_4	3	4	1.0949714279700219e-05
C3_4	3	4	8.0862272666007939e-12
R3_5	3	5	1.7044521534670751e-05
C3_5	3	5	5.1947411952805142e-12
R3_7	3	7	5.6441035722043803e-06
C3_7	3	7	1.5687500599039997e-11
R3_23	3	23	2.2576414288817521e-05
C3_23	3	23	3.9218751497599992e-12
R3_25	3	25	2.8220517861021901e-05
C3_25	3	25	3.1375001198079993e-12
R4_6	4	6	2.3619263661606744e-06
C4_6	4	6	3.7487145847787521e-11
R4_5	4	5	6.2739315161192001e-06
C4_5	4	5	1.4112662521501099e-11
R4_8	4	8	1.8935802862529262e-06
C4_8	4	8	4.6758977590123386e-11
R4_9	4	9	7.8411563043783437e-06
C4_9	4	9	1.1291941485793364e-11
R4_19	4	19	6.1614952437383129e-06
C4_19	4	19	1.4370193381222140e-11
R4_12	4	12	9.4133191796874964e-06
C4_12	4	12	9.4060210303991235e-12
R4_32	4	32	1.0671032584764309e-05
C4_32	4	32	8.2974049106003755e-12
R5_6	5	6	3.4278906272563111e-06
C5_6	5	6	2.5829843422066551e-11
R5_8	5	8	7.1853961666608574e-06
C5_8	5	8	1.2322476884548248e-11
R5_23	5	23	9.2147920286354837e-06
C5_23	5	23	9.6086680952593566e-12
R5_32	5	32	8.8635256870985299e-06
C5_32	5	32	9.9894648355201118e-12
R5_12	5	12	1.6385199709060314e-05
C5_12	5	12	5.4037716806735129e-12
R5_21	5	21	1.2659850421140132e-05
C5_21	5	21	6.9939118729355449e-12
R5_33	5	33	1.5683349018234185e-06
C5_33	5	33	5.6455976377913381e-11
R5_22	5	22	1.6882070876620330e-05
C5_22	5	22	5.2447284943353730e-12
R6_7	6	7	1.0226673316126184e-06
C6_7	6	7	8.6579355214545211e-11
R6_8	6	8	2.5312111605494481e-06
C6_8	6	8	3.4980044158299413e-11
R6_9	6	9	1.4009043825740077e-05
C6_9	6	9	6.3203370102471970e-12
R6_23	6	23	1.1635372457915299e-05
C6_23	6	23	7.6097158462483781e-12
R6_25	6	25	1.1635372457915299e-05
C6_25	6	25	7.6097158462483781e-12
R6_33	6	33	4.5101545300918485e-06
C6_33	6	33	1.9631672834987508e-11
R7_9	7	9	1.2788309342237576e-05
C7_9	7	9	4.1541946987452302e-11
R7_8	7	8	5.9518158933285534e-06
C7_8	7	8	2.3802316368403697e-10
R7_25	7	25	1.2788309342237576e-05
C7_25	7	25	4.1541946987452296e-11
R7_33	7	33	1.0076214188341908e-05
C7_33	7	33	1.4059546791235045e-10
R7_26	7	26	6.1372628940077147e+03
C7_26	7	26	1.4426932608093148e-10
R7_34	7	34	7.2579125349457418e+03
C7_34	7	34	1.2199358664586322e-10
R7_35	7	35	4.6394992963870591e+03
C7_35	7	35	1.9084360728096384e-10
R8_9	8	9	6.1061461207614473e-06
C8_9	8	9	1.5950497083331915e-10
R8_19	8	19	6.5522148487049993e-06
C8_19	8	19	2.1621239249732332e-10
R8_32	8	32	4.8698860786700271e-06
C8_32	8	32	1.9999660015908000e-10
R8_33	8	33	3.5970554779482115e-06
C8_33	8	33	1.8871576201117073e-10
R8_34	8	34	2.1692898940925793e+03
C8_34	8	34	4.0816065391314308e-10
R8_35	8	35	3.0601804564645513e+03
C8_35	8	35	2.8933548014450461e-10
R8_36	8	36	2.0488433892976336e+03
C8_36	8	36	4.3215542306702695e-10
R8_37	8	37	4.7873177893818583e+03
C8_37	8	37	1.8495091001976831e-10
R9_19	9	19	1.2109408024120366e-05
C9_19	9	19	4.3870952873682264e-11
R9_35	9	35	6.9627739220387812e+03
C9_35	9	35	1.2716466046634745e-10
R9_37	9	37	6.9451914338860361e+03
C9_37	9	37	1.2748659128098110e-10
R9_38	9	38	2.4218816060350175e+04
C9_38	9	38	3.6559127394735171e-11
R10_39	10	39	7.7322449131047990e-07
C10_39	10	39	1.1450992456270629e-10
R10_24	10	24	2.4847176286056367e-06
C10_24	10	24	3.5634583644696711e-11
R10_22	10	22	5.3238757740762910e-06
C10_22	10	22	1.6631093948724285e-11
R10_28	10	28	6.1258990142493200e-06
C10_28	10	28	1.4453695361945191e-11
R10_40	10	40	3.2571897606868273e-06
C10_40	10	40	2.7183518516074920e-11
R10_11	10	11	6.9436286027082060e-06
C10_11	10	11	1.2751528521480286e-11
R10_43	10	43	4.4294717740925231e-06
C10_43	10	43	1.9989263434947568e-11
R11_43	11	43	2.2193778886840432e-06
C11_43	11	43	3.9894908668527817e-11
R11_24	11	24	1.7755023109472346e-05
C11_24	11	24	4.9868635835659771e-12
R11_40	11	40	1.7755023109472322e-05
C11_40	11	40	4.9868635835659836e-12
R12_19	12	19	3.4374550125041972e-06
C12_19	12	19	2.5757974387422448e-11
R12_13	12	13	5.0075953773978511e-06
C12_13	12	13	1.7681516076486583e-11
R12_32	12	32	4.6757645483345486e-07
C12_32	12	32	1.8936342336043751e-10
R12_16	12	16	4.2827362496208728e-06
C12_16	12	16	2.0674137516135423e-11
R12_20	12	20	5.4688720259808429e-06
C12_20	12	20	1.6190153609257294e-11
R12_21	12	21	7.3925451747279246e-06
C12_21	12	21	1.1977184593026002e-11
R12_48	12	48	4.5514370603489610e-06
C12_48	12	48	1.9453609265819764e-11
R13_19	13	19	1.1153175482764277e-05
C13_19	13	19	7.9387147011924520e-12
R13_48	13	48	1.4870900643685687e-06
C13_48	13	48	5.9540360258943459e-11
R13_16	13	16	7.3219470593384979e-06
C13_16	13	16	1.2092668446307958e-11
R13_18	13	18	1.7845080772422828e-05
C13_18	13	18	4.9616966882452880e-12
R14_29	14	29	5.2334227386368790e-07
C14_29	14	29	1.6918541190322804e-10
R14_21	14	21	1.0835034436056717e-05
C14_21	14	21	8.1718132685717403e-12
R14_20	14	20	3.3597045855990173e-06
C14_20	14	20	2.6354066529993275e-11
R14_15	14	15	6.5296694082190388e-07
C14_15	14	15	1.3559932767583976e-10
R14_30	14	30	3.6123028261072051e-06
C14_30	14	30	2.4511200315234114e-11
R14_46	14	46	5.4497515410297920e-06
C14_46	14	46	1.6246956857278858e-11
R14_50	14	50	1.3447670229733682e-06
C14_50	14	50	6.5841797618020187e-11
R14_52	14	52	8.9294896175665597e-06
C14_52	14	52	9.9156706555563691e-12
R15_29	15	29	6.0382756708747488e-07
C15_29	15	29	1.4663437543449082e-10
R15_20	15	20	3.6170202931251716e-06
C15_20	15	20	2.4479231797037612e-11
R15_17	15	17	3.3349771448263585e-06
C15_17	15	17	2.6549470753452517e-11
R15_31	15	31	3.6087542969725644e-06
C15_31	15	31	2.4535302457216066e-11
R15_44	15	44	8.5408064124377225e-07
C15_44	15	44	1.0366922500556750e-10
R15_46	15	46	3.7763643045022868e-06
C15_46	15	46	2.3446328539976376e-11
R15_50	15	50	7.7212656276426649e-07
C15_50	15	50	1.1467275242159001e-10
R15_55	15	55	3.7607681982031186e-06
C15_55	15	55	2.3543561714945630e-11
R16_17	16	17	5.7064610585795157e-06
C16_17	16	17	1.5516075070183749e-11
R16_20	16	20	6.5497415198201647e-06
C16_20	16	20	1.3518377466051680e-11
R16_31	16	31	9.0075628434428889e-06
C16_31	16	31	9.8297263875826994e-12
R16_32	16	32	1.0304757608928495e-05
C16_32	16	32	8.5923300217448516e-12
R16_46	16	46	1.2296197643442798e-05
C16_46	16	46	7.2007526828602005e-12
R16_48	16	48	9.6682354102940038e-06
C16_48	16	48	9.1580184400275692e-12
R16_18	16	18	1.3791907093274392e-05
C16_18	16	18	6.4198429971426746e-12
R16_56	16	56	1.6310865852553708e-06
C16_56	16	56	5.4283984044990138e-11
R16_47	16	47	2.2553269098180610e-05
C16_47	16	47	3.9258999564343751e-12
R17_20	17	20	2.3443769696580020e-06
C17_20	17	20	3.7767764875678882e-11
R17_31	17	31	2.0062215912865106e-06
C17_31	17	31	4.4133648324072510e-11
R17_46	17	46	2.6746272814445038e-06
C17_46	17	46	3.3104380107190338e-11
R17_55	17	55	4.0895446461817588e-06
C17_55	17	55	2.1650791428006034e-11
R17_56	17	56	8.0419098906746424e-06
C17_56	17	56	1.1010055990887529e-11
R18_48	18	48	7.2847050902790394e-05
C18_48	18	48	1.2154490411444842e-12
R18_56	18	56	4.9002085430378439e-05
C18_56	18	56	1.8069002041923137e-12
R18_47	18	47	5.4984132380980548e-05
C18_47	18	47	1.6103169102769612e-12
R18_59	18	59	1.4569410180558075e-05
C18_59	18	59	6.0772452057224220e-12
R18_57	18	57	1.7483292216669691e-04
C18_57	18	57	5.0643710047686857e-13
R19_32	19	32	2.4912066686440720e-05
C19_32	19	32	2.7248685308269716e-11
R19_36	19	36	6.9662869356898491e+03
C19_36	19	36	1.2710053287696223e-10
R19_37	19	37	1.1927876658406174e+04
C19_37	19	37	7.4231047742768281e-11
R19_48	19	48	2.9690047254611203e-05
C19_48	19	48	3.2804281197119759e-11
R19_63	19	63	3.0923008387019883e+04
C19_63	19	63	2.8633009137353532e-11
R20_29	20	29	5.9982642212397700e-06
C20_29	20	29	1.4761250072391681e-11
R20_21	20	21	1.1635648623835717e-05
C20_21	20	21	7.6095352336973542e-12
R20_31	20	31	3.0407370299450786e-06
C20_31	20	31	2.9118558197582526e-11
R20_32	20	32	1.3972580525827069e-05
C20_32	20	32	6.3368307669680797e-12
R20_46	20	46	1.2320015706860877e-05
C20_46	20	46	7.1868315980061648e-12
R20_69	20	69	1.5822206662847766e-05
C20_69	20	69	5.5960511739431278e-12
R21_29	21	29	7.5231086879236868e-06
C21_29	21	29	1.1769320615044416e-11
R21_30	21	30	1.2654281620595290e-05
C21_30	21	30	6.9969897007740818e-12
R21_32	21	32	1.4969854396018850e-05
C21_32	21	32	5.9146786486812609e-12
R21_33	21	33	1.4413611608494001e-05
C21_33	21	33	6.1429349267203713e-12
R21_22	21	22	1.8796136195307346e-05
C21_22	21	22	4.7106425091825756e-12
R21_69	21	69	2.0725089801060630e-06
C21_69	21	69	4.2722072145361111e-11
R21_28	21	28	2.1517713277440995e-05
C21_28	21	28	4.1148367871797341e-12
R21_70	21	70	1.7456564417813621e-05
C21_70	21	70	5.0721250786120939e-12
R22_33	22	33	2.1361899296584124e-05
C22_33	22	33	4.1448504620634687e-12
R22_23	22	23	1.8807925021166145e-05
C22_23	22	23	4.7076898738354364e-12
R22_39	22	39	1.7694980927306844e-05
C22_39	22	39	5.0037848887060640e-12
R22_24	22	24	2.1030478117833878e-05
C22_24	22	24	4.2101695298556408e-12
R22_28	22	28	2.7529825509394305e-05
C22_28	22	28	3.2162164682004940e-12
R22_70	22	70	3.4050833099981285e-06
C22_70	22	70	2.6002852238598731e-11
R23_25	23	25	1.0505590188562998e-06
C23_25	23	25	8.4280727289735602e-11
R23_33	23	33	3.0743535143444437e-06
C23_33	23	33	2.8800161645977832e-11
R23_70	23	70	3.4412658496361735e-06
C23_70	23	70	2.5729450161300688e-11
R23_27	23	27	1.0505590188562999e-05
C23_27	23	27	8.4280727289735592e-12
R23_24	23	24	8.4044721508503988e-06
C23_24	23	24	1.0535090911216950e-11
R24_39	24	39	2.8521218860498125e-06
C24_39	24	39	3.1044212592411496e-11
R24_43	24	43	7.9967202633772350e-06
C24_43	24	43	1.1072274039082909e-11
R24_27	24	27	1.5993440526754465e-06
C24_27	24	27	5.5361370195414549e-11
R24_70	24	70	4.9492130597389389e-06
C24_70	24	70	1.7890092243204100e-11
R25_33	25	33	3.9363526249867792e-06
C25_33	25	33	2.4742718747137415e-10
R25_26	25	26	5.0109117537506490e+03
C25_26	25	26	1.7669813902375499e-10
R25_70	25	70	6.8743299064323487e-06
C25_70	25	70	2.0608118433033151e-10
R25_27	25	27	1.7771362741855270e-05
C25_27	25	27	1.0462784789553668e-10
R25_65	25	65	5.9402300479693049e+03
C25_65	25	65	1.4905462828037856e-10
R25_71	25	71	3.1372774808184859e+03
C25_71	25	71	2.8222520548899703e-10
R25_74	25	74	6.2827271769046356e+03
C25_74	25	74	1.4092905147223452e-10
R26_33	26	33	3.9903064441235201e+03
C26_33	26	33	2.2189242708512938e-10
R26_34	26	34	2.4069932156720988e+03
C26_34	26	34	3.6785262872158405e-10
R26_35	26	35	3.1935237423085036e+03
C26_35	26	35	2.7725448537293704e-10
R26_67	26	67	2.0974656299975873e+03
C26_67	26	67	4.2213744484624464e-10
R26_60	26	60	7.7309934695927550e+03
C26_60	26	60	1.1452846069298791e-10
R26_68	26	68	3.3814460878023674e+03
C26_68	26	68	2.6184619204603136e-10
R26_71	26	71	1.8586176010025738e+03
C26_71	26	71	4.7638566492773364e-10
R26_74	26	74	9.1080310785820602e+03
C26_74	26	74	9.7212973260719532e-11
R27_43	27	43	1.7844909351449661e-05
C27_43	27	43	1.0419663116418084e-10
R27_39	27	39	4.3991689785855031e-06
C27_39	27	39	2.2139651003112959e-10
R27_65	27	65	1.1796656648425308e+03
C27_65	27	65	7.5056756171520120e-10
R27_70	27	70	4.6486520630480127e-06
C27_70	27	70	1.4602535451370507e-10
R27_72	27	72	6.0018340975023957e+03
C27_72	27	72	1.4752470116900739e-10
R27_74	27	74	9.4578052121438286e+03
C27_74	27	74	9.3617785716618660e-11
R28_39	28	39	2.7268517883103399e-06
C28_39	28	39	3.2470366944609004e-11
R28_40	28	40	5.1028956100596513e-06
C28_40	28	40	1.7351301091766795e-11
R28_42	28	42	4.9043274597290446e-07
C28_42	28	42	1.8053826726915128e-10
R28_41	28	41	7.6406046778607609e-06
C28_41	28	41	1.1588333895425439e-11
R28_45	28	45	4.1818581383465408e-06
C28_45	28	45	2.1172855520395162e-11
R28_69	28	69	3.6317481968211144e-06
C28_69	28	69	2.4379960661232272e-11
R28_30	28	30	3.4287747735177467e-06
C28_30	28	30	2.5823182920574454e-11
R28_70	28	70	3.2364106637786086e-06
C28_70	28	70	2.7358047963735433e-11
R28_75	28	75	3.5323276804942375e-06
C28_75	28	75	2.5066156421142499e-11
R29_30	29	30	8.8295734736083341e-07
C29_30	29	30	1.0027877160165479e-10
R29_31	29	31	1.8264220591637694e-06
C29_31	29	31	4.8478322809208205e-11
R29_44	29	44	2.9871854345003313e-07
C29_44	29	44	2.9640569730754079e-10
R29_50	29	50	6.9696668232500094e-07
C29_50	29	50	1.2703889642849847e-10
R29_69	29	69	1.3262399068538336e-06
C29_69	29	69	6.6761584923230881e-11
R29_75	29	75	1.2100086422709964e-06
C29_75	29	75	7.3174583285472056e-11
R30_50	30	50	1.5052086452521318e-06
C30_50	30	50	5.8823657736279261e-11
R30_52	30	52	5.3779134748813219e-06
C30_52	30	52	1.6463983398683057e-11
R30_45	30	45	2.7643967062955589e-06
C30_45	30	45	3.2029367553635565e-11
R30_69	30	69	3.6086854211612681e-06
C30_69	30	69	2.4535770740999470e-11
R30_75	30	75	8.7135538469364775e-07
C30_75	30	75	1.0161396799209506e-10
R31_32	31	32	2.9275904826608137e-06
C31_32	31	32	2.3187022554482728e-10
R31_44	31	44	1.3130908983954159e-06
C31_44	31	44	5.1696426069738615e-10
R31_55	31	55	2.0208629288095206e-06
C31_55	31	55	3.3590653568836678e-10
R31_56	31	56	2.2645782715158151e-06
C31_56	31	56	2.9975606233432502e-10
R31_69	31	69	2.6639943072363201e-06
C31_69	31	69	2.5481325679771255e-10
R31_81	31	81	2.5992932658079275e+02
C31_81	31	81	3.4063827785311063e-09
R32_33	32	33	7.7741444443217875e-06
C32_33	32	33	1.2528203789774159e-10
R32_34	32	34	4.0467189635001032e+03
C32_34	32	34	2.1879917772549749e-10
R32_36	32	36	1.9803630087304473e+03
C32_36	32	36	4.4709923271472138e-10
R32_48	32	48	8.9609447170990702e-06
C32_48	32	48	1.0868950647999757e-10
R32_49	32	49	2.5198738630218477e+03
C32_49	32	49	3.5137424721656527e-10
R32_56	32	56	1.1101166155722137e-05
C32_56	32	56	1.2761452524199606e-10
R32_69	32	69	8.3506053947651054e-06
C32_69	32	69	1.1663353886972120e-10
R32_81	32	81	2.7129467858368012e+03
C32_81	32	81	3.2636791341518889e-10
R32_82	32	82	3.1574945780295984e+03
C32_82	32	82	2.8041814793947689e-10
R32_84	32	84	3.7703354728559534e+03
C32_84	32	84	2.3483819624923537e-10
R33_34	33	34	1.0239662774426766e+03
C33_34	33	34	8.6469525530792437e-10
R33_69	33	69	7.8990491648159444e-06
C33_69	33	69	2.3539281742077449e-10
R33_70	33	70	3.1252662929975419e-06
C33_70	33	70	1.6998592086206982e-10
R33_71	33	71	1.2384516291209045e+03
C33_71	33	71	7.1494014047888248e-10
R33_82	33	82	4.8700403554826853e+03
C33_82	33	82	1.8180933155989084e-10
R33_85	33	85	4.5828443494859248e+03
C33_85	33	85	1.9320289195493205e-10
R34_35	34	35	3.1159855173529636e+03
C34_35	34	35	2.8415368966546582e-10
R34_36	34	36	2.0987923535960726e+03
C34_36	34	36	4.2187059628977716e-10
R34_67	34	67	2.4424209813856828e+03
C34_67	34	67	3.6251685866114152e-10
R34_71	34	71	2.1615911234395894e+03
C34_71	34	71	4.0961436790649606e-10
R34_82	34	82	4.5912824999889608e+03
C34_82	34	82	1.9284781141263447e-10
R34_84	34	84	4.4192529159394653e+03
C34_84	34	84	2.0035485602248535e-10
R34_85	34	85	1.8870990679194617e+03
C34_85	34	85	4.6919570718466815e-10
R34_86	34	86	1.7973105629338863e+03
C34_86	34	86	4.9263538531407932e-10
R35_36	35	36	1.3802854706869046e+04
C35_36	35	36	6.4147511547692230e-11
R35_37	35	37	6.3002461793365437e+03
C35_37	35	37	1.4053717211939815e-10
R35_38	35	38	5.2525826303375388e+03
C35_38	35	38	1.6856827279328335e-10
R35_60	35	60	9.4978881807566613e+03
C35_60	35	60	9.3222700125478010e-11
R35_62	35	62	1.5593302294560037e+04
C35_62	35	62	5.6781992997653370e-11
R35_67	35	67	8.6196147687953398e+03
C35_67	35	67	1.0272138668022454e-10
R35_86	35	86	8.6857694160249139e+03
C35_86	35	86	1.0193901533541014e-10
R36_37	36	37	6.2987612319664158e+03
C36_37	36	37	1.4057030407923251e-10
R36_48	36	48	1.4117556761523001e+04
C36_48	36	48	6.2717564848981792e-11
R36_49	36	49	9.2121781664027458e+03
C36_49	36	49	9.6113944574928531e-11
R36_63	36	63	4.5065053658549850e+03
C36_63	36	63	1.9647569675799473e-10
R36_84	36	84	7.0152289107898905e+03
C36_84	36	84	1.2621381183130988e-10
R36_86	36	86	6.4717343543770776e+03
C36_86	36	86	1.3681321469895593e-10
R37_38	37	38	5.7812041560760690e+03
C37_38	37	38	1.5315473347700778e-10
R37_63	37	63	9.1794680379092042e+03
C37_63	37	63	9.6456437131586858e-11
R37_86	37	86	8.6733329081044358e+03
C37_86	37	86	1.0208518352531555e-10
R37_64	37	64	1.1883291417676077e+04
C37_64	37	64	7.4509557207606920e-11
R38_60	38	60	6.0030230029520635e+03
C38_60	38	60	1.4749548373620824e-10
R38_62	38	62	3.3693097265563483e+03
C38_62	38	62	2.6278937039277634e-10
R38_61	38	61	6.4525790479018679e+03
C38_61	38	61	1.3721936223127781e-10
R38_64	38	64	3.2729594673210104e+03
C38_64	38	64	2.7052543440898000e-10
R38_86	38	86	6.0161049010072156e+03
C38_86	38	86	1.4717475779914730e-10
R39_40	39	40	4.0480468535180086e-06
C39_40	39	40	2.1872740453350115e-11
R39_42	39	42	5.3206218324716999e-06
C39_42	39	42	1.2758303200099937e-10
R39_43	39	43	5.4074156802003786e-06
C39_43	39	43	1.3918034203219545e-10
R39_65	39	65	1.5034972319929420e+03
C39_65	39	65	5.8890616015723839e-10
R39_70	39	70	3.0876124833574542e-06
C39_70	39	70	2.4375013637144177e-10
R39_66	39	66	1.3333196497812494e+03
C39_66	39	66	6.6407090141157528e-10
R39_90	39	90	2.0489782306496459e+03
C39_90	39	90	4.3212698332049656e-10
R39_91	39	91	7.4102379224436978e-06
C39_91	39	91	1.9117740394060319e-10
R40_42	40	42	5.8985597368455398e-06
C40_42	40	42	1.5010762308114027e-11
R40_41	40	41	8.8291698507161704e-06
C40_41	40	41	1.0028335581608276e-11
R40_43	40	43	7.3576415422634567e-06
C40_43	40	43	1.2034002697929961e-11
R40_91	40	91	1.4715283084526932e-06
C40_91	40	91	6.0170013489649730e-11
R41_42	41	42	3.8839566808232940e-06
C41_42	41	42	2.2796824333074575e-11
R41_45	41	45	4.1413964943300447e-06
C41_45	41	45	2.1379715342692260e-11
R41_89	41	89	1.2105033082435783e-06
C41_89	41	89	7.3144680867062563e-11
R41_77	41	77	1.4526039698922942e-05
C41_77	41	77	6.0953900722552136e-12
R41_91	41	91	9.0787748118268486e-06
C41_91	41	91	9.7526241156083307e-12
R42_45	42	45	3.4031769887366707e-06
C42_45	42	45	2.6017417978272292e-11
R42_66	42	66	6.3497326830781060e+02
C42_66	42	66	1.3944189872112589e-09
R42_70	42	70	6.9118726228728792e-06
C42_70	42	70	2.0496182813134137e-10
R42_69	42	69	8.0856450247823620e-06
C42_69	42	69	1.2045553025279576e-10
R42_75	42	75	3.8880338230655157e-06
C42_75	42	75	1.7459237661215536e-10
R42_78	42	78	9.1813632109487992e+02
C42_78	42	78	9.6436527055604970e-10
R42_88	42	88	7.9338477878184362e-06
C42_88	42	88	1.7856027573028794e-10
R42_89	42	89	5.2982281602084252e-06
C42_89	42	89	1.8382761735533207e-10
R42_91	42	91	5.2946120588772030e-06
C42_91	42	91	1.2820978344944249e-10
R42_92	42	92	1.8152450410937788e+03
C42_92	42	92	4.8776818647387118e-10
R43_65	43	65	7.0140515905999027e+03
C43_65	43	65	1.2623499702890996e-10
R43_72	43	72	4.7882932935763383e+03
C43_72	43	72	1.8491323054246070e-10
R43_90	43	90	4.4301754182821078e+03
C43_90	43	90	1.9986088542817555e-10
R43_91	43	91	1.9266136381623773e-05
C43_91	43	91	9.6510239573759861e-11
R43_93	43	93	6.5549940535872593e+03
C43_93	43	93	1.3507545155063098e-10
R43_95	43	95	1.9266136420156075e+04
C43_95	43	95	4.5957256939885581e-11
R44_50	44	50	5.5668844860189761e-07
C44_50	44	50	1.5905104262962460e-10
R44_55	44	55	2.3189571180266327e-06
C44_55	44	55	4.1999942617518182e-10
R44_69	44	69	4.1866933247652494e-06
C44_69	44	69	4.4411646462199312e-10
R44_75	44	75	1.4540107429126056e-06
C44_75	44	75	6.6984419726160155e-10
R44_80	44	80	1.1043665365700356e+03
C44_80	44	80	8.0174358094003099e-10
R44_81	44	81	1.4620566323919700e+03
C44_81	44	81	6.0559814311120593e-10
R44_79	44	79	5.8276930451819624e+02
C44_79	44	79	1.5193298185669178e-09
R44_82	44	82	2.7323289464006407e+03
C44_82	44	82	3.2405277661256067e-10
R44_83	44	83	1.0254995746669431e+03
C44_83	44	83	8.6340238803859309e-10
R44_100	44	100	4.1835109713070502e-06
C44_100	44	100	3.3863184734337775e-10
R45_50	45	50	4.6304284226520067e-06
C45_50	45	50	1.9121746432112865e-11
R45_52	45	52	4.7918853830969055e-06
C45_52	45	52	1.8477461602551321e-11
R45_75	45	75	1.9587876558224961e-06
C45_75	45	75	4.5202387255611551e-11
R45_88	45	88	7.7103959693414771e-07
C45_88	45	88	1.1483441125730165e-10
R45_76	45	76	5.4312251046358136e-06
C45_76	45	76	1.6302376805267234e-11
R45_77	45	77	5.4262710235187192e-06
C45_77	45	77	1.6317260561855267e-11
R45_89	45	89	4.7037617364301901e-06
C45_89	45	89	1.8823631623228600e-11
R45_100	45	100	3.6726679216882926e-06
C45_100	45	100	2.4108326714520407e-11
R46_50	46	50	1.3645883287916385e-06
C46_50	46	50	6.4885413645890569e-11
R46_52	46	52	5.0823609152763780e-06
C46_52	46	52	1.7421407028348579e-11
R46_51	46	51	1.3596354721955382e-06
C46_51	46	51	6.5121777109141353e-11
R46_55	46	55	5.5729438269334305e-07
C46_55	46	55	1.5887810988168720e-10
R46_56	46	56	2.6960769105167881e-06
C46_56	46	56	3.2841006065004336e-11
R46_47	46	47	3.4984991240436932e-06
C46_47	46	47	2.5308532325044596e-11
R46_106	46	106	3.5341548920258936e-06
C46_106	46	106	2.5053196839158598e-11
R47_56	47	56	3.0889723540276068e-06
C47_56	47	56	2.8663862288878448e-11
R47_59	47	59	4.0249538947814864e-06
C47_59	47	59	2.1998234137488653e-11
R47_57	47	57	4.7039325920895793e-06
C47_57	47	57	1.8822947913602641e-11
R47_106	47	106	4.8841074946910112e-07
C47_106	47	106	1.8128568682455161e-10
R47_54	47	54	5.4380637964301191e-06
C47_54	47	54	1.6281875587433221e-11
R47_53	47	53	6.6815430965359160e-06
C47_53	47	53	1.3251711003092240e-11
R47_51	47	51	5.1656916527215206e-06
C47_51	47	51	1.7140372310715088e-11
R48_49	48	49	1.8166531097641298e+03
C48_49	48	49	4.8739012249562668e-10
R48_56	48	56	4.9171441564547538e-06
C48_56	48	56	1.9807445702349754e-10
R48_59	48	59	1.6731293996369167e-05
C48_59	48	59	1.1113183703870975e-10
R48_63	48	63	5.9089342247103950e+03
C48_63	48	63	1.4984407475671225e-10
R48_110	48	110	5.7021401217454977e+03
C48_110	48	110	1.5527832757448304e-10
R48_111	48	111	4.7828457786296685e+03
C48_111	48	111	1.8512384105215308e-10
R49_56	49	56	1.2466567469329798e+03
C49_56	49	56	7.1023462061895065e-10
R49_63	49	63	4.1477545891055424e+03
C49_63	49	63	2.1346942367941288e-10
R49_81	49	81	2.3585510909163290e+03
C49_81	49	81	3.7540792951659274e-10
R49_84	49	84	6.2728272988321726e+02
C49_84	49	84	1.4115146799352193e-09
R49_108	49	108	2.2967870383569320e+03
C49_108	49	108	3.8550321249348745e-10
R49_110	49	110	1.7703179126276455e+03
C49_110	49	110	5.0014676764231105e-10
R49_111	49	111	3.1962820592315311e+03
C49_111	49	111	2.7701522121388677e-10
R50_52	50	52	2.5184610659640302e-07
C50_52	50	52	3.5157135985386967e-10
R50_51	50	51	2.3367230734067196e-06
C50_51	50	51	3.7891472540181834e-11
R50_55	50	55	8.2482880574763227e-07
C50_55	50	55	1.0734576381549243e-10
R50_75	50	75	8.3295395988167487e-07
C50_75	50	75	1.0629864606511724e-10
R50_100	50	100	3.9406044593799062e-07
C50_100	50	100	2.2469110788128425e-10
R50_114	50	114	2.3002316110338801e-06
C50_114	50	114	3.8492592548192701e-11
R51_52	51	52	2.9913812068660277e-06
C51_52	51	52	2.9598995262379966e-11
R51_55	51	55	1.7625208051779551e-06
C51_55	51	55	5.0235933618417788e-11
R51_106	51	106	1.8082323349268915e-06
C51_106	51	106	4.8965985432165089e-11
R51_53	51	53	2.2046318172817479e-06
C51_53	51	53	4.0161752849584551e-11
R51_112	51	112	2.4038943835701625e-06
C51_112	51	112	3.6832682323797170e-11
R51_101	51	101	3.1201286733405823e-06
C51_101	51	101	2.8377636770730407e-11
R51_114	51	114	4.7501927729603028e-07
C51_114	51	114	1.8639638937183816e-10
R52_100	52	100	8.0738709484064608e-07
C52_100	52	100	1.0966471812071199e-10
R52_76	52	76	7.2519481147508428e-06
C52_76	52	76	1.2209392120429155e-11
R52_101	52	101	6.4354358919502017e-06
C52_101	52	101	1.3758489658913870e-11
R52_114	52	114	3.9188520170818104e-06
C52_114	52	114	2.2593830485064628e-11
R53_106	53	106	3.5504522814857803e-06
C53_106	53	106	2.4938196925420252e-11
R53_54	53	54	2.9695842261426087e-06
C53_54	53	54	2.9816254205058522e-11
R53_112	53	112	6.7142829289458376e-07
C53_112	53	112	1.3187093708590759e-10
R53_104	53	104	6.7866732374553064e-06
C53_104	53	104	1.3046433071411461e-11
R53_101	53	101	8.0717664960267442e-06
C53_101	53	101	1.0969330965357330e-11
R53_103	53	103	4.1285953284764456e-06
C53_103	53	103	2.1446005511679482e-11
R53_115	53	115	3.3667132318685223e-06
C53_115	53	115	2.6299204022452291e-11
R54_106	54	106	3.5263083433760558e-06
C54_106	54	106	2.5108943843870107e-11
R54_57	54	57	3.0077919028292921e-06
C54_57	54	57	2.9437501340007165e-11
R54_115	54	115	7.2686686836984547e-07
C54_115	54	115	1.2181306099227513e-10
R54_58	54	58	6.9060000133154439e-06
C54_58	54	58	1.2821007529580451e-11
R54_103	54	103	3.7919194094651851e-06
C54_103	54	103	2.3350147671647913e-11
R55_56	55	56	5.9477092928153082e-06
C55_56	55	56	2.1337630835638012e-10
R55_81	55	81	2.9928410718940318e+03
C55_81	55	81	2.9584557296243568e-10
R55_79	55	79	1.3435191060375512e+03
C55_79	55	79	6.5902954243157048e-10
R55_100	55	100	8.8863504530535154e-06
C55_100	55	100	1.5942090693803336e-10
R55_106	55	106	5.9914070766029475e-06
C55_106	55	106	1.1329910600939101e-10
R55_108	55	108	4.2349325920360097e+03
C55_108	55	108	2.0907505903755629e-10
R55_113	55	113	4.7946622575146021e+03
C55_113	55	113	1.8466760204272920e-10
R55_114	55	114	3.0513905589003841e-06
C55_114	55	114	3.1918584006074317e-10
R55_118	55	118	1.4774358268804699e+03
C55_118	55	118	5.9929424046086417e-10
R56_59	56	59	4.9313708259137023e-06
C56_59	56	59	1.3765362400863017e-10
R56_81	56	81	2.0794453529745711e+03
C56_81	56	81	4.2579564807194412e-10
R56_106	56	106	5.6668657049921390e-06
C56_106	56	106	1.7186937358300966e-10
R56_108	56	108	2.2236172863026868e+03
C56_108	56	108	3.9818847746602463e-10
R56_110	56	110	1.5912658686222283e+03
C56_110	56	110	5.5642416465994189e-10
R56_118	56	118	4.7335447402358404e+03
C56_118	56	118	1.8705195161119056e-10
R57_59	57	59	7.1863302106302546e-06
C57_59	57	59	1.2320875269414419e-11
R57_106	57	106	4.4393865895309463e-06
C57_106	57	106	1.9944619911859291e-11
R57_107	57	107	1.4372660421260506e-06
C57_107	57	107	6.1604376347072104e-11
R57_115	57	115	2.9555353708813281e-06
C57_115	57	115	2.9957982923275655e-11
R57_58	57	58	8.6235962527563041e-06
C57_58	57	58	1.0267396057845349e-11
R57_120	57	120	1.0779495315945382e-05
C57_120	57	120	8.2139168462762793e-12
R58_115	58	115	3.9003866571048984e-06
C58_115	58	115	2.2700795063154354e-11
R58_103	58	103	8.5435169930304777e-06
C58_103	58	103	1.0363633412589871e-11
R58_117	58	117	1.0679396241288098e-05
C58_117	58	117	8.2909067300718955e-12
R58_120	58	120	2.1358792482576194e-06
C58_120	58	120	4.1454533650359482e-11
R59_106	59	106	4.4701107969319289e-06
C59_106	59	106	2.1788288996427555e-10
R59_107	59	107	1.2903465884635446e-05
C59_107	59	107	7.5480546668919738e-11
R59_110	59	110	2.2095121121908692e+03
C59_110	59	110	4.0073044941222423e-10
R59_111	59	111	5.3500234974236600e+03
C59_111	59	111	1.6549811082631306e-10
R59_126	59	126	2.9927916339829367e+03
C59_126	59	126	2.9585046003408082e-10
R60_62	60	62	1.7432577540101595e+03
C60_62	60	62	5.0791042211812807e-10
R60_61	60	61	8.6917004272688719e+03
C60_61	60	61	1.0186945455714683e-10
R60_67	60	67	1.5398877792425681e+03
C60_67	60	67	5.7498916066176928e-10
R60_68	60	68	6.7783856153133484e+03
C60_68	60	68	1.3062384348563935e-10
R60_73	60	73	4.5205870473686427e+03
C60_73	60	73	1.9586367266512149e-10
R60_122	60	122	3.3744494103253251e+03
C60_122	60	122	2.6238911124011732e-10
R60_128	60	128	5.9443090571988550e+03
C60_128	60	128	1.4895234638375903e-10
R61_62	61	62	2.3785807793663594e+03
C61_62	61	62	3.7224667305008270e-10
R61_64	61	64	6.7908641340604399e+03
C61_64	61	64	1.3038381628916267e-10
R61_128	61	128	5.0906936737014757e+03
C61_128	61	128	1.7392890604949845e-10
R61_121	61	121	5.0297316763898989e+03
C61_121	61	121	1.7603698142711091e-10
R61_130	61	130	5.0331877779727147e+03
C61_130	61	130	1.7591610342355083e-10
R61_131	61	131	8.9846760447495144e+03
C61_131	61	131	9.8547657955616891e-11
R62_64	62	64	1.1592003854358175e+03
C62_64	62	64	7.6381857082208848e-10
R62_67	62	67	2.5964646525337034e+03
C62_67	62	67	3.4100937243107987e-10
R62_86	62	86	1.3926512734419573e+03
C62_86	62	86	6.3577924968371676e-10
R62_87	62	87	6.0656865095967378e+03
C62_87	62	87	1.4597173465841787e-10
R62_122	62	122	1.3355213553900883e+03
C62_122	62	122	6.6297613147592146e-10
R62_123	62	123	3.0266577002555096e+03
C62_123	62	123	2.9254011169655993e-10
R62_121	62	121	1.3865277713248879e+03
C62_121	62	121	6.3858712390155996e-10
R62_128	62	128	4.5379100260608911e+03
C62_128	62	128	1.9511598436617378e-10
R62_130	62	130	2.9574616245684720e+03
C62_130	62	130	2.9938470692048045e-10
R62_133	62	133	1.4355953466668325e+03
C62_133	62	133	6.1676069357271644e-10
R62_134	62	134	5.6088632002714376e+03
C62_134	62	134	1.5786064842108303e-10
R63_84	63	84	3.3228017433809982e+03
C63_84	63	84	2.6646753254651715e-10
R63_86	63	86	3.7693418718907465e+03
C63_86	63	86	2.3490009975026850e-10
R63_64	63	64	5.2580529279318152e+03
C63_64	63	64	1.6839290015444322e-10
R63_87	63	87	1.4238506644756856e+03
C63_87	63	87	6.2184806580544318e-10
R63_111	63	111	4.2976404054411532e+03
C63_111	63	111	2.0602439901183679e-10
R63_129	63	129	8.1374262102697603e+03
C63_129	63	129	1.0880821021548139e-10
R63_134	63	134	9.2460883858257530e+03
C63_134	63	134	9.5761444705346583e-11
R64_86	64	86	3.3266599748648282e+03
C64_86	64	86	2.6615848580556448e-10
R64_87	64	87	5.3819866454828871e+03
C64_87	64	87	1.6451523201811249e-10
R64_130	64	130	7.5555251425932329e+03
C64_130	64	130	1.1718825164230791e-10
R64_134	64	134	5.4553346508522782e+03
C64_134	64	134	1.6230329363234802e-10
R65_70	65	70	1.4100990698618707e+04
C65_70	65	70	6.2791246418362162e-11
R65_66	65	66	2.3135365597447289e+04
C65_66	65	66	3.8271224976781677e-11
R65_71	65	71	4.8577306596878079e+04
C65_71	65	71	1.8227004412733399e-11
R65_72	65	72	1.2605218808324025e+04
C65_72	65	72	7.0242238168472102e-11
R65_74	65	74	1.8805581514989797e+04
C65_74	65	74	4.7082765347843090e-11
R65_90	65	90	1.3187435744347946e+04
C65_90	65	90	6.7141087840332061e-11
R65_136	65	136	1.0520712050706788e+04
C65_136	65	136	8.4159587053855078e-11
R66_70	66	70	2.3359917308503350e+03
C66_70	66	70	3.7903335444500693e-10
R66_78	66	78	2.2073151845666030e+03
C66_78	66	78	4.0112929403593459e-10
R66_90	66	90	7.1843849338130849e+02
C66_90	66	90	1.2324211325771313e-09
R66_91	66	91	2.0078988775323633e+03
C66_91	66	91	4.4096781546496439e-10
R66_89	66	89	7.0467434175025455e+03
C66_89	66	89	1.2564935733303650e-10
R66_92	66	92	6.3294655742985867e+02
C66_92	66	92	1.3988839520596016e-09
R66_136	66	136	1.6119963925454986e+03
C66_136	66	136	5.4926846349937432e-10
R67_68	67	68	4.2512240718012299e+03
C67_68	67	68	2.0827384460232673e-10
R67_71	67	71	9.7633186008720768e+03
C67_71	67	71	9.0688301580254993e-11
R67_73	67	73	1.0348220438410530e+04
C67_73	67	73	8.5562419835346986e-11
R67_85	67	85	1.1022404603047413e+04
C67_85	67	85	8.0329003841430784e-11
R67_86	67	86	4.2512240718012663e+03
C67_86	67	86	2.0827384460232497e-10
R67_122	67	122	4.3272487161040526e+03
C67_122	67	122	2.0461471937235176e-10
R67_123	67	123	3.4794805515089788e+03
C67_123	67	123	2.5446866812231854e-10
R67_139	67	139	3.3257227606051524e+03
C67_139	67	139	2.6623349131449800e-10
R68_71	68	71	1.7483400453005783e+04
C68_71	68	71	5.0643396522315380e-11
R68_73	68	73	9.1381082048382468e+03
C68_73	68	73	9.6893006938920646e-11
R68_74	68	74	2.3774750764251072e+04
C68_74	68	74	3.7241979547115207e-11
R68_138	68	138	1.5067948958719004e+04
C68_138	68	138	5.8761732212243550e-11
R68_137	68	137	1.7636359739707950e+04
C68_137	68	137	5.0204168817587418e-11
R68_139	68	139	7.0110226676168304e+03
C68_139	68	139	1.2628953344989960e-10
R69_70	69	70	2.3124864121602358e-05
C69_70	69	70	5.4880333367767654e-11
R69_71	69	71	2.2037295487001258e+04
C69_71	69	71	4.0178196195729470e-11
R69_75	69	75	1.0991198844638612e-05
C69_75	69	75	6.8473509989099925e-11
R69_78	69	78	1.1082004355702515e+04
C69_78	69	78	7.9896989143880458e-11
R69_80	69	80	4.7807014148288372e+03
C69_80	69	80	1.8520687758361095e-10
R69_81	69	81	1.3613160163920658e+04
C69_81	69	81	6.5041384295664892e-11
R69_82	69	82	4.4138664672835575e+03
C69_82	69	82	2.0059935846788690e-10
R69_85	69	85	1.4129487494505767e+04
C69_85	69	85	6.2664607052753609e-11
R69_140	69	140	1.4058465843103782e+04
C69_140	69	140	6.2981180989555270e-11
R70_71	70	71	1.5545535217413687e+03
C70_71	70	71	5.6956468163809369e-10
R70_78	70	78	3.3333167725682069e+03
C70_78	70	78	2.6562695420567994e-10
R70_136	70	136	2.7031262859130516e+03
C70_136	70	136	3.2755361313092579e-10
R70_140	70	140	5.5146879535968847e+03
C70_140	70	140	1.6055646106367575e-10
R71_74	71	74	1.9778996088475981e+03
C71_74	71	74	4.4765607806347650e-10
R71_85	71	85	8.5585135824735335e+02
C71_85	71	85	1.0345473815841061e-09
R71_136	71	136	3.1070368178797125e+03
C71_136	71	136	2.8497209193170191e-10
R71_138	71	138	1.1464887248255839e+03
C71_138	71	138	7.7228738715655432e-10
R71_139	71	139	2.8729233267624732e+03
C71_139	71	139	3.0819436545763566e-10
R71_140	71	140	3.4481358718160554e+03
C71_140	71	140	2.5678187131114121e-10
R72_74	72	74	3.4230335110190786e+03
C72_74	72	74	2.5866494699796266e-10
R72_90	72	90	1.8920988187593139e+03
C72_90	72	90	4.6795588735718689e-10
R72_93	72	93	3.0883128102310966e+03
C72_93	72	93	2.8669983777768433e-10
R72_95	72	95	2.3563003008897413e+03
C72_95	72	95	3.7576652745223727e-10
R72_136	72	136	2.5768304524393748e+03
C72_136	72	136	3.4360769869892374e-10
R72_94	72	94	2.8795675528276493e+03
C72_94	72	94	3.0748324720861131e-10
R72_144	72	144	2.4915003404719550e+03
C72_144	72	144	3.5537574180394398e-10
R73_122	73	122	9.1249405988210708e+02
C73_122	73	122	9.7032826911157602e-10
R73_128	73	128	2.4088717264861807e+03
C73_128	73	128	3.6756576614876864e-10
R73_124	73	124	1.9494312182383330e+03
C73_124	73	124	4.5419339416352300e-10
R73_132	73	132	2.8172019415213836e+03
C73_132	73	132	3.1429013612770840e-10
R73_139	73	139	2.3593055213193807e+03
C73_139	73	139	3.7528788607456504e-10
R73_137	73	137	3.4536229663800946e+03
C73_137	73	137	2.5637389788036112e-10
R73_145	73	145	1.1943269498536426e+03
C73_145	73	145	7.4135376565730382e-10
R74_136	74	136	2.3310775917314800e+03
C74_136	74	136	3.7983239375671222e-10
R74_94	74	94	4.9825637953698451e+03
C74_94	74	94	1.7770345108732869e-10
R74_138	74	138	2.0473365917823439e+03
C74_138	74	138	4.3247348054732106e-10
R74_137	74	137	7.1324473064735748e+03
C74_137	74	137	1.2413954757105231e-10
R74_146	74	146	5.4154548801414212e+03
C74_146	74	146	1.6349850590517298e-10
R75_78	75	78	1.2993816641421229e+03
C75_78	75	78	6.8141548102002085e-10
R75_80	75	80	8.9946605080981465e+02
C75_80	75	80	9.8438265780329628e-10
R75_83	75	83	1.2034352425586369e+03
C75_83	75	83	7.3574277234685390e-10
R75_88	75	88	3.9872005559255674e-06
C75_88	75	88	3.5530443696633582e-10
R75_100	75	100	2.5658631695085107e-06
C75_100	75	100	3.7958402087458196e-10
R75_148	75	148	1.1437866133998361e+03
C75_148	75	148	7.7411185908894900e-10
R76_88	76	88	3.9151187061025646e-06
C76_88	76	88	2.2615375117997884e-11
R76_77	76	77	3.3825576221076628e-06
C76_77	76	77	2.6176014738465802e-11
R76_100	76	100	3.0418294349341555e-06
C76_100	76	100	2.9108100918852676e-11
R76_101	76	101	5.2626295528131422e-06
C76_101	76	101	1.6824645793787608e-11
R76_149	76	149	6.1462193047413182e-07
C76_149	76	149	1.4405909353364108e-10
R76_102	76	102	4.7601801878863607e-06
C76_102	76	102	1.8600530794048537e-11
R76_97	76	97	6.1741281630196170e-06
C76_97	76	97	1.4340790445577067e-11
R77_88	77	88	2.2125144512528232e-05
C77_88	77	88	4.0018666598929411e-12
R77_89	77	89	4.8894045711227992e-05
C77_89	77	89	1.8108928578529823e-12
R77_96	77	96	9.7788091422455970e-06
C77_96	77	96	9.0544642892649137e-12
R77_97	77	97	5.8672854853473575e-05
C77_97	77	97	1.5090773815441521e-12
R77_149	77	149	2.9002650491937646e-05
C77_149	77	149	3.0528891900625937e-12
R78_80	78	80	2.7991172719045877e+04
C78_80	78	80	3.1632071674422543e-11
R78_88	78	88	7.9794293497324645e+04
C78_88	78	88	1.1096266949586895e-11
R78_92	78	92	2.2097654731553073e+04
C78_92	78	92	4.0068450360739754e-11
R78_136	78	136	6.9297765731066800e+04
C78_136	78	136	1.2777017734398025e-11
R78_140	78	140	1.6807430552948568e+04
C78_140	78	140	5.2680198731784668e-11
R78_142	78	142	5.3128855375168059e+04
C78_142	78	142	1.6665497034476611e-11
R78_147	78	147	1.0269866164303849e+05
C78_147	78	147	8.6215221068561881e-12
R78_148	78	148	5.3745668745803909e+04
C78_148	78	148	1.6474235084648146e-11
R78_152	78	152	2.1413601751402235e+04
C78_152	78	152	4.1348428535242559e-11
R79_81	79	81	2.1017663001326153e+04
C79_81	79	81	4.2127365998975852e-11
R79_80	79	80	3.8056068582365180e+04
C79_80	79	80	2.3266165284090713e-11
R79_82	79	82	5.7841472230669431e+04
C79_82	79	82	1.5307680588920457e-11
R79_83	79	83	1.1115762394286474e+04
C79_83	79	83	7.9654345810333902e-11
R79_100	79	100	6.7991436969365692e+04
C79_100	79	100	1.3022504320638722e-11
R79_108	79	108	3.0162205046770334e+04
C79_108	79	108	2.9355240451652849e-11
R79_113	79	113	3.5218731366273489e+04
C79_113	79	113	2.5140564334691043e-11
R79_118	79	118	5.3341387173399497e+04
C79_118	79	118	1.6599095535737105e-11
R79_119	79	119	1.6620395904933008e+04
C79_119	79	119	5.3273025911326435e-11
R79_153	79	153	3.5088165967018569e+04
C79_153	79	153	2.5234114046663400e-11
R80_82	80	82	8.1054276663038436e+03
C80_82	80	82	1.0923776241701504e-10
R80_83	80	83	4.2382286527107854e+03
C80_83	80	83	2.0891246184504068e-10
R80_85	80	85	2.3073439388348652e+04
C80_85	80	85	3.8373940130794204e-11
R80_140	80	140	7.6503060988753032e+03
C80_140	80	140	1.1573638626435723e-10
R80_147	80	147	1.3887793082173011e+04
C80_147	80	147	6.3755182444110808e-11
R80_148	80	148	1.9371678752630392e+04
C80_148	80	148	4.5706868929971967e-11
R80_153	80	153	9.6939500272548667e+03
C80_153	80	153	9.1337254598034389e-11
R81_82	81	82	2.7160761211106487e+03
C81_82	81	82	3.2599188764191835e-10
R81_84	81	84	7.8015085966657161e+03
C81_84	81	84	1.1349327770764990e-10
R81_108	81	108	3.1464984777679724e+03
C81_108	81	108	2.8139812809573911e-10
R81_153	81	153	1.3678351289398190e+04
C81_153	81	153	6.4731396567236142e-11
R82_84	82	84	6.9946356067463757e+03
C82_84	82	84	1.2658540508472054e-10
R82_85	82	85	3.9797379342684285e+03
C82_85	82	85	2.2248168003121576e-10
R82_153	82	153	7.2898992129637145e+03
C82_153	82	153	1.2145830221156548e-10
R83_100	83	100	4.6991065384907515e+03
C83_100	83	100	1.8842279366246859e-10
R83_113	83	113	3.8150583915608149e+03
C83_113	83	113	2.3208525029619741e-10
R83_119	83	119	7.1439349978716018e+03
C83_119	83	119	1.2393992693995587e-10
R83_147	83	147	2.7568482633782646e+03
C83_147	83	147	3.2117066196998469e-10
R83_148	83	148	3.9857117342271940e+03
C83_148	83	148	2.2214822364008155e-10
R83_153	83	153	8.2363125535676591e+03
C83_153	83	153	1.0750184332386342e-10
R84_85	84	85	1.0951177465287887e+04
C84_85	84	85	8.0851468666864859e-11
R84_86	84	86	7.4058767873373981e+03
C84_86	84	86	1.1955623987883422e-10
R84_87	84	87	5.4312651567583443e+03
C84_87	84	87	1.6302256585617761e-10
R84_108	84	108	4.1274631886800862e+03
C84_108	84	108	2.1451888029633686e-10
R84_110	84	110	1.0845902851980622e+04
C84_110	84	110	8.1636244928960397e-11
R84_109	84	109	3.0470028282086137e+03
C84_109	84	109	2.9058679352147284e-10
R84_111	84	111	1.2183004067328169e+04
C84_111	84	111	7.2676556357267944e-11
R84_143	84	143	1.4263349840609917e+04
C84_143	84	143	6.2076496166354888e-11
R84_153	84	153	8.7419128724470047e+03
C84_153	84	153	1.0128432925597861e-10
R84_154	84	154	7.5552310539759919e+03
C84_154	84	154	1.1719281321436789e-10
R85_86	85	86	1.3544001913247344e+04
C85_86	85	86	6.5373497978760257e-11
R85_123	85	123	1.4156984161761728e+04
C85_123	85	123	6.2542895547734841e-11
R85_138	85	138	1.1401744634178474e+04
C85_138	85	138	7.7656429792842555e-11
R85_139	85	139	1.0326152228098459e+04
C85_139	85	139	8.5745276860309094e-11
R85_140	85	140	5.9789795141952200e+03
C85_140	85	140	1.4808861271356588e-10
R85_141	85	141	5.6071981788003604e+03
C85_141	85	141	1.5790752412632443e-10
R85_153	85	153	1.0447588852963871e+04
C85_153	85	153	8.4748624219531407e-11
R85_154	85	154	1.3792127738339834e+04
C85_154	85	154	6.4197402931433295e-11
R86_87	86	87	8.5827698556140022e+03
C86_87	86	87	1.0316235860860775e-10
R86_123	86	123	5.9540888664130143e+03
C86_123	86	123	1.4870768669487671e-10
R86_133	86	133	1.1721537711586163e+04
C86_133	86	133	7.5537766757752896e-11
R86_154	86	154	1.4358265521350017e+04
C86_154	86	154	6.1666137903873353e-11
R87_111	87	111	1.6423213180540177e+04
C87_111	87	111	5.3912640112906195e-11
R87_109	87	109	4.5259355568041483e+03
C87_109	87	109	1.9563221141513816e-10
R87_129	87	129	5.5564091684718833e+03
C87_129	87	129	1.5935089638899052e-10
R87_133	87	133	8.1321327163020205e+03
C87_133	87	133	1.0887903734343290e-10
R87_134	87	134	4.8938444793020490e+03
C87_134	87	134	1.8092499372319185e-10
R87_135	87	135	5.6570697601576248e+03
C87_135	87	135	1.5651544337245883e-10
R87_154	87	154	1.0773439416758967e+04
C87_154	87	154	8.2185340024529086e-11
R88_89	88	89	2.8414077861660752e-05
C88_89	88	89	4.4664488436215250e-11
R88_92	88	92	4.5092518975680265e+04
C88_92	88	92	1.9635602574731581e-11
R88_96	88	96	4.1032406897029948e-05
C88_96	88	96	3.4525638531273626e-11
R88_100	88	100	3.8180513710816450e-05
C88_100	88	100	1.7779254377217670e-11
R88_148	88	148	6.5898498444793122e+03
C88_148	88	148	1.3436099495374161e-10
R88_149	88	149	3.7720144077561952e-05
C88_149	88	149	2.5820703571368526e-11
R88_151	88	151	2.6012263460444028e+04
C88_151	88	151	3.4038513528298926e-11
R88_152	88	152	2.8202554370085771e+04
C88_152	88	152	3.1394985364841867e-11
R88_155	88	155	2.5782003073385105e+04
C88_155	88	155	3.4342513232186461e-11
R89_91	89	91	5.7169008071469533e-05
C89_91	89	91	4.8011996492998636e-11
R89_92	89	92	1.1231079152930828e+04
C89_92	89	92	7.8836483087998163e-11
R89_96	89	96	5.7169008185807461e-05
C89_96	89	96	1.7036514884612442e-11
R89_152	89	152	2.5775544501485841e+04
C89_152	89	152	3.4351118427351156e-11
R89_155	89	155	1.8786577857962246e+04
C89_155	89	155	4.7130392155202241e-11
R89_158	89	158	1.9547393557281564e+04
C89_158	89	158	4.5296002206400272e-11
R90_91	90	91	2.7986467993264682e+03
C90_91	90	91	3.1637389252301789e-10
R90_92	90	92	2.9933895267936714e+03
C90_92	90	92	2.9579136753658802e-10
R90_93	90	93	1.7331558050230644e+03
C90_93	90	93	5.1087085138789189e-10
R90_136	90	136	2.6321209118683714e+03
C90_136	90	136	3.3638985872860180e-10
R90_144	90	144	2.6184103572347385e+03
C90_144	90	144	3.3815126771614087e-10
R90_158	90	158	7.0481468346055526e+03
C90_158	90	158	1.2562433820940003e-10
R91_92	91	92	4.5658373548041282e+03
C91_92	91	92	1.9392254101394378e-10
R91_93	91	93	5.6563592316030672e+03
C91_93	91	93	1.5653510419794603e-10
R91_158	91	158	6.2360781894206639e+03
C91_158	91	158	1.4198327134545693e-10
R92_136	92	136	1.7619465225079575e+03
C92_136	92	136	5.0252307342432473e-10
R92_142	92	142	1.2370104670373335e+03
C92_142	92	142	7.1577307168677153e-10
R92_144	92	144	2.3233231265508771e+03
C92_144	92	144	3.8110014555507017e-10
R92_152	92	152	1.1517123795049977e+03
C92_152	92	152	7.6878463534493760e-10
R92_158	92	158	1.2900401516752620e+03
C92_158	92	158	6.8634978574130767e-10
R92_159	92	159	2.5927282807237530e+03
C92_159	92	159	3.4150079986508959e-10
R93_95	93	95	2.2694316710797689e+03
C93_95	93	95	3.9015000671015064e-10
R93_144	93	144	1.4163522352501825e+03
C93_144	93	144	6.2514024383461432e-10
R93_158	93	158	3.8336636605338717e+03
C93_158	93	158	2.3095891035383576e-10
R93_161	93	161	4.0515380885288128e+03
C93_161	93	161	2.1853892579879753e-10
R94_136	94	136	4.2738672358758258e+03
C94_136	94	136	2.0717039927389204e-10
R94_144	94	144	2.2111594688098303e+03
C94_144	94	144	4.0043189746806551e-10
R94_95	94	95	3.9245947850942935e+03
C94_95	94	95	2.2560769459890284e-10
R94_146	94	146	8.7480545057475274e+02
C94_146	94	146	1.0121322187902170e-09
R94_137	94	137	8.3926211504989915e+03
C94_137	94	137	1.0549967236962156e-10
R94_160	94	160	7.3931079225105432e+03
C94_160	94	160	1.1976272914995275e-10
R94_161	94	161	3.9463491029033617e+03
C94_161	94	161	2.2436402827326908e-10
R94_162	94	162	3.6784236048266380e+03
C94_162	94	162	2.4070604063604831e-10
R95_144	95	144	4.6417188349814442e+03
C95_144	95	144	1.9075235126850154e-10
R95_161	95	161	5.3151377257130807e+03
C95_161	95	161	1.6658435348092736e-10
R95_162	95	162	1.9206677846559240e+04
C95_162	95	162	4.6099527923233090e-11
R96_98	96	98	4.1713793619369574e-05
C96_98	96	98	2.3348647399065283e-11
R96_97	96	97	2.6071121038177109e-05
C96_97	96	97	3.3961668944094953e-12
R96_149	96	149	1.0270248021742033e-05
C96_149	96	149	9.4833216961671487e-11
R96_151	96	151	1.3059726830546801e+04
C96_151	96	151	6.7797649459941147e-11
R96_155	96	155	1.0896011941345359e+04
C96_155	96	155	8.1260812347336231e-11
R96_163	96	163	1.0928715814480116e+04
C96_163	96	163	8.1017641663520534e-11
R97_102	97	102	2.6436935417099622e-06
C97_102	97	102	3.3491732976255028e-11
R97_127	97	127	2.4435806926432978e-06
C97_127	97	127	3.6234480996091632e-11
R97_99	97	99	8.0783934378674187e-06
C97_99	97	99	1.0960332503113861e-11
R97_98	97	98	1.3463989063112365e-06
C97_98	97	98	6.5761995018683175e-11
R97_149	97	149	2.7144802767666699e-06
C97_149	97	149	3.2618353843950522e-11
R97_165	97	165	1.0097991797334276e-05
C97_165	97	165	8.7682660024910882e-12
R98_149	98	149	2.1128026123539616e-05
C98_149	98	149	6.7051699023441868e-11
R98_127	98	127	1.4108783060586018e-05
C98_127	98	127	6.9032223028283286e-11
R98_163	98	163	2.2798283671716286e+04
C98_163	98	163	3.8837080652630743e-11
R98_164	98	164	9.2953025067087856e+03
C98_164	98	164	9.5254434275910689e-11
R98_165	98	165	5.5742945214465240e-05
C98_165	98	165	1.7472357356591516e-11
R99_102	99	102	2.2750883443458444e-05
C99_102	99	102	3.8917995597862557e-12
R99_127	99	127	1.2038819681235712e-05
C99_127	99	127	7.3546975961443835e-12
R99_105	99	105	2.2178475057885530e-05
C99_105	99	105	3.9922437380796853e-12
R99_165	99	165	5.5446187644713824e-06
C99_165	99	165	1.5968974952318741e-11
R100_101	100	101	1.1911829913745800e-05
C100_101	100	101	7.4331046372502381e-12
R100_113	100	113	2.9720218716200029e+03
C100_113	100	113	2.9791798982198342e-10
R100_114	100	114	8.1378523440163100e-06
C100_114	100	114	6.5281507490732334e-11
R100_148	100	148	4.2247773727313424e+03
C100_148	100	148	2.0957761879120552e-10
R100_149	100	149	1.2845631656440549e-05
C100_149	100	149	9.8796251209769396e-11
R100_150	100	150	1.1304157610543481e+04
C100_150	100	150	7.8326825598588848e-11
R100_151	100	151	1.0373076350998012e+04
C100_151	100	151	8.5357395601818026e-11
R100_166	100	166	2.6553845479730160e-05
C100_166	100	166	5.3350843277159547e-11
R101_112	101	112	3.4946046612687685e-06
C101_112	101	112	2.5336736699095898e-11
R101_104	101	104	5.4048915146960799e-06
C101_104	101	104	1.6381804876055639e-11
R101_114	101	114	2.9869189212345647e-06
C101_114	101	114	2.9643214464423270e-11
R101_149	101	149	4.8691504916092962e-06
C101_149	101	149	1.8184255820923734e-11
R101_102	101	102	4.0173292562586033e-06
C101_102	101	102	2.2039985403750631e-11
R101_166	101	166	5.6353282203922920e-07
C101_166	101	166	1.5711929227049765e-10
R101_105	101	105	8.6891295853205313e-06
C101_105	101	105	1.0189959454579110e-11
R102_127	102	127	8.0380111169866395e-07
C102_127	102	127	1.1015396331424004e-10
R102_105	102	105	3.6041111038096564e-06
C102_105	102	105	2.4566911401928904e-11
R102_149	102	149	2.4665076848823173e-06
C102_149	102	149	3.5897669694154847e-11
R102_166	102	166	3.3887599961249257e-06
C102_166	102	166	2.6128105345686432e-11
R103_112	103	112	2.9465992314755003e-06
C103_112	103	112	3.0048836375234829e-11
R103_104	103	104	6.9646704474184932e-06
C103_104	103	104	1.2713003269640519e-11
R103_115	103	115	2.1099326535426996e-06
C103_115	103	115	4.1964314842624493e-11
R103_117	103	117	1.1607784079030823e-06
C103_117	103	117	7.6278019617843114e-11
R103_168	103	168	8.7058380592731188e-06
C103_168	103	168	1.0170402615712414e-11
R104_112	104	112	2.2291876153187913e-06
C104_112	104	112	3.9719347784613372e-11
R104_166	104	166	2.9906051306250095e-06
C104_166	104	166	2.9606676342287805e-11
R104_105	104	105	5.6244846872066736e-06
C104_105	104	105	1.5742220504466011e-11
R104_168	104	168	9.3741411453444578e-07
C104_168	104	168	9.4453323026796057e-11
R104_169	104	169	7.0306058590083435e-06
C104_169	104	169	1.2593776403572806e-11
R105_127	105	127	2.4860214964897333e-06
C105_127	105	127	3.5615894027875984e-11
R105_165	105	165	9.3535180896346616e-06
C105_165	105	165	9.4661577944794831e-12
R105_166	105	166	3.6686852819460773e-06
C105_166	105	166	2.4134498155435235e-11
R105_169	105	169	1.2471357452846216e-06
C105_169	105	169	7.0996183458596131e-11
R106_107	106	107	6.1734364090760969e-06
C106_107	106	107	2.2947835771212079e-10
R106_110	106	110	2.6411502976279467e+03
C106_110	106	110	3.3523983186235444e-10
R106_112	106	112	4.0417355347382165e-06
C106_112	106	112	1.6795286571401563e-10
R106_114	106	114	4.8742316796179801e-06
C106_114	106	114	2.9064479116143021e-10
R106_115	106	115	2.2982221552729664e-06
C106_115	106	115	3.2747311314260510e-10
R106_116	106	116	1.2074774807951528e+03
C106_116	106	116	7.3327974706156071e-10
R106_118	106	118	1.2023032574444039e+03
C106_118	106	118	7.3643548432367370e-10
R106_126	106	126	3.8723707183593810e+03
C106_126	106	126	2.2865031426410749e-10
R106_172	106	172	1.7334248102904482e+03
C106_172	106	172	5.1079157079310616e-10
R107_115	107	115	4.8467553484968781e-06
C107_115	107	115	2.9229246098306697e-10
R107_120	107	120	1.5974372479699431e-05
C107_120	107	120	6.0970198368278278e-11
R107_125	107	125	2.6204374024470067e+03
C107_125	107	125	3.3788969004685319e-10
R107_126	107	126	4.4167633273926813e+03
C107_126	107	126	2.0046778966141332e-10
R107_172	107	172	4.9532346605422454e+03
C107_172	107	172	1.7875567025994089e-10
R108_110	108	110	9.4614744416615656e+02
C108_110	108	110	9.3581480049372589e-10
R108_109	108	109	1.8833845486266594e+03
C108_109	108	109	4.7012108193498595e-10
R108_118	108	118	1.0647481519495302e+03
C108_118	108	118	8.3157578632920674e-10
R108_119	108	119	5.6500452427816424e+02
C108_119	108	119	1.5671003392958478e-09
R108_143	108	143	1.6806997186212732e+03
C108_143	108	143	5.2681557085422431e-10
R108_153	108	153	1.8126951750827284e+03
C108_153	108	153	4.8845431591088736e-10
R108_174	108	174	8.1237785532294572e+02
C108_174	108	174	1.0899100411199891e-09
R109_110	109	110	1.5754526812287525e+03
C109_110	109	110	5.6200912426606801e-10
R109_111	109	111	2.2726281916100438e+03
C109_111	109	111	3.8960124888388578e-10
R109_129	109	129	2.1696016621829399e+03
C109_129	109	129	4.0810200191731882e-10
R109_135	109	135	1.1712997496610622e+03
C109_135	109	135	7.5592843075072186e-10
R109_143	109	143	1.7714384257378144e+03
C109_143	109	143	4.9983040270294349e-10
R109_154	109	154	3.5961760089352556e+03
C109_154	109	154	2.4621119197170555e-10
R109_173	109	173	7.7749472272820765e+02
C109_173	109	173	1.1388100212347294e-09
R109_174	109	174	1.5596526902628514e+03
C109_174	109	174	5.6770253225465128e-10
R110_111	110	111	9.9534239542745615e+02
C110_111	110	111	8.8956200978433275e-10
R110_118	110	118	3.3720860848719076e+03
C110_118	110	118	2.6257300656475787e-10
R110_126	110	126	3.1542381658501331e+03
C110_126	110	126	2.8070764956372947e-10
R110_172	110	172	4.2723829699989501e+03
C110_172	110	172	2.0724237221182855e-10
R110_173	110	173	4.8233891135593703e+03
C110_173	110	173	1.8356776964374211e-10
R110_174	110	174	1.0003776196192572e+03
C110_174	110	174	8.8508455640679923e-10
R110_175	110	175	4.4863242705197099e+03
C110_175	110	175	1.9735951489690919e-10
R111_126	111	126	5.5176785337550109e+03
C111_126	111	126	1.6046943950854553e-10
R111_129	111	129	1.9514493219563003e+03
C111_129	111	129	4.5372368717850188e-10
R111_173	111	173	3.4719379986793629e+03
C111_173	111	173	2.5502148426521175e-10
R111_175	111	175	3.6691620535489910e+03
C111_175	111	175	2.4131362114234776e-10
R112_114	112	114	3.7549100585884140e-06
C112_114	112	114	2.5938321922474525e-10
R112_115	112	115	4.3976991304887654e-06
C112_115	112	115	1.5435823265199310e-10
R112_116	112	116	1.3504425570913465e+03
C112_116	112	116	6.5565082872318622e-10
R112_117	112	117	7.4559151686279792e-06
C112_117	112	117	1.9000619193682263e-10
R112_166	112	166	6.5337071446494391e-06
C112_166	112	166	1.4906708203070168e-10
R112_168	112	168	4.5591841677497582e-06
C112_168	112	168	1.4889090691251748e-10
R112_170	112	170	1.5846365493520245e+03
C112_170	112	170	5.5875196243710115e-10
R112_177	112	177	4.4854872945210509e+03
C112_177	112	177	1.9739634148145392e-10
R113_114	113	114	2.3522211879200945e+03
C113_114	113	114	3.7641816434912495e-10
R113_118	113	118	1.7485497126644716e+03
C113_118	113	118	5.0637323908325303e-10
R113_119	113	119	1.5304875190176792e+03
C113_119	113	119	5.7852074629677011e-10
R113_147	113	147	8.8250628398665560e+02
C113_147	113	147	1.0033002571949825e-09
R113_148	113	148	3.0987390409072668e+03
C113_148	113	148	2.8573518776875192e-10
R113_150	113	150	1.3448171823451544e+03
C113_150	113	150	6.5839341832022528e-10
R113_151	113	151	3.2955498326614611e+03
C113_151	113	151	2.6867103417002271e-10
R113_166	113	166	5.8011454751706360e+03
C113_166	113	166	1.5262826720854747e-10
R113_176	113	176	1.6168375334088998e+03
C113_176	113	176	5.4762384185454003e-10
R113_177	113	177	1.1851878662150064e+03
C113_177	113	177	7.4707040709727873e-10
R114_116	114	116	4.1508427136668797e+03
C114_116	114	116	2.1331060769532648e-10
R114_118	114	118	2.0731262554277173e+03
C114_118	114	118	4.2709351607595396e-10
R114_166	114	166	8.3967666318475213e-06
C114_166	114	166	1.6871613928411497e-10
R114_177	114	177	1.8531593091696866e+03
C114_177	114	177	4.7778881034071190e-10
R115_116	115	116	2.9262167991537917e+03
C115_116	115	116	3.0258140201916926e-10
R115_117	115	117	5.3471135030736482e-06
C115_117	115	117	1.8214699544645604e-10
R115_120	115	120	9.3936186203652147e-06
C115_120	115	120	1.0368322350073998e-10
R115_125	115	125	7.0166969405226846e+03
C115_125	115	125	1.2618740544237384e-10
R115_172	115	172	6.8841211844019372e+03
C115_172	115	172	1.2861754724861392e-10
R115_178	115	178	3.8068592685846961e+03
C115_178	115	178	2.3258510998994154e-10
R116_117	116	117	7.0797671013793906e+03
C116_117	116	117	1.2506326394938741e-10
R116_118	116	118	4.6788992223700270e+03
C116_118	116	118	1.8923655749343201e-10
R116_170	116	170	3.9943311024590348e+03
C116_170	116	170	2.2166884992456148e-10
R116_172	116	172	2.7119769726327168e+03
C116_172	116	172	3.2648462381318025e-10
R116_177	116	177	4.8864671891402968e+03
C116_177	116	177	1.8119814324503357e-10
R116_178	116	178	2.5157108741499778e+03
C116_178	116	178	3.5195569999639568e-10
R116_179	116	179	2.0759305426047849e+03
C116_179	116	179	4.2651657342495478e-10
R116_180	116	180	9.3694759744497496e+03
C116_180	116	180	9.4500352433210520e-11
R117_120	117	120	5.4100315368585230e-05
C117_120	117	120	3.4369105340390290e-11
R117_168	117	168	5.4100315368585230e-05
C117_168	117	168	3.4369105340390290e-11
R117_170	117	170	1.7567967649535818e+04
C117_170	117	170	5.0399613624254058e-11
R117_178	117	178	1.1534132991769877e+04
C117_178	117	178	7.6765092125414715e-11
R117_180	117	180	1.1267542585315816e+04
C117_180	117	180	7.8581356582037970e-11
R117_181	117	181	1.4590286839503899e+04
C117_181	117	181	6.0685495181814134e-11
R118_119	118	119	8.0174440055054276e+02
C118_119	118	119	1.1043654075937413e-09
R118_172	118	172	2.0035538925647732e+03
C118_172	118	172	4.4192411543597908e-10
R118_174	118	174	1.4402068614453171e+03
C118_174	118	174	6.1478583764796092e-10
R118_176	118	176	3.0917034657647405e+03
C118_176	118	176	2.8638541551752268e-10
R118_177	118	177	1.0121575370589902e+03
C118_177	118	177	8.7478356805280240e-10
R118_179	118	179	3.4087392162355750e+03
C118_179	118	179	2.5974963924574090e-10
R118_182	118	182	1.9523262463827753e+03
C118_182	118	182	4.5351988856395462e-10
R119_147	119	147	3.4740160080447240e+03
C119_147	119	147	2.5486894120512104e-10
R119_143	119	143	1.5709172258033866e+03
C119_143	119	143	5.6363172238256281e-10
R119_153	119	153	1.2292818104788978e+03
C119_153	119	153	7.2027323120893052e-10
R119_174	119	174	2.2245719542068668e+03
C119_174	119	174	3.9801759616073243e-10
R119_176	119	176	1.7726364315765766e+03
C119_176	119	176	4.9949260092353609e-10
R119_182	119	182	5.1079642076393184e+03
C119_182	119	182	1.7334083515616538e-10
R120_125	120	125	5.2348521845891273e+03
C120_125	120	125	1.6913921357829032e-10
R120_178	120	178	5.1082207106572951e+03
C120_178	120	178	1.7333213105940166e-10
R120_181	120	181	8.8115024098397244e+03
C120_181	120	181	1.0048442825269627e-10
R120_184	120	184	8.7081996261479853e+03
C120_184	120	184	1.0167644515651269e-10
R121_122	121	122	3.1674493993425790e+03
C121_122	121	122	2.7953683550044191e-10
R121_128	121	128	3.0892897474595306e+03
C121_128	121	128	2.8660917365492238e-10
R121_124	121	124	1.7590467574895647e+03
C121_124	121	124	5.0335147597988320e-10
R121_130	121	130	3.6467522402347149e+03
C121_130	121	130	2.4279652780661954e-10
R121_131	121	131	1.3810042715170099e+04
C121_131	121	131	6.4114123320370522e-11
R121_133	121	133	3.7481644322306092e+03
C121_133	121	133	2.3622730478050805e-10
R121_187	121	187	3.3246191090623392e+03
C121_187	121	187	2.6632187106381623e-10
R121_188	121	188	5.8675487579353912e+03
C121_188	121	188	1.5090096703543229e-10
R122_123	122	123	5.6333994062666284e+02
C122_123	122	123	1.5717308819166181e-09
R122_128	122	128	2.5502213862918647e+03
C122_128	122	128	3.4719290899973133e-10
R122_124	122	124	5.9094993693410640e+02
C122_124	122	124	1.4982974468084734e-09
R122_133	122	133	1.9909253330955155e+03
C122_133	122	133	4.4472726675456980e-10
R122_139	122	139	2.7568590352492033e+03
C122_139	122	139	3.2116940706036636e-10
R122_145	122	145	1.8156597657334887e+03
C122_145	122	145	4.8765677271165907e-10
R122_189	122	189	2.5794028254881764e+03
C122_189	122	189	3.4326502745162583e-10
R123_133	123	133	1.4824231749121193e+03
C123_133	123	133	5.9727802201452321e-10
R123_139	123	139	1.2901398073298922e+03
C123_139	123	139	6.8629676928773058e-10
R123_141	123	141	2.4310473813185968e+03
C123_141	123	141	3.6421288556694040e-10
R123_145	123	145	3.0026487114901297e+03
C123_145	123	145	2.9487924388617268e-10
R123_154	123	154	2.6833139978753202e+03
C123_154	123	154	3.2997211001063805e-10
R123_189	123	189	1.7887281375779887e+03
C123_189	123	189	4.9499907956884574e-10
R124_128	124	128	3.3160280700048129e+03
C124_128	124	128	2.6701184761041998e-10
R124_132	124	132	4.5360391796743743e+03
C124_132	124	132	1.9519645810545244e-10
R124_133	124	133	4.6658292186795870e+03
C124_133	124	133	1.8976665029985183e-10
R124_145	124	145	2.7996475851059172e+03
C124_145	124	145	3.1626079882711476e-10
R124_187	124	187	1.5921491708037117e+03
C124_187	124	187	5.5611546828432135e-10
R124_188	124	188	5.6237733573769756e+03
C124_188	124	188	1.5744211678419677e-10
R124_189	124	189	1.5917578975346444e+03
C124_189	124	189	5.5625216816662838e-10
R124_190	124	190	3.2153465058714032e+03
C124_190	124	190	2.7537274134628272e-10
R125_126	125	126	1.1844177940762791e+04
C125_126	125	126	7.4755612937285637e-11
R125_172	125	172	4.0276210728842602e+03
C125_172	125	172	2.1983666429323103e-10
R125_178	125	178	3.2778598026790860e+03
C125_178	125	178	2.7012100425293439e-10
R125_183	125	183	6.8428871669937043e+03
C125_183	125	183	1.2939257364504993e-10
R125_184	125	184	6.6310195667379949e+03
C125_184	125	184	1.3352679369872001e-10
R125_191	125	191	8.3338996076491821e+03
C125_191	125	191	1.0624303427981392e-10
R126_172	126	172	2.4500417902263875e+03
C126_172	126	172	3.6138925680046709e-10
R126_175	126	175	6.8400431769797678e+03
C126_175	126	175	1.2944637318663216e-10
R126_191	126	191	1.3683951768624378e+04
C126_191	126	191	6.4704903720148779e-11
R127_149	127	149	3.3671947902761311e-06
C127_149	127	149	2.8924987105250554e-10
R127_164	127	164	2.3514475012281459e+03
C127_164	127	164	3.7654201560424024e-10
R127_165	127	165	2.9302882646251005e-06
C127_165	127	165	2.5683683512169189e-10
R127_166	127	166	3.3662865683206446e-06
C127_166	127	166	2.0165278616077521e-10
R127_167	127	167	1.7941324399409050e+03
C127_167	127	167	4.9350803875390828e-10
R127_169	127	169	4.0717926674272742e-06
C127_169	127	169	3.4792293328876816e-10
R127_192	127	192	3.3482781431298499e+03
C127_192	127	192	2.6444003271255787e-10
R128_131	128	131	7.0271147853723733e+03
C128_131	128	131	1.2600032997085600e-10
R128_132	128	132	7.1503229558268749e+03
C128_132	128	132	1.2382920144585394e-10
R128_187	128	187	3.5785286202617203e+03
C128_187	128	187	2.4742537384967003e-10
R128_194	128	194	1.0251509631087278e+04
C128_194	128	194	8.6369599557806030e-11
R129_134	129	134	3.1414210641740028e+03
C129_134	129	134	2.8185294604332508e-10
R129_135	129	135	1.8838833083141483e+03
C129_135	129	135	4.6999661698385368e-10
R129_173	129	173	1.1086524205261640e+03
C129_173	129	173	7.9864416052037495e-10
R129_175	129	175	3.9146409024662876e+03
C129_175	129	175	2.2618135449976309e-10
R129_195	129	195	3.7775344511228614e+03
C129_195	129	195	2.3439065696325071e-10
R130_131	130	131	5.7800124758837546e+03
C130_131	130	131	1.5318630978640247e-10
R130_133	130	133	5.1677606788107651e+03
C130_133	130	133	1.7133509787526724e-10
R130_134	130	134	3.8513414566228530e+03
C130_134	130	134	2.2989880063150831e-10
R130_187	130	187	4.2582380724414425e+03
C130_187	130	187	2.0793078419693641e-10
R130_188	130	188	2.7704882053374040e+03
C130_188	130	188	3.1958944275388797e-10
R130_196	130	196	5.9052016922684197e+03
C130_196	130	196	1.4993878750310320e-10
R130_197	130	197	6.2346251630358611e+03
C130_197	130	197	1.4201636161697621e-10
R130_198	130	198	6.2691182419027464e+03
C130_198	130	198	1.4123497875376901e-10
R131_187	131	187	3.6981036572596004e+03
C131_187	131	187	2.3942508478957036e-10
R131_194	131	194	3.6532463458966176e+03
C131_194	131	194	2.4236492638787310e-10
R131_198	131	198	3.9882460749152360e+03
C131_198	131	198	2.2200705900997304e-10
R131_199	131	199	1.3349633285968106e+04
C131_199	131	199	6.6325326151892896e-11
R132_145	132	145	3.7572418316342987e+03
C132_145	132	145	2.3565658570208844e-10
R132_137	132	137	1.3561505723111261e+04
C132_137	132	137	6.5289120528193709e-11
R132_187	132	187	5.0416266411415336e+03
C132_187	132	187	1.7562164847247042e-10
R132_190	132	190	3.3710144060397888e+03
C132_190	132	190	2.6265648112141267e-10
R132_194	132	194	8.3448362547764482e+03
C132_194	132	194	1.0610379337200304e-10
R132_200	132	200	3.7730435699419081e+03
C132_200	132	200	2.3466964144112241e-10
R132_203	132	203	3.5694587645698593e+03
C132_203	132	203	2.4805407208750822e-10
R132_202	132	202	1.1269599357662320e+04
C132_202	132	202	7.8567014993127895e-11
R133_134	133	134	1.9413858244349701e+03
C133_134	133	134	4.5607563965689123e-10
R133_135	133	135	2.6215916640881987e+03
C133_135	133	135	3.3774092046022461e-10
R133_154	133	154	1.6078230781928758e+03
C133_154	133	154	5.5069416138445592e-10
R133_188	133	188	7.9210002030738360e+02
C133_188	133	188	1.1178118406768920e-09
R133_189	133	189	1.0637633703890062e+03
C133_189	133	189	8.3234561966183559e-10
R133_206	133	206	1.8366814360342560e+03
C133_206	133	206	4.8207531492874860e-10
R133_207	133	207	3.1778819315635724e+03
C133_207	133	207	2.7861915601891438e-10
R134_135	134	135	3.6759539182866379e+03
C134_135	134	135	2.4086775878645771e-10
R134_188	134	188	3.6057702031624599e+03
C134_188	134	188	2.4555607590396047e-10
R134_195	134	195	5.0167093990161402e+03
C134_195	134	195	1.7649393482382005e-10
R134_196	134	196	6.1111734770077501e+03
C134_196	134	196	1.4488523113134286e-10
R134_205	134	205	7.0177413229587337e+03
C134_205	134	205	1.2616862619363415e-10
R134_207	134	207	4.4661139850452755e+03
C134_207	134	207	1.9825261618149767e-10
R135_154	135	154	2.0094631611396542e+03
C135_154	135	154	4.4062454033635556e-10
R135_143	135	143	3.0082755441934823e+03
C135_143	135	143	2.9432768664061341e-10
R135_173	135	173	8.0670324599025014e+02
C135_173	135	173	1.0975768178707707e-09
R135_186	135	186	3.0098888162116559e+03
C135_186	135	186	2.9416992977648156e-10
R135_185	135	185	1.7131647287904436e+03
C135_185	135	185	5.1683225017429456e-10
R135_195	135	195	3.7027107034025703e+03
C135_195	135	195	2.3912718346760201e-10
R135_206	135	206	3.4993410694219633e+03
C135_206	135	206	2.5302443063838233e-10
R135_207	135	207	9.6367724664509558e+02
C135_207	135	207	9.1879183075294030e-10
R135_210	135	210	1.5436951684192036e+03
C135_210	135	210	5.7357100016494790e-10
R136_138	136	138	1.3136380938631266e+03
C136_138	136	138	6.7402033013230768e-10
R136_140	136	140	2.4385747720609847e+03
C136_140	136	140	3.6308863351017115e-10
R136_142	136	142	9.5456612549998010e+02
C136_142	136	142	9.2756149421941591e-10
R136_144	136	144	7.0123720206378437e+02
C136_144	136	144	1.2626523223442195e-09
R136_146	136	146	2.5783766950060476e+03
C136_146	136	146	3.4340163848631251e-10
R136_211	136	211	3.2734930632460741e+03
C136_211	136	211	2.7048133739498373e-10
R137_138	137	138	3.7787548638400299e+03
C137_138	137	138	2.3431495654106115e-10
R137_139	137	139	3.2606613285212006e+03
C137_139	137	139	2.7154576709797758e-10
R137_145	137	145	1.4038859674952666e+03
C137_145	137	145	6.3069138249149516e-10
R137_146	137	146	1.7733383326690098e+03
C137_146	137	146	4.9929489787060379e-10
R137_156	137	156	2.2018904100957302e+03
C137_156	137	156	4.0211755209992728e-10
R137_157	137	157	3.6758569488965809e+03
C137_157	137	157	2.4087411289652752e-10
R137_160	137	160	5.0092842063884073e+03
C137_160	137	160	1.7675554933992638e-10
R137_200	137	200	4.5898778198466634e+03
C137_200	137	200	1.9290683030198384e-10
R137_211	137	211	4.0182473863770242e+03
C137_211	137	211	2.2034949483245254e-10
R138_139	138	139	8.2844864988398319e+02
C138_139	138	139	1.0687672456512482e-09
R138_140	138	140	4.0640896884583544e+03
C138_140	138	140	2.1786398666705336e-10
R138_141	138	141	2.2420677798178467e+03
C138_141	138	141	3.9491169253229910e-10
R138_142	138	142	4.9796078598255463e+03
C138_142	138	142	1.7780893729471691e-10
R138_146	138	146	4.4894252427616748e+03
C138_146	138	146	1.9722319313091707e-10
R138_211	138	211	1.9405501382917644e+03
C138_211	138	211	4.5627204586397353e-10
R139_141	139	141	1.5155854833448327e+03
C139_141	139	141	5.8420906734070758e-10
R139_145	139	145	1.2192826230274654e+03
C139_145	139	145	7.2618010375766273e-10
R139_211	139	211	3.4369967582570621e+03
C139_211	139	211	2.5761408694170702e-10
R140_141	140	141	2.3968793471312733e+03
C140_141	140	141	3.6940481912855633e-10
R140_142	140	142	1.1072877249457335e+03
C140_142	140	142	7.9962846309290857e-10
R140_147	140	147	3.5649737225166923e+03
C140_147	140	147	2.4836614534003884e-10
R140_152	140	152	2.2430556874010008e+03
C140_152	140	152	3.9473776182789438e-10
R140_153	140	153	2.2055831780824087e+03
C140_153	140	153	4.0144429396211045e-10
R140_215	140	215	2.2064431642821960e+03
C140_215	140	215	4.0128782650426723e-10
R141_142	141	142	2.8495921757153324e+03
C141_142	141	142	3.1071771927424441e-10
R141_145	141	145	2.3973707651447962e+03
C141_145	141	145	3.6932909776536912e-10
R141_153	141	153	2.2119454100003727e+03
C141_153	141	153	4.0028961731919556e-10
R141_154	141	154	1.0996781320842874e+03
C141_154	141	154	8.0516176130720316e-10
R141_189	141	189	2.8759800059060981e+03
C141_189	141	189	3.0786680709939166e-10
R141_211	141	211	8.5310016339254116e+02
C141_211	141	211	1.0378837324083221e-09
R141_212	141	212	1.0489334318822359e+03
C141_212	141	212	8.4411341538726581e-10
R141_213	141	213	5.7129512456317912e+02
C141_213	141	213	1.5498448063546922e-09
R141_215	141	215	1.7983321104708775e+03
C141_215	141	215	4.9235554241878109e-10
R142_144	142	144	2.8145025589767442e+03
C142_144	142	144	3.1459157103126159e-10
R142_152	142	152	1.1260321157924966e+03
C142_152	142	152	7.8631752086115772e-10
R142_159	142	159	1.2397681226075540e+03
C142_159	142	159	7.1418095493351983e-10
R142_211	142	211	1.6127392531310281e+03
C142_211	142	211	5.4901545924489471e-10
R142_214	142	214	2.0721274553143994e+03
C142_214	142	214	4.2729938229869035e-10
R142_215	142	215	2.2923698678574606e+03
C142_215	142	215	3.8624603913832950e-10
R143_153	143	153	1.3328495556771056e+03
C143_153	143	153	6.6430511825484705e-10
R143_154	143	154	2.0838378453817063e+03
C143_154	143	154	4.2489811943011997e-10
R143_173	143	173	3.9861055141289530e+03
C143_173	143	173	2.2212627803292918e-10
R143_174	143	174	1.4215483113205930e+03
C143_174	143	174	6.2285521684272673e-10
R143_176	143	176	2.2005583274615233e+03
C143_176	143	176	4.0236096932789965e-10
R143_182	143	182	3.3069476378318031e+03
C143_182	143	182	2.6774502612945024e-10
R143_186	143	186	1.1731816141593577e+03
C143_186	143	186	7.5471586923431816e-10
R143_209	143	209	1.7968539636202911e+03
C143_209	143	209	4.9276056909826065e-10
R143_210	143	210	1.4644471896667610e+03
C143_210	143	210	6.0460956731493977e-10
R143_216	143	216	1.2252381420116444e+03
C143_216	143	216	7.2265035778782108e-10
R144_146	144	146	2.1899536174052582e+03
C144_146	144	146	4.0430937653788244e-10
R144_158	144	158	3.0696088252714489e+03
C144_158	144	158	2.8844678006217994e-10
R144_159	144	159	6.6257155557447834e+02
C144_159	144	159	1.3363368443009956e-09
R144_161	144	161	8.4476765632532454e+02
C144_161	144	161	1.0481210721910268e-09
R144_211	144	211	3.6744461610900744e+03
C144_211	144	211	2.4096659547661700e-10
R144_218	144	218	4.1325353182441495e+03
C144_218	144	218	2.1425558731248811e-10
R145_189	145	189	1.5131284671089772e+03
C145_189	145	189	5.8515770534124197e-10
R145_190	145	190	1.4324552015498150e+03
C145_190	145	190	6.1811272055282400e-10
R145_156	145	156	1.6065128567460913e+03
C145_156	145	156	5.5114329025250991e-10
R145_200	145	200	5.0684421145566839e+03
C145_200	145	200	1.7469249163506408e-10
R145_204	145	204	2.1729295350819252e+03
C145_204	145	204	4.0747698781986376e-10
R145_211	145	211	2.3512676656151857e+03
C145_211	145	211	3.7657081524503466e-10
R145_212	145	212	2.7446670546462433e+03
C145_212	145	212	3.2259606140611489e-10
R145_219	145	219	3.9268934813831816e+03
C145_219	145	219	2.2547563001075506e-10
R146_156	146	156	2.6232464491569704e+03
C146_156	146	156	3.3752786818201779e-10
R146_157	146	157	2.1567634855794272e+03
C146_157	146	157	4.1053123702255524e-10
R146_160	146	160	2.1181363236109728e+03
C146_160	146	160	4.1801784513593021e-10
R146_161	146	161	4.0979584702587854e+03
C146_161	146	161	2.1606338573852992e-10
R146_162	146	162	4.4818008418543277e+03
C146_162	146	162	1.9755870752473272e-10
R146_211	146	211	8.8400932319847641e+02
C146_211	146	211	1.0015943932541618e-09
R146_218	146	218	9.0184426649774196e+02
C146_218	146	218	9.8178678358567483e-10
R146_219	146	219	2.8811875996130348e+03
C146_219	146	219	3.0731035418135158e-10
R147_148	147	148	6.6631289915537957e+02
C147_148	147	148	1.3288333196346035e-09
R147_150	147	150	2.2599763895320229e+03
C147_150	147	150	3.9178231498398314e-10
R147_151	147	151	1.8768708950740913e+03
C147_151	147	151	4.7175263041470274e-10
R147_152	147	152	1.6702811493872696e+03
C147_152	147	152	5.3010164308254907e-10
R147_153	147	153	1.0934636142166612e+03
C147_153	147	153	8.0973776373372856e-10
R147_176	147	176	1.9893020067024397e+03
C147_176	147	176	4.4509017671364626e-10
R147_215	147	215	2.0055506805818784e+03
C147_215	147	215	4.4148412217790969e-10
R147_217	147	217	8.9601057282626880e+02
C147_217	147	217	9.8817894403538203e-10
R147_222	147	222	9.6799279148756011e+02
C147_222	147	222	9.1469563563519432e-10
R148_149	148	149	7.3204956311481083e+03
C148_149	148	149	1.2095066048979192e-10
R148_151	148	151	8.5947359082387220e+02
C148_151	148	151	1.0301873043606349e-09
R148_152	148	152	1.7494469487283548e+03
C148_152	148	152	5.0611353624846820e-10
R148_155	148	155	6.0848203428687930e+03
C148_155	148	155	1.4551272376310689e-10
R148_222	148	222	3.6870348737613699e+03
C148_222	148	222	2.4014385868738208e-10
R148_223	148	223	4.2045265089236727e+03
C148_223	148	223	2.1058703752272467e-10
R149_151	149	151	2.3699878118316969e+03
C149_151	149	151	3.7359634394730688e-10
R149_150	149	150	4.4756192431273821e+03
C149_150	149	150	1.9783157002455490e-10
R149_163	149	163	4.2162670384554558e+03
C149_163	149	163	2.1000064123650844e-10
R149_164	149	164	9.1198036151774650e+03
C149_164	149	164	9.7087483356161120e-11
R149_166	149	166	7.6079507811136844e-06
C149_166	149	166	1.2801879072533470e-10
R149_167	149	167	4.3159371078391769e+03
C149_167	149	167	2.0515099260639948e-10
R149_224	149	224	7.3385141515560254e+03
C149_224	149	224	1.2065368593889812e-10
R150_151	150	151	1.4658176075395297e+03
C150_151	150	151	6.0404430752215699e-10
R150_166	150	166	3.2036180059537596e+03
C150_166	150	166	2.7638088562821627e-10
R150_167	150	167	2.1638193509544931e+03
C150_167	150	167	4.0919256097299838e-10
R150_171	150	171	1.7589811290474356e+03
C150_171	150	171	5.0337025626846419e-10
R150_176	150	176	3.9667251182065702e+03
C150_176	150	176	2.2321152974177209e-10
R150_177	150	177	4.1239825481537100e+03
C150_177	150	177	2.1469993419259217e-10
R150_217	150	217	7.0353977090954386e+03
C150_217	150	217	1.2585198709595639e-10
R150_221	150	221	1.5877346331857623e+03
C150_221	150	221	5.5766169181774583e-10
R150_222	150	222	3.9886186041644255e+03
C150_222	150	222	2.2198632398082750e-10
R150_224	150	224	2.5935457258665938e+03
C150_224	150	224	3.4139316414178547e-10
R151_155	151	155	2.1952027848052194e+03
C151_155	151	155	4.0334259223280070e-10
R151_163	151	163	1.9822379364338221e+03
C151_163	151	163	4.4667633760098818e-10
R151_222	151	222	9.2209134135108809e+02
C151_222	151	222	9.6022892960110238e-10
R151_223	151	223	1.1230640815354232e+03
C151_223	151	223	7.8839560115704104e-10
R151_224	151	224	1.0876076342512565e+03
C151_224	151	224	8.1409761555190849e-10
R152_155	152	155	2.5059583117586785e+03
C152_155	152	155	3.5332542346987980e-10
R152_158	152	158	1.9019457858735971e+03
C152_158	152	158	4.6553313363414929e-10
R152_159	152	159	2.7251034931997715e+03
C152_159	152	159	3.2491198367675795e-10
R152_214	152	214	9.7700930262473901e+02
C152_214	152	214	9.0625419770448399e-10
R152_215	152	215	1.1482367676878969e+03
C152_215	152	215	7.7111167889431902e-10
R152_222	152	222	1.5234929382250630e+03
C152_222	152	222	5.8117682037407574e-10
R152_223	152	223	1.2750818123575962e+03
C152_223	152	223	6.9440154593914401e-10
R152_225	152	225	2.9395280967524027e+03
C152_225	152	225	3.0121119872207141e-10
R153_154	153	154	1.6193722028521877e+03
C153_154	153	154	5.4676669152435646e-10
R153_176	153	176	3.4150149275818835e+03
C153_176	153	176	2.5927230201800335e-10
R153_213	153	213	3.4153074110165303e+03
C153_213	153	213	2.5925009820315540e-10
R153_215	153	215	1.5833826020963058e+03
C153_215	153	215	5.5919446160880965e-10
R153_216	153	216	1.6092390212265320e+03
C153_216	153	216	5.5020961461967905e-10
R153_217	153	217	3.3335242019910752e+03
C153_217	153	217	2.6561042549838082e-10
R153_226	153	226	4.8679467189661527e+03
C153_226	153	226	1.8188752523734362e-10
R154_189	154	189	1.6262897877531111e+03
C154_189	154	189	5.4444096517589178e-10
R154_206	154	206	5.5597958298714218e+02
C154_206	154	206	1.5925383031924687e-09
R154_210	154	210	1.2685292676138240e+03
C154_210	154	210	6.9798845348323978e-10
R154_212	154	212	1.9407151207744425e+03
C154_212	154	212	4.5623325763890252e-10
R154_213	154	213	1.0181811331318336e+03
C154_213	154	213	8.6960831711400047e-10
R154_216	154	216	2.6044700895583578e+03
C154_216	154	216	3.3996120180060935e-10
R154_226	154	226	1.4407650837496440e+03
C154_226	154	226	6.1454763978293048e-10
R155_158	155	158	7.5584566961227401e+03
C155_158	155	158	1.1714280008433376e-10
R155_163	155	163	5.4088983393249609e+03
C155_163	155	163	1.6369669499288498e-10
R155_223	155	223	9.2087663531905855e+02
C155_223	155	223	9.6149554428995452e-10
R155_227	155	227	8.7147856377667940e+03
C155_227	155	227	1.0159960537215152e-10
R155_228	155	228	6.6830054908985667e+03
C155_228	155	228	1.3248811225814967e-10
R156_157	156	157	5.1700205327728565e+02
C156_157	156	157	1.7126020604508508e-09
R156_200	156	200	1.9335309901611456e+03
C156_200	156	200	4.5792841501144328e-10
R156_190	156	190	4.1600326169673681e+03
C156_190	156	190	2.1283938450113969e-10
R156_203	156	203	5.0212335050494275e+03
C156_203	156	203	1.7633491467975144e-10
R156_204	156	204	1.3168538159855841e+03
C156_204	156	204	6.7237439034743461e-10
R156_211	156	211	3.3255051692328611e+03
C156_211	156	211	2.6625091125756740e-10
R156_219	156	219	5.0065988357465136e+02
C156_219	156	219	1.7685035505106109e-09
R156_229	156	229	1.0369339302479823e+03
C156_229	156	229	8.5388157902042269e-10
R157_160	157	160	1.3223467352349637e+03
C157_160	157	160	6.6958140259836829e-10
R157_200	157	200	3.4746624918892362e+03
C157_200	157	200	2.5482152115976647e-10
R157_218	157	218	5.1808289979526862e+03
C157_218	157	218	1.7090291573991188e-10
R157_219	157	219	2.0894117008011203e+03
C157_219	157	219	4.2376463258079471e-10
R157_229	157	229	1.3583300610220906e+03
C157_229	157	229	6.5184361820996346e-10
R157_231	157	231	7.1608690282900980e+03
C157_231	157	231	1.2364683367368108e-10
R157_233	157	233	1.5934099849388649e+03
C157_233	157	233	5.5567543197865128e-10
R158_159	158	159	1.9696922739056063e+03
C158_159	158	159	4.4952137622205662e-10
R158_161	158	161	6.0149674835697051e+03
C158_161	158	161	1.4720258822987521e-10
R158_214	158	214	4.4123186767793350e+03
C158_214	158	214	2.0066972640931053e-10
R158_223	158	223	6.6766390145694313e+03
C158_223	158	223	1.3261444564666188e-10
R158_228	158	228	5.6576419691859883e+03
C158_228	158	228	1.5649961353552963e-10
R158_235	158	235	6.7194416121051172e+03
C158_235	158	235	1.3176969647372373e-10
R159_161	159	161	5.2070208819824511e+03
C159_161	159	161	1.7004325539844922e-10
R159_211	159	211	8.8193350439222722e+03
C159_211	159	211	1.0039518595114207e-10
R159_214	159	214	3.5876141789926128e+03
C159_214	159	214	2.4679877420615563e-10
R159_218	159	218	5.4680781363924807e+03
C159_218	159	218	1.6192504196440541e-10
R159_235	159	235	7.0340279819344023e+03
C159_235	159	235	1.2587649409044637e-10
R160_162	160	162	1.3592043066516075e+04
C160_162	160	162	6.5142434979567163e-11
R160_200	160	200	2.6593119233644265e+04
C160_200	160	200	3.3295032971529457e-11
R160_218	160	218	1.1304163115294199e+04
C160_218	160	218	7.8326787456035079e-11
R160_231	160	231	1.9492545990513780e+04
C160_231	160	231	4.5423454798100607e-11
R160_233	160	233	6.0524465139173781e+03
C160_233	160	233	1.4629105431398889e-10
R160_234	160	234	1.6901384479686338e+04
C160_234	160	234	5.2387352217457617e-11
R160_236	160	236	1.9863151684048600e+04
C160_236	160	236	4.4575946243770006e-11
R161_162	161	162	4.0237787785568034e+03
C161_162	161	162	2.2004658566681210e-10
R161_218	161	218	3.3599073977301159e+03
C161_218	161	218	2.6352475734842291e-10
R161_235	161	235	6.9028467232993171e+03
C161_235	161	235	1.2826864295152728e-10
R161_236	161	236	1.0327557296142762e+04
C161_236	161	236	8.5733611183226756e-11
R162_218	162	218	3.1108789803311956e+04
C162_218	162	218	2.8462013061200315e-11
R162_234	162	234	9.0009365582589860e+04
C162_234	162	234	9.8369628090264337e-12
R162_236	162	236	3.0001623641631446e+04
C162_236	162	236	2.9512362140006241e-11
R163_164	163	164	8.4819704122676103e+03
C163_164	163	164	1.0438833651428503e-10
R163_167	163	167	1.6624021560625231e+04
C163_167	163	167	5.3261407203486544e-11
R163_193	163	193	1.3662659775384915e+04
C163_193	163	193	6.4805740335801896e-11
R163_223	163	223	1.3269064137604968e+04
C163_223	163	223	6.6728050487802971e-11
R163_224	163	224	3.2260763465626028e+03
C163_224	163	224	2.7445685922573328e-10
R163_227	163	227	1.6337275030617289e+04
C163_227	163	227	5.4196234074572311e-11
R163_237	163	237	1.8516849137570283e+04
C163_237	163	237	4.7816924743611193e-11
R164_165	164	165	4.6609288753479350e+03
C164_165	164	165	1.8996616455210423e-10
R164_167	164	167	1.9294956567501420e+03
C164_167	164	167	4.5888612322212474e-10
R164_192	164	192	2.7048073779411261e+03
C164_192	164	192	3.2735003199154702e-10
R164_193	164	193	1.0249233752329199e+03
C164_193	164	193	8.6388778234156617e-10
R164_237	164	237	5.0868027105922247e+03
C164_237	164	237	1.7406194658509102e-10
R164_238	164	238	3.1550726045315569e+03
C164_238	164	238	2.8063340933210018e-10
R165_169	165	169	1.7731628665217076e-05
C165_169	165	169	5.4927873647985392e-11
R165_192	165	192	5.4050395980624735e+03
C165_192	165	192	1.6381356059211725e-10
R165_238	165	238	1.7731628682948703e+04
C165_238	165	238	4.9934430589077630e-11
R166_167	166	167	3.5205488135347027e+03
C166_167	166	167	2.5150021448247485e-10
R166_168	166	168	1.1672367648652473e-05
C166_168	166	168	1.2136955339635350e-10
R166_169	166	169	7.0347985788288951e-06
C166_169	166	169	1.3844897589920442e-10
R166_170	166	170	4.4410332129745384e+03
C166_170	166	170	1.9937224948312412e-10
R166_171	166	171	3.3701714544146621e+03
C166_171	166	171	2.6272217709878538e-10
R166_177	166	177	4.1884230294296167e+03
C166_177	166	177	2.1139669404897176e-10
R166_242	166	242	7.1636417340237576e+03
C166_242	166	242	1.2359897585256092e-10
R167_169	167	169	1.0077079647642848e+04
C167_169	167	169	8.7864620769084667e-11
R167_171	167	171	4.3521320963059507e+03
C167_171	167	171	2.0344483166113809e-10
R167_192	167	192	3.6957782676210022e+03
C167_192	167	192	2.3957573143855034e-10
R167_193	167	193	1.4035706530864547e+03
C167_193	167	193	6.3083306832681505e-10
R167_221	167	221	4.7411942226841102e+03
C167_221	167	221	1.8675016042661550e-10
R167_224	167	224	3.5519495073214857e+03
C167_224	167	224	2.4927684919927016e-10
R167_241	167	241	3.6400311050135356e+03
C167_241	167	241	2.4324483944120241e-10
R167_242	167	242	7.4156893288238052e+03
C167_242	167	242	1.1939804142798891e-10
R168_169	168	169	2.5799153713912419e-05
C168_169	168	169	3.7751651457110497e-11
R168_170	168	170	3.7803199996728158e+03
C168_170	168	170	2.3421794498260262e-10
R168_180	168	180	1.1206157217301901e+04
C168_180	168	180	7.9011811500640505e-11
R168_242	168	242	9.5825091623153821e+03
C168_242	168	242	9.2399471443454380e-11
R169_192	169	192	7.7720756641455164e+03
C169_192	169	192	1.1392307794745915e-10
R169_242	169	242	1.3690738763877460e+04
C169_242	169	242	6.4672827154963103e-11
R170_177	170	177	2.9349981010186079e+03
C170_177	170	177	3.0167610036705321e-10
R170_171	170	171	3.6901124960375159e+03
C170_171	170	171	2.3994357425438188e-10
R170_179	170	179	3.5948559377811216e+03
C170_179	170	179	2.4630160346467553e-10
R170_180	170	180	2.3125578493908083e+03
C170_180	170	180	3.8287421952849487e-10
R170_242	170	242	5.7132734610272528e+03
C170_242	170	242	1.5497573986959147e-10
R170_243	170	243	2.5669608722834378e+03
C170_243	170	243	3.4492881884575691e-10
R171_177	171	177	4.0126687246052734e+03
C171_177	171	177	2.2065583841265115e-10
R171_176	171	176	1.5317866333519109e+04
C171_176	171	176	5.7803010055159889e-11
R171_221	171	221	8.9068259285071672e+03
C171_221	171	221	9.9409013806605414e-11
R171_241	171	241	1.0789657775769168e+04
C171_241	171	241	8.2061804007206417e-11
R171_242	171	242	8.0912639430380450e+03
C171_242	171	242	1.0942898265750431e-10
R171_243	171	243	4.0480543723008009e+03
C171_243	171	243	2.1872699827318598e-10
R171_245	171	245	7.8826451702845234e+03
C171_245	171	245	1.1232508410219878e-10
R172_174	172	174	3.7694731950534574e+03
C172_174	172	174	2.3489191616003608e-10
R172_175	172	175	5.6869136498872867e+03
C172_175	172	175	1.5569407875879190e-10
R172_178	172	178	1.5460881735016794e+03
C172_178	172	178	5.7268323817175765e-10
R172_179	172	179	2.3381048537724464e+03
C172_179	172	179	3.7869079321716877e-10
R172_182	172	182	2.5162890376618229e+03
C172_182	172	182	3.5187483172551029e-10
R172_183	172	183	9.0685851248196877e+02
C172_183	172	183	9.7635824057791485e-10
R172_191	172	191	3.8663025113202580e+03
C172_191	172	191	2.2900918360825544e-10
R172_247	172	247	3.4933492056151440e+03
C172_247	172	247	2.5345842330242695e-10
R173_174	173	174	4.5183792879735784e+03
C173_174	173	174	1.9595937509201368e-10
R173_175	173	175	2.9597513565822496e+03
C173_175	173	175	2.9915309599602005e-10
R173_186	173	186	3.6035535841996389e+03
C173_186	173	186	2.4570712243110839e-10
R173_185	173	185	2.5399346454760380e+03
C173_185	173	185	3.4859904103322068e-10
R173_195	173	195	9.0238696240237132e+03
C173_195	173	195	9.8119633659467140e-11
R173_247	173	247	9.8637702416904049e+03
C173_247	173	247	8.9764741068042286e-11
R174_175	174	175	1.0671346206462438e+04
C174_175	174	175	8.2971610569976747e-11
R174_182	174	182	3.7319388215820541e+03
C174_182	174	182	2.3725436670600375e-10
R174_186	174	186	5.1571269859570966e+03
C174_186	174	186	1.7168838078081137e-10
R174_247	174	247	8.0953894751407142e+03
C174_247	174	247	1.0937321600386741e-10
R175_191	175	191	1.0358439691121037e+04
C175_191	175	191	8.5478007122921797e-11
R175_195	175	195	9.1357745757703397e+03
C175_195	175	195	9.6917757148724364e-11
R175_185	175	185	5.7034175072253665e+03
C175_185	175	185	1.5524355013083094e-10
R175_247	175	247	3.0161757701451729e+03
C175_247	175	247	2.9355675835078519e-10
R175_249	175	249	5.9306292611354838e+03
C175_249	175	249	1.4929592505508882e-10
R176_177	176	177	2.1508498107791788e+03
C176_177	176	177	4.1165997609997857e-10
R176_182	176	182	2.5917834698705528e+03
C176_182	176	182	3.4162529084430904e-10
R176_209	176	209	2.1370654139116059e+03
C176_209	176	209	4.1431524554008017e-10
R176_216	176	216	2.5025175190047339e+03
C176_216	176	216	3.5381122208972044e-10
R176_217	176	217	2.5558279225427877e+03
C176_217	176	217	3.4643129683750340e-10
R176_221	176	221	6.2755619940951219e+03
C176_221	176	221	1.4108995856197724e-10
R176_240	176	240	3.5852699757264704e+03
C176_240	176	240	2.4696014182881470e-10
R176_245	176	245	3.9912666832572718e+03
C176_245	176	245	2.2183904308228535e-10
R176_250	176	250	8.1378122841363047e+03
C176_250	176	250	1.0880304813936522e-10
R177_179	177	179	1.1902186291754658e+03
C177_179	177	179	7.4391272325604727e-10
R177_182	177	182	2.9426051720844298e+03
C177_182	177	182	3.0089622287749979e-10
R177_243	177	243	2.5334461184664451e+03
C177_243	177	243	3.4949185429527318e-10
R177_245	177	245	4.0116983498645627e+03
C177_245	177	245	2.2070921202983577e-10
R177_250	177	250	3.1007315314541866e+03
C177_250	177	250	2.8555157798029519e-10
R178_179	178	179	3.4384920396126759e+03
C178_179	178	179	2.5750205947829881e-10
R178_180	178	180	6.4424712514896491e+03
C178_180	178	180	1.3743465001807666e-10
R178_181	178	181	2.5106811688183520e+03
C178_181	178	181	3.5266078094524489e-10
R178_183	178	183	2.0470742496372093e+03
C178_183	178	183	4.3252890404777339e-10
R178_184	178	184	5.9816063313783598e+03
C178_184	178	184	1.4802357972895395e-10
R178_251	178	251	6.3749653398959972e+03
C178_251	178	251	1.3888997578682448e-10
R179_180	179	180	7.1189271284195784e+03
C179_180	179	180	1.2437531185918537e-10
R179_182	179	182	5.0675898876938545e+03
C179_182	179	182	1.7472187002546372e-10
R179_183	179	183	4.9635337738189755e+03
C179_183	179	183	1.7838476014211802e-10
R179_243	179	243	8.8866152501831257e+03
C179_243	179	243	9.9635098040477688e-11
R179_250	179	250	3.6684459988177005e+03
C179_250	179	250	2.4136072385564914e-10
R179_251	179	251	1.5617996555864958e+04
C179_251	179	251	5.6692212636421827e-11
R180_181	180	181	3.8777445167756300e+03
C180_181	180	181	2.2833344947547794e-10
R180_242	180	242	4.7450697879420250e+03
C180_242	180	242	1.8659763107172619e-10
R180_243	180	243	1.8132733272480730e+03
C180_243	180	243	4.8829857495547123e-10
R180_244	180	244	2.6070590048742511e+03
C180_244	180	244	3.3962360654077614e-10
R180_250	180	250	3.9699936717782516e+03
C180_250	180	250	2.2302775644057904e-10
R180_251	180	251	3.2842409410488494e+03
C180_251	180	251	2.6959617080263121e-10
R181_184	181	184	9.1975341484991604e+03
C181_184	181	184	9.6266974104627948e-11
R181_251	181	251	1.0543365619476581e+04
C181_251	181	251	8.3978761019572443e-11
R182_183	182	183	5.6633546510226251e+03
C182_183	182	183	1.5634175082786331e-10
R182_186	182	186	4.6252197563238942e+03
C182_186	182	186	1.9143280283912979e-10
R182_209	182	209	5.0927185950084440e+03
C182_209	182	209	1.7385974999047282e-10
R182_247	182	247	4.4543617312049437e+03
C182_247	182	247	1.9877567991328950e-10
R182_250	182	250	6.0962655360711105e+03
C182_250	182	250	1.4523953664108769e-10
R182_252	182	252	5.8225849897621401e+03
C182_252	182	252	1.5206627009426799e-10
R183_184	183	184	1.5224766109173965e+04
C183_184	183	184	5.8156478421463203e-11
R183_191	183	191	3.9164059864906794e+03
C183_191	183	191	2.2607941688225870e-10
R183_247	183	247	5.3807980862545965e+03
C183_247	183	247	1.6455157162686102e-10
R183_250	183	250	1.2025855907342122e+04
C183_250	183	250	7.3626258997451225e-11
R183_251	183	251	6.0472144676764810e+03
C183_251	183	251	1.4641762524427283e-10
R183_252	183	252	7.6354272281390686e+03
C183_252	183	252	1.1596191742053930e-10
R183_253	183	253	1.2158356975622919e+04
C183_253	183	253	7.2823884302396585e-11
R184_191	184	191	2.1180259703746273e+04
C184_191	184	191	4.1803962467154787e-11
R184_251	184	251	1.5567586035155227e+04
C184_251	184	251	5.6875791770189583e-11
R184_254	184	254	6.0372608305295696e+04
C184_254	184	254	1.4665902410950397e-11
R185_186	185	186	1.3433483645335307e+03
C185_186	185	186	6.5911330603172030e-10
R185_195	185	195	1.4971864715094659e+03
C185_195	185	195	5.9138844662904243e-10
R185_207	185	207	2.1478415822620932e+03
C185_207	185	207	4.1223653970209598e-10
R185_205	185	205	2.9143323665541102e+03
C185_205	185	205	3.0381530667585253e-10
R185_210	185	210	3.2420026443098036e+03
C185_210	185	210	2.7310859331161916e-10
R185_247	185	247	2.4649067423723891e+03
C185_247	185	247	3.5920985020626565e-10
R185_248	185	248	2.2833052163021257e+03
C185_248	185	248	3.8777942404649671e-10
R185_249	185	249	4.0638644323179492e+03
C185_249	185	249	2.1787606266062727e-10
R185_256	185	256	1.3707229704261524e+03
C185_256	185	256	6.4595020350809964e-10
R186_209	186	209	1.1576183490644401e+03
C186_209	186	209	7.6486242846407445e-10
R186_210	186	210	1.9465746409540855e+03
C186_210	186	210	4.5485991806922172e-10
R186_247	186	247	2.0011835233416714e+03
C186_247	186	247	4.4244756733829480e-10
R186_252	186	252	7.9227311628456982e+03
C186_252	186	252	1.1175676209389064e-10
R186_256	186	256	2.5077884582012607e+03
C186_256	186	256	3.5306757186970894e-10
R186_258	186	258	6.8891521465754631e+03
C186_258	186	258	1.2852362131966180e-10
R187_188	187	188	1.2061786794747529e+03
C187_188	187	188	7.3406933546990535e-10
R187_189	187	189	2.1735912368453437e+03
C187_189	187	189	4.0735294046596300e-10
R187_190	187	190	1.0514708936491161e+03
C187_190	187	190	8.4207635898238273e-10
R187_194	187	194	1.0939147019048030e+03
C187_194	187	194	8.0940385951321884e-10
R187_197	187	197	9.7984797517080244e+02
C187_197	187	197	9.0362873030957466e-10
R187_198	187	198	3.0773692063370549e+03
C187_198	187	198	2.8771938702600470e-10
R187_201	187	201	1.6569006836881551e+03
C187_201	187	201	5.3438253144365565e-10
R187_203	187	203	2.5543337306478402e+03
C187_203	187	203	3.4663394648726523e-10
R187_255	187	255	2.9121193037604758e+03
C187_255	187	255	3.0404619088120521e-10
R187_259	187	259	1.3447028959155650e+03
C187_259	187	259	6.5844937524072687e-10
R188_189	188	189	1.2539476823576997e+03
C188_189	188	189	7.0610504262443882e-10
R188_196	188	196	1.5514292637863944e+03
C188_196	188	196	5.7071166721392157e-10
R188_197	188	197	2.5610432355174066e+03
C188_197	188	197	3.4572582353187768e-10
R188_205	188	205	3.0839650740825819e+03
C188_205	188	205	2.8710402369371660e-10
R188_206	188	206	2.2674409525965671e+03
C188_206	188	206	3.9049254212598570e-10
R188_207	188	207	1.6628766602831245e+03
C188_207	188	207	5.3246208985171944e-10
R188_208	188	208	7.0271280526369208e+02
C188_208	188	208	1.2600009208139413e-09
R188_259	188	259	2.0041650971244633e+03
C188_259	188	259	4.4178934308874135e-10
R189_190	189	190	1.8730096778709549e+03
C189_190	189	190	4.7272515041484109e-10
R189_204	189	204	5.1163622762238656e+03
C189_204	189	204	1.7305631108543862e-10
R189_206	189	206	1.4815169573315500e+03
C189_206	189	206	5.9764336636063995e-10
R189_208	189	208	4.0677696786142787e+03
C189_208	189	208	2.1766689160277771e-10
R189_212	189	212	1.7153555472410728e+03
C189_212	189	212	5.1617216216432882e-10
R189_259	189	259	5.2083752104727091e+03
C189_259	189	259	1.6999903922429584e-10
R189_260	189	260	2.5040808800161253e+03
C189_260	189	260	3.5359032879732642e-10
R190_200	190	200	5.8069989110064516e+03
C190_200	190	200	1.5247441841633512e-10
R190_203	190	203	1.0649688822909241e+03
C190_203	190	203	8.3140343011273502e-10
R190_204	190	204	1.0622301842413237e+03
C190_204	190	204	8.3354699841484190e-10
R190_255	190	255	4.1566873899537250e+03
C190_255	190	255	2.1301067379759271e-10
R190_259	190	259	3.6974905267572467e+03
C190_259	190	259	2.3946478707452569e-10
R190_260	190	260	3.7338552644731876e+03
C190_260	190	260	2.3713259325409994e-10
R190_261	190	261	1.6873577182428942e+03
C190_261	190	261	5.2473685462618926e-10
R191_247	191	247	2.0712251059951318e+03
C191_247	191	247	4.2748553942165344e-10
R191_249	191	249	4.7434863363982586e+03
C191_249	191	249	1.8665992034295617e-10
R191_251	191	251	5.6058535214420635e+03
C191_251	191	251	1.5794540087665952e-10
R191_253	191	253	2.2583998394819182e+03
C191_253	191	253	3.9205581147363036e-10
R191_254	191	254	5.0391641989013269e+03
C191_254	191	254	1.7570746789577629e-10
R191_263	191	263	7.8165664283257647e+03
C191_263	191	263	1.1327464428516964e-10
R192_193	192	193	3.6185543304377038e+03
C192_193	192	193	2.4468854156817342e-10
R192_238	192	238	4.3187558514053444e+03
C192_238	192	238	2.0501709570173559e-10
R192_241	192	241	7.4752379383434745e+03
C192_241	192	241	1.1844690282811390e-10
R192_242	192	242	7.3596965526813956e+03
C192_242	192	242	1.2030642504919731e-10
R192_265	192	265	6.7273111210361312e+03
C192_265	192	265	1.3161555423404131e-10
R193_224	193	224	2.1712394677259940e+03
C193_224	193	224	4.0779416313177401e-10
R193_221	193	221	3.6465611203048088e+03
C193_221	193	221	2.4280925301643919e-10
R193_237	193	237	9.4615053327866110e+02
C193_237	193	237	9.3581174512663485e-10
R193_238	193	238	2.8958214630860416e+03
C193_238	193	238	3.0575737937808503e-10
R193_241	193	241	1.2250004992277293e+03
C193_241	193	241	7.2279054764319691e-10
R193_265	193	265	3.4022786876719783e+03
C193_265	193	265	2.6024287337432996e-10
R194_198	194	198	4.7887510727210110e+03
C194_198	194	198	1.8489555382065355e-10
R194_197	194	197	8.1149247747050176e+03
C194_197	194	197	1.0910991861069785e-10
R194_199	194	199	5.9594743305768161e+03
C194_199	194	199	1.4857330237284545e-10
R194_201	194	201	1.5090537540771140e+03
C194_201	194	201	5.8673773502620655e-10
R194_202	194	202	5.4493664125653841e+03
C194_202	194	202	1.6248105094536551e-10
R194_203	194	203	7.1021041003535202e+03
C194_203	194	203	1.2466992446026335e-10
R194_266	194	266	8.6211451467001461e+03
C194_266	194	266	1.0270315214898167e-10
R195_205	195	205	1.1103601785060905e+03
C195_205	195	205	7.9741582852085647e-10
R195_196	195	196	8.8429993981429016e+03
C195_196	195	196	1.0012652289515533e-10
R195_207	195	207	3.4036720173930403e+03
C195_207	195	207	2.6013634015717091e-10
R195_248	195	248	3.6226031461821967e+03
C195_248	195	248	2.4441506451876427e-10
R195_249	195	249	4.4638467802547921e+03
C195_249	195	249	1.9835330944075575e-10
R195_272	195	272	5.6330067783356862e+03
C195_272	195	272	1.5718404336122663e-10
R195_273	195	273	8.8845291551533101e+03
C195_273	195	273	9.9658492446550071e-11
R196_197	196	197	2.1915779586875806e+03
C196_197	196	197	4.0400971281451934e-10
R196_198	196	198	7.8285860796146890e+03
C196_198	196	198	1.1310072760208814e-10
R196_205	196	205	2.3557170902400517e+03
C196_205	196	205	3.7585955689177190e-10
R196_208	196	208	4.5972719215077814e+03
C196_208	196	208	1.9259656527117207e-10
R196_259	196	259	6.0249104730794434e+03
C196_259	196	259	1.4695965784989435e-10
R196_267	196	267	3.3002490712425301e+03
C196_267	196	267	2.6828847235055615e-10
R196_273	196	273	5.2796980925738198e+03
C196_273	196	273	1.6770254021634104e-10
R196_274	196	274	5.7236309921215152e+03
C196_274	196	274	1.5469529445884345e-10
R197_198	197	198	1.4760097148780353e+03
C197_198	197	198	5.9987327507066121e-10
R197_201	197	201	2.6043005810115073e+03
C197_201	197	201	3.3998332917320335e-10
R197_259	197	259	1.7220113340243950e+03
C197_259	197	259	5.1417709291770357e-10
R197_267	197	267	7.0866967235296370e+03
C197_267	197	267	1.2494097267633653e-10
R197_268	197	268	1.9850417253201449e+03
C197_268	197	268	4.4604542584977698e-10
R197_274	197	274	4.4525922111365426e+03
C197_274	197	274	1.9885467604364182e-10
R197_275	197	275	9.8969199240461894e+03
C197_275	197	275	8.9464074529766576e-11
R198_199	198	199	3.9290345195787545e+03
C198_199	198	199	2.2535276218314542e-10
R198_201	198	201	3.3026749840163943e+03
C198_201	198	201	2.6809140650686712e-10
R198_274	198	274	5.6621600849195283e+03
C198_274	198	274	1.5637473480451476e-10
R198_275	198	275	4.2070033608843733e+03
C198_275	198	275	2.1046305546898166e-10
R199_201	199	201	4.1102458767258095e+03
C199_201	199	201	2.1541747337152440e-10
R199_266	199	266	3.4116343517565233e+03
C199_266	199	266	2.5952921398042876e-10
R199_275	199	275	3.7181427584331759e+03
C199_275	199	275	2.3813469229812879e-10
R199_276	199	276	1.2483096016440819e+04
C199_276	199	276	7.0929421718287057e-11
R200_203	200	203	1.1924608602796065e+03
C200_203	200	203	7.4251391487380866e-10
R200_202	200	202	6.4568136472784436e+03
C200_202	200	202	1.3712936907714621e-10
R200_229	200	229	1.3387401802803254e+03
C200_229	200	229	6.6138209246442287e-10
R200_230	200	230	2.3513269020980401e+03
C200_230	200	230	3.7656132837588817e-10
R200_231	200	231	2.6468579850762148e+03
C200_231	200	231	3.3451692032298630e-10
R200_277	200	277	4.5022124114482294e+03
C200_277	200	277	1.9666304047506877e-10
R201_202	201	202	2.1930153963135335e+03
C201_202	201	202	4.0374489991652228e-10
R201_203	201	203	3.4004529363644415e+03
C201_203	201	203	2.6038260145621547e-10
R201_255	201	255	7.2093150192801238e+02
C201_255	201	255	1.2281593734385215e-09
R201_259	201	259	2.8036020830123421e+03
C201_259	201	259	3.1581471103369205e-10
R201_266	201	266	1.4409476407056011e+03
C201_266	201	266	6.1446978133530867e-10
R201_268	201	268	2.1733888578665615e+03
C201_268	201	268	4.0739087186134903e-10
R201_270	201	270	1.4430219429947520e+03
C201_270	201	270	6.1358649880434979e-10
R201_275	201	275	2.3635539782954161e+03
C201_275	201	275	3.7461331106918902e-10
R201_271	201	271	2.7045580392340999e+03
C201_271	201	271	3.2738021105686475e-10
R201_279	201	279	2.9270700953043920e+03
C201_279	201	279	3.0249319383242290e-10
R202_203	202	203	7.8552441354068242e+02
C202_203	202	203	1.1271690178400090e-09
R202_255	202	255	2.8672008382892841e+03
C202_255	202	255	3.0880947364269229e-10
R202_266	202	266	3.3482421360173353e+03
C202_266	202	266	2.6444287650987733e-10
R202_277	202	277	2.1170175477703688e+03
C202_277	202	277	4.1823875415322765e-10
R202_279	202	279	1.1513513731672074e+03
C202_279	202	279	7.6902568784396057e-10
R202_239	202	239	4.7311011556143958e+03
C202_239	202	239	1.8714856279267545e-10
R203_204	203	204	1.4813193508332099e+03
C203_204	203	204	5.9772309137929730e-10
R203_229	203	229	3.0214034303832573e+03
C203_229	203	229	2.9304884372481398e-10
R203_230	203	230	1.9308204145674736e+03
C203_230	203	230	4.5857127624080162e-10
R203_255	203	255	9.3389561851898964e+02
C203_255	203	255	9.4809180398997262e-10
R203_261	203	261	2.3064471696949931e+03
C203_261	203	261	3.8388860292737112e-10
R203_277	203	277	3.4147088945478245e+03
C203_277	203	277	2.5929553851976222e-10
R203_278	203	278	1.8258908267883210e+03
C203_278	203	278	4.8492427296840154e-10
R203_279	203	279	2.5323303061862430e+03
C203_279	203	279	3.4964584972861005e-10
R203_280	203	280	2.0123207665269240e+03
C203_280	203	280	4.3999882942526580e-10
R204_212	204	212	1.2770852767690467e+03
C204_212	204	212	6.9331218345893023e-10
R204_219	204	219	7.3472217659454066e+02
C204_219	204	219	1.2051069232780511e-09
R204_220	204	220	3.6604687237446979e+02
C204_220	204	220	2.4188672230866852e-09
R204_229	204	229	1.2134670628916476e+03
C204_229	204	229	7.2966033341694452e-10
R204_230	204	230	2.6406358455291461e+03
C204_230	204	230	3.3530514372100960e-10
R204_260	204	260	1.4802653990529136e+03
C204_260	204	260	5.9814867135751352e-10
R204_261	204	261	1.6283273546423904e+03
C204_261	204	261	5.4375969253089997e-10
R204_278	204	278	3.4667141726727846e+03
C204_278	204	278	2.5540576395929275e-10
R204_280	204	280	3.1494333796307251e+03
C204_280	204	280	2.8113589810361902e-10
R205_207	205	207	5.0036755897405777e+02
C205_207	205	207	1.7695367451787694e-09
R205_208	205	208	1.3634808399587589e+03
C205_208	205	208	6.4938116895487976e-10
R205_248	205	248	2.0475981631913344e+03
C205_248	205	248	4.3241823401521763e-10
R205_256	205	256	2.1580308685172063e+03
C205_256	205	256	4.1029013746609457e-10
R205_262	205	262	1.3059682177534862e+03
C205_262	205	262	6.7797881270272336e-10
R205_267	205	267	1.7934274805543921e+03
C205_267	205	267	4.9370202659451583e-10
R205_272	205	272	4.9602064449609998e+03
C205_272	205	272	1.7850442144388646e-10
R205_273	205	273	2.3503125058607752e+03
C205_273	205	273	3.7672385246306878e-10
R205_283	205	283	2.1815943208439357e+03
C205_283	205	283	4.0585858389908235e-10
R206_207	206	207	6.6991670710333153e+02
C206_207	206	207	1.3216848786000321e-09
R206_208	206	208	7.7904307874244159e+02
C206_208	206	208	1.1365466247762240e-09
R206_210	206	210	1.0287168462440918e+03
C206_210	206	210	8.6070213094372696e-10
R206_212	206	212	1.1733541729822532e+03
C206_212	206	212	7.5460487727211766e-10
R206_213	206	213	2.5773562065737847e+03
C206_213	206	213	3.4353760626554365e-10
R206_226	206	226	8.9538739510901178e+02
C206_226	206	226	9.8886670343645165e-10
R206_260	206	260	1.1831719183486564e+03
C206_260	206	260	7.4834330325872863e-10
R206_283	206	283	1.6440879556004945e+03
C206_283	206	283	5.3854708848384311e-10
R207_208	207	208	9.8574444881789270e+02
C207_208	207	208	8.9822345209429939e-10
R207_210	207	210	1.1278369608401870e+03
C207_210	207	210	7.8505919954990966e-10
R207_256	207	256	2.3751314760797404e+03
C207_256	207	256	3.7278727119621308e-10
R207_283	207	283	1.8237065592632571e+03
C207_283	207	283	4.8550507054034640e-10
R208_259	208	259	1.1867565631577270e+03
C208_259	208	259	7.4608290291993326e-10
R208_260	208	260	2.4753455892350048e+03
C208_260	208	260	3.5769501662740960e-10
R208_267	208	267	2.1838577676255236e+03
C208_267	208	267	4.0543793411175443e-10
R208_283	208	283	1.1564580699216824e+03
C208_283	208	283	7.6562981808753536e-10
R209_210	209	210	1.6530430833442754e+03
C209_210	209	210	5.3562958559356315e-10
R209_216	209	216	1.5670640305422628e+03
C209_216	209	216	5.6501761538972470e-10
R209_240	209	240	3.6639673606017636e+03
C209_240	209	240	2.4165575032703905e-10
R209_245	209	245	6.1950029903882287e+03
C209_245	209	245	1.4292467381755255e-10
R209_250	209	250	5.2876174016532750e+03
C209_250	209	250	1.6745137071058829e-10
R209_252	209	252	3.4910407639365731e+03
C209_252	209	252	2.5362602202948291e-10
R209_256	209	256	1.8248623231979045e+03
C209_256	209	256	4.8519757926087516e-10
R209_257	209	257	1.6142381240588700e+03
C209_257	209	257	5.4850568110340930e-10
R209_258	209	258	3.7533505058969645e+03
C209_258	209	258	2.3590090515364893e-10
R209_284	209	284	2.4998673490334163e+03
C209_284	209	284	3.5418630594233364e-10
R210_216	210	216	1.2353117776046859e+03
C210_216	210	216	7.1675733831086695e-10
R210_226	210	226	1.5094029813991795e+03
C210_226	210	226	5.8660198277814363e-10
R210_256	210	256	9.5846789477572645e+02
C210_256	210	256	9.2378553994986020e-10
R210_283	210	283	2.0309310741114421e+03
C210_283	210	283	4.3596692816735893e-10
R210_284	210	284	2.0238859893855526e+03
C210_284	210	284	4.3748451560199369e-10
R211_212	211	212	2.3557423582263286e+03
C211_212	211	212	3.7585552537529800e-10
R211_213	211	213	3.0643558216660617e+03
C211_213	211	213	2.8894124352001858e-10
R211_214	211	214	3.5666726116444347e+03
C211_214	211	214	2.4824784276787681e-10
R211_215	211	215	3.5071197779313825e+03
C211_215	211	215	2.5246322845074028e-10
R211_218	211	218	1.6511562914090246e+03
C211_218	211	218	5.3624165459492793e-10
R211_219	211	219	1.3614100074655296e+03
C211_219	211	219	6.5036893870667306e-10
R211_285	211	285	2.6743937655390682e+03
C211_285	211	285	3.3107270631164125e-10
R212_213	212	213	4.5071139634667315e+02
C212_213	212	213	1.9644916655689873e-09
R212_219	212	219	2.3719388884964678e+03
C212_219	212	219	3.7328903623703899e-10
R212_220	212	220	2.0996843774828999e+03
C212_220	212	220	4.2169136999601792e-10
R212_226	212	226	9.2545690585565956e+02
C212_226	212	226	9.5673691135446114e-10
R212_260	212	260	1.1955476702459391e+03
C212_260	212	260	7.4059680239923697e-10
R212_285	212	285	2.6642958018641948e+03
C212_285	212	285	3.3232750698345010e-10
R213_215	213	215	1.3817252098622491e+03
C213_215	213	215	6.4080670699224764e-10
R213_226	213	226	6.2193258001304446e+02
C213_226	213	226	1.4236571778912586e-09
R213_285	213	285	4.2911915641690439e+03
C213_285	213	285	2.0633401433139110e-10
R214_215	214	215	1.1461259041083410e+03
C214_215	214	215	7.7253186454138745e-10
R214_218	214	218	3.6194896177485693e+03
C214_218	214	218	2.4462531329230809e-10
R214_223	214	223	3.0338576248155264e+03
C214_223	214	223	2.9184585804478475e-10
R214_225	214	225	1.0541154285145724e+03
C214_225	214	225	8.3996378171573239e-10
R214_228	214	228	1.7945905866349924e+03
C214_228	214	228	4.9338204952932145e-10
R214_235	214	235	1.4741568499915045e+03
C214_235	214	235	6.0062725462701123e-10
R214_285	214	285	1.3254478602277941e+03
C214_285	214	285	6.6801479580481593e-10
R214_286	214	286	2.3720013414144628e+03
C214_286	214	286	3.7327920783215516e-10
R215_217	215	217	1.3578440606579766e+03
C215_217	215	217	6.5207692647044376e-10
R215_216	215	216	3.1642234439279869e+03
C215_216	215	216	2.7982182592037929e-10
R215_222	215	222	4.1867571491496683e+03
C215_222	215	222	2.1148080725910480e-10
R215_225	215	225	1.5549438075640373e+03
C215_225	215	225	5.6942172276121687e-10
R215_226	215	226	2.3575734084209689e+03
C215_226	215	226	3.7556361067587154e-10
R215_285	215	285	2.6448974752514946e+03
C215_285	215	285	3.3476487840641490e-10
R215_287	215	287	2.8941623953022208e+03
C215_287	215	287	3.0593265365385308e-10
R216_217	216	217	1.0057461952647614e+03
C216_217	216	217	8.8036006088684733e-10
R216_226	216	226	1.4770967789595006e+03
C216_226	216	226	5.9943180048345152e-10
R216_240	216	240	2.8778387621860566e+03
C216_240	216	240	3.0766796018391957e-10
R216_284	216	284	1.3691678271104036e+03
C216_284	216	284	6.4668389379894778e-10
R216_287	216	287	4.1518794346255372e+03
C216_287	216	287	2.1325734420798688e-10
R217_221	217	221	4.5825405679857022e+03
C217_221	217	221	1.9321569958063546e-10
R217_222	217	222	1.0634299468429667e+03
C217_222	217	222	8.3260658995786868e-10
R217_225	217	225	1.3180505770934549e+03
C217_225	217	225	6.7176388910091167e-10
R217_240	217	240	1.1651898268302327e+03
C217_240	217	240	7.5989230365036909e-10
R217_284	217	284	4.2192325038985755e+03
C217_284	217	284	2.0985304338688900e-10
R217_287	217	287	4.7022364086144235e+03
C217_287	217	287	1.8829737698383830e-10
R218_219	218	219	1.0119079263265445e+03
C218_219	218	219	8.7499935385847928e-10
R218_233	218	233	2.1182143190845122e+03
C218_233	218	233	4.1800245316190493e-10
R218_232	218	232	3.7664449673497711e+03
C218_232	218	232	2.3508076963169276e-10
R218_235	218	235	2.4021739591378750e+03
C218_235	218	235	3.6859061698336416e-10
R218_236	218	236	1.1349723964691168e+03
C218_236	218	236	7.8012362631419551e-10
R218_285	218	285	2.8759985624017268e+03
C218_285	218	285	3.0786482068356554e-10
R218_289	218	289	3.5443046797744209e+03
C218_289	218	289	2.4981452264886917e-10
R219_220	219	220	8.9616560638520411e+02
C219_220	219	220	9.8800799248639690e-10
R219_229	219	229	9.7844429492105644e+02
C219_229	219	229	9.0492507983956098e-10
R219_232	219	232	1.8541868626927380e+03
C219_232	219	232	4.7752402927402523e-10
R219_233	219	233	2.5405824652049164e+03
C219_233	219	233	3.4851015222943561e-10
R219_285	219	285	2.4034059120112888e+03
C219_285	219	285	3.6840168249359006e-10
R219_289	219	289	3.8932543832343331e+03
C219_289	219	289	2.2742381939205209e-10
R220_229	220	229	2.2070839174147113e+03
C220_229	220	229	4.0117132598072842e-10
R220_230	220	230	2.4622823269438259e+03
C220_230	220	230	3.5959271283036749e-10
R220_232	220	232	1.7201488567698480e+03
C220_232	220	232	5.1473381400413718e-10
R220_260	220	260	1.9347204156308042e+03
C220_260	220	260	4.5764689024140715e-10
R220_226	220	226	4.8953773943719934e+03
C220_226	220	226	1.8086833973575324e-10
R220_261	220	261	3.4563420278901885e+03
C220_261	220	261	2.5617221170685915e-10
R220_278	220	278	3.7271535434668335e+03
C220_278	220	278	2.3755897667591733e-10
R220_280	220	280	2.5627968652195773e+03
C220_280	220	280	3.4548925578779286e-10
R220_285	220	285	1.7911966139295398e+03
C220_285	220	285	4.9431691351713887e-10
R220_288	220	288	7.0624696391106920e+02
C220_288	220	288	1.2536956998678047e-09
R220_289	220	289	1.8839327508048498e+03
C220_289	220	289	4.6998428225303351e-10
R220_290	220	290	1.4842286898288919e+03
C220_290	220	290	5.9655145313359706e-10
R221_222	221	222	2.1738705201804646e+03
C221_222	221	222	4.0730060667389544e-10
R221_224	221	224	9.8064553868324890e+02
C221_224	221	224	9.0289380492046748e-10
R221_237	221	237	4.7559515889287823e+03
C221_237	221	237	1.8617068848243456e-10
R221_240	221	240	1.5331328351343029e+03
C221_240	221	240	5.7752254821574999e-10
R221_241	221	241	1.0112121092048847e+03
C221_241	221	241	8.7560144270444319e-10
R221_245	221	245	2.7333647884103634e+03
C221_245	221	245	3.2392997285039693e-10
R221_246	221	246	1.5743611273968515e+03
C221_246	221	246	5.6239878277737180e-10
R221_291	221	291	1.1056914697221091e+03
C221_291	221	291	8.0078286388745515e-10
R222_223	222	223	8.2915206366198163e+02
C222_223	222	223	1.0678605535750757e-09
R222_224	222	224	2.5885987694721321e+03
C222_224	222	224	3.4204558548892263e-10
R222_225	222	225	1.1653876281129365e+03
C222_225	222	225	7.5976332710320752e-10
R222_240	222	240	3.5951083727702285e+03
C222_240	222	240	2.4628430909239496e-10
R222_291	222	291	2.3935074069406883e+03
C222_291	222	291	3.6992523153781110e-10
R223_224	223	224	6.8084297483567352e+03
C223_224	223	224	1.3004742861798679e-10
R223_225	223	225	6.7684648941633459e+03
C223_225	223	225	1.3081530236841796e-10
R223_227	223	227	3.8246593201869582e+03
C223_227	223	227	2.3150265358973695e-10
R223_228	223	228	4.4863317214713779e+03
C223_228	223	228	1.9735918711994174e-10
R223_291	223	291	1.2689564977228993e+04
C223_291	223	291	6.9775345592134564e-11
R224_227	224	227	3.6418926428664640e+03
C224_227	224	227	2.4312050588155281e-10
R224_237	224	237	2.7856915863931567e+03
C224_237	224	237	3.1784522953828421e-10
R224_291	224	291	3.0289722412187421e+03
C224_291	224	291	2.9231657182296979e-10
R225_228	225	228	4.2899270496131157e+03
C225_228	225	228	2.0639483409860105e-10
R225_227	225	227	4.8932547914434545e+03
C225_227	225	227	1.8094679705791729e-10
R225_240	225	240	1.9034382107564877e+03
C225_240	225	240	4.6516812402757545e-10
R225_284	225	284	4.1275112173317912e+03
C225_284	225	284	2.1451638410624952e-10
R225_285	225	285	3.2637157493709929e+03
C225_285	225	285	2.7129163496258656e-10
R225_286	225	286	8.8494857098112618e+02
C225_286	225	286	1.0005313424240605e-09
R225_287	225	287	1.4634372063924627e+03
C225_287	225	287	6.0502683533833134e-10
R225_291	225	291	1.6713411691240128e+03
C225_291	225	291	5.2976543512302032e-10
R225_292	225	292	2.0012212164731220e+03
C225_292	225	292	4.4243923380965818e-10
R226_260	226	260	2.8364742308845248e+03
C226_260	226	260	3.1215470673389182e-10
R226_283	226	283	6.0976020097028841e+03
C226_283	226	283	1.4520770301030908e-10
R226_284	226	284	3.4386811802632510e+03
C226_284	226	284	2.5748789587763298e-10
R226_285	226	285	4.6321653931293458e+03
C226_285	226	285	1.9114576155102247e-10
R226_287	226	287	2.1843190135199347e+03
C226_287	226	287	4.0535232089253599e-10
R226_288	226	288	7.4842004124409514e+03
C226_288	226	288	1.1830506038135652e-10
R226_293	226	293	6.9340045301239988e+03
C226_293	226	293	1.2769227044104144e-10
R227_228	227	228	4.3798393865804874e+03
C227_228	227	228	2.0215781985359085e-10
R227_237	227	237	1.1339478406088165e+04
C227_237	227	237	7.8082849139217793e-11
R227_286	227	286	1.1250585877276717e+04
C227_286	227	286	7.8699793180399394e-11
R227_291	227	291	3.2594221165691156e+03
C227_291	227	291	2.7164900710436247e-10
R227_295	227	295	6.2711005162422953e+03
C227_295	227	295	1.4119033483943447e-10
R227_299	227	299	1.0431193556283419e+04
C227_299	227	299	8.4881828423809855e-11
R227_300	227	300	1.0133211009768645e+04
C227_300	227	300	8.7377908231303604e-11
R228_235	228	235	4.9354886294013841e+03
C228_235	228	235	1.7939840372145497e-10
R228_286	228	286	5.8686886807662304e+03
C228_286	228	286	1.5087165632108426e-10
R228_300	228	300	9.0834028312794308e+03
C228_300	228	300	9.7476551260171931e-11
R229_230	229	230	5.0789721503078846e+02
C229_230	229	230	1.7433030847517573e-09
R229_231	229	231	2.8715926581772806e+03
C229_231	229	231	3.0833717978023113e-10
R229_232	229	232	1.0974213800215259e+03
C229_232	229	232	8.0681750676538899e-10
R229_233	229	233	1.1810367732632983e+03
C229_233	229	233	7.4969620061322707e-10
R229_301	229	301	3.5102664841165674e+03
C229_301	229	301	2.5223691298264334e-10
R230_231	230	231	1.9335946289436108e+03
C230_231	230	231	4.5791334359660215e-10
R230_232	230	232	1.0928061722686768e+03
C230_232	230	232	8.1022490920037699e-10
R230_277	230	277	2.4722616755275399e+03
C230_277	230	277	3.5814120748810558e-10
R230_278	230	278	3.4430573555817341e+02
C230_278	230	278	2.5716062506614873e-09
R230_290	230	290	1.8987530903652867e+03
C230_290	230	290	4.6631591342382554e-10
R230_296	230	296	1.2531482658026287e+03
C230_296	230	296	7.0655548578116439e-10
R230_301	230	301	1.0804948728147772e+03
C230_301	230	301	8.1945671745152472e-10
R230_304	230	304	1.7991294621292684e+03
C230_304	230	304	4.9213733660506430e-10
R231_233	231	233	1.4256428817474634e+03
C231_233	231	233	6.2106632245426664e-10
R231_234	231	234	4.0445725011409891e+03
C231_234	231	234	2.1891529486743535e-10
R231_277	231	277	4.4484325653516889e+03
C231_277	231	277	1.9904062131826419e-10
R231_296	231	296	2.8229739447530596e+03
C231_296	231	296	3.1364752173702843e-10
R231_301	231	301	7.1890265226794202e+02
C231_301	231	301	1.2316254209199881e-09
R231_302	231	302	4.5513279141433459e+03
C231_302	231	302	1.9454075786289597e-10
R231_303	231	303	3.5862320186611832e+03
C231_303	231	303	2.4689389227820954e-10
R231_306	231	306	4.4122922310221375e+03
C231_306	231	306	2.0067092915441069e-10
R232_233	232	233	7.1416940604257888e+02
C232_233	232	233	1.2397881709976404e-09
R232_236	232	236	4.8017410414462965e+03
C232_236	232	236	1.8439536286057395e-10
R232_289	232	289	9.5537021873751689e+02
C232_289	232	289	9.2678080636640016e-10
R232_290	232	290	1.7029794483260403e+03
C232_290	232	290	5.1992335114221776e-10
R232_301	232	301	1.8888691391655948e+03
C232_301	232	301	4.6875602091266755e-10
R232_304	232	304	2.8663196772659594e+03
C232_304	232	304	3.0890440753089946e-10
R232_305	232	305	3.2732525033749284e+03
C232_305	232	305	2.7050121577454771e-10
R232_306	232	306	2.1517983764886449e+03
C232_306	232	306	4.1147850624594625e-10
R233_234	233	234	1.0979406726621803e+04
C233_234	233	234	8.0643590655324053e-11
R233_236	233	236	8.5980356519377856e+03
C233_236	233	236	1.0297919403258678e-10
R233_301	233	301	1.0308511336527663e+04
C233_301	233	301	8.5892012221256970e-11
R233_306	233	306	9.5255152308578272e+03
C233_306	233	306	9.2952324387839214e-11
R234_236	234	236	3.5890392305445275e+03
C234_236	234	236	2.4670078113514093e-10
R234_303	234	303	1.1199522150655945e+04
C234_303	234	303	7.9058621411641386e-11
R234_306	234	306	3.7506696911504528e+03
C234_306	234	306	2.3606951680898703e-10
R235_236	235	236	4.9485521702088836e+03
C235_236	235	236	1.7892481502577059e-10
R235_285	235	285	4.6170641745036673e+03
C235_285	235	285	1.9177094972806659e-10
R235_286	235	286	4.4512399704187692e+03
C235_286	235	286	1.9891508603987951e-10
R235_289	235	289	5.6730739406960238e+03
C235_289	235	289	1.5607390119638897e-10
R235_298	235	298	5.2821946213937745e+03
C235_298	235	298	1.6762327880042616e-10
R235_300	235	300	6.1949137022904397e+03
C235_300	235	300	1.4292673380948550e-10
R235_307	235	307	5.7765512703064423e+03
C235_307	235	307	1.5327809626677634e-10
R236_289	236	289	6.9687458293018053e+03
C236_289	236	289	1.2705568597107376e-10
R236_306	236	306	6.4298193942101198e+03
C236_306	236	306	1.3770507807688907e-10
R236_307	236	307	1.1993444308798411e+04
C236_307	236	307	7.3825229759098941e-11
R237_238	237	238	1.1115300525881088e+04
C237_238	237	238	7.9657655646680287e-11
R237_241	237	241	5.1203172727873161e+03
C237_241	237	241	1.7292264024451943e-10
R237_265	237	265	8.1360533545916687e+03
C237_265	237	265	1.0882657021912283e-10
R237_264	237	264	5.7913380070741359e+03
C237_264	237	264	1.5288673888805288e-10
R237_291	237	291	6.8150526233987257e+03
C237_291	237	291	1.2992104839513827e-10
R237_295	237	295	1.1013092922535232e+04
C237_295	237	295	8.0396922819768152e-11
R237_309	237	309	1.8694286018468203e+04
C237_309	237	309	4.7363070235754876e-11
R237_310	237	310	1.1061822833058839e+04
C237_310	237	310	8.0042755616540837e-11
R238_265	238	265	5.4478749928949692e+03
C238_265	238	265	1.6252553203859285e-10
R238_310	238	310	2.0124112656088433e+04
C238_310	238	310	4.3997904247078528e-11
R239_279	239	279	2.2464357889693592e+03
C239_279	239	279	3.9414381931042016e-10
R239_277	239	277	5.4939843030458906e+03
C239_277	239	277	1.6116150554145557e-10
R239_266	239	266	4.4300717367037651e+03
C239_266	239	266	1.9986556298043248e-10
R239_271	239	271	2.2821099979409892e+03
C239_271	239	271	3.8798251727517979e-10
R239_282	239	282	1.8797055948041734e+03
C239_282	239	282	4.7104120142401482e-10
R239_308	239	308	3.6791447062568095e+03
C239_308	239	308	2.4065886296732057e-10
R239_311	239	311	5.4085194843143790e+03
C239_311	239	311	1.6370816158985178e-10
R239_312	239	312	1.5610111681614308e+03
C239_312	239	312	5.6720848624219152e-10
R239_313	239	313	8.2618128738647210e+03
C239_313	239	313	1.0717003582844620e-10
R240_245	240	245	2.8769843809650315e+03
C240_245	240	245	3.0775932867699574e-10
R240_246	240	246	1.3632755251930123e+03
C240_246	240	246	6.4947896836528543e-10
R240_257	240	257	3.5721480776622761e+03
C240_257	240	257	2.4786732309245297e-10
R240_284	240	284	1.3310900293763725e+03
C240_284	240	284	6.6518324242487710e-10
R240_291	240	291	1.3769572374927304e+03
C240_291	240	291	6.4302562025254965e-10
R240_292	240	292	1.7775848797347514e+03
C240_292	240	292	4.9810211135016024e-10
R240_294	240	294	4.2700658099005950e+03
C240_294	240	294	2.0735483271641013e-10
R240_314	240	314	2.5111244341363104e+03
C240_314	240	314	3.5259852903487675e-10
R241_242	241	242	2.7017911695117009e+03
C241_242	241	242	3.2771547693674015e-10
R241_243	241	243	4.7044573460472939e+03
C241_243	241	243	1.8820848326830570e-10
R241_245	241	245	2.8591803504302538e+03
C241_245	241	245	3.0967573681274102e-10
R241_246	241	246	1.4816295999068977e+03
C241_246	241	246	5.9759792984402968e-10
R241_265	241	265	1.0889490620302406e+03
C241_265	241	265	8.1309476501060752e-10
R241_264	241	264	1.0536454648142301e+03
C241_264	241	264	8.4033843571481575e-10
R241_291	241	291	3.9543328269223584e+03
C241_291	241	291	2.2391104149650395e-10
R241_316	241	316	3.0229382358872167e+03
C241_316	241	316	2.9290005703346242e-10
R242_243	242	243	1.3593655411774832e+03
C242_243	242	243	6.5134708426774578e-10
R242_244	242	244	8.1604478285275682e+03
C242_244	242	244	1.0850124898841009e-10
R242_265	242	265	9.7235158502078175e+03
C242_265	242	265	9.1059529838795546e-11
R242_316	242	316	7.9828072587089528e+03
C242_316	242	316	1.1091571586349405e-10
R243_244	243	244	4.6090293677187510e+03
C243_244	243	244	1.9210525927680085e-10
R243_245	243	245	4.6859678905527053e+03
C243_245	243	245	1.8895109876554574e-10
R243_250	243	250	3.2379309823011827e+03
C243_250	243	250	2.7345202431422338e-10
R243_316	243	316	1.0812325722789594e+04
C243_316	243	316	8.1889762147450456e-11
R244_250	244	250	3.1539168069282246e+03
C244_250	244	250	2.8073625143028379e-10
R244_251	244	251	1.1407303868123972e+04
C244_251	244	251	7.7618584718705720e-11
R244_315	244	315	7.1349849528023196e+03
C244_315	244	315	1.2409539579368631e-10
R244_316	244	316	9.0144059940775041e+03
C244_316	244	316	9.8222642987427402e-11
R245_246	245	246	1.3323683331396408e+03
C245_246	245	246	6.6454505085209231e-10
R245_250	245	250	1.4718700417556795e+03
C245_250	245	250	6.0156043440075243e-10
R245_257	245	257	3.8851778020403058e+03
C245_257	245	257	2.2789659233485306e-10
R245_316	245	316	5.3978329426330720e+03
C245_316	245	316	1.6403226833991110e-10
R245_318	245	318	3.4989539067133123e+03
C245_318	245	318	2.5305242804175851e-10
R246_257	246	257	1.5505835175209286e+04
C246_257	246	257	5.7102295471037039e-11
R246_291	246	291	8.7307689902244947e+03
C246_291	246	291	1.0141360774650770e-10
R246_264	246	264	6.5819777236785085e+03
C246_264	246	264	1.3452169224376543e-10
R246_294	246	294	8.9307397387357323e+03
C246_294	246	294	9.9142826641742794e-11
R246_314	246	314	8.3866272804406890e+03
C246_314	246	314	1.0557507232555523e-10
R246_316	246	316	1.2952894415638533e+04
C246_316	246	316	6.8356828465381417e-11
R246_318	246	318	4.7829118669702830e+03
C246_318	246	318	1.8512128308583387e-10
R246_319	246	319	7.8675685982910609e+03
C246_319	246	319	1.1254033195113477e-10
R247_249	247	249	1.8206062964664889e+03
C247_249	247	249	4.8633182441391036e-10
R247_248	247	248	4.5130444883892969e+03
C247_248	247	248	1.9619101561660105e-10
R247_252	247	252	2.5435886584043838e+03
C247_252	247	252	3.4809825825195775e-10
R247_253	247	253	1.8155395240353412e+03
C247_253	247	253	4.8768906982096885e-10
R247_256	247	256	5.5988279810334889e+03
C247_256	247	256	1.5814359446288267e-10
R247_258	247	258	2.6688748007760123e+03
C247_258	247	258	3.3175733138270570e-10
R247_321	247	321	3.6345353114758150e+03
C247_321	247	321	2.4361265081242885e-10
R248_249	248	249	1.9069538018013920e+03
C248_249	248	249	4.6431055690158546e-10
R248_256	248	256	9.4746757645785249e+02
C248_256	248	256	9.3451090433107549e-10
R248_258	248	258	2.4960943220339045e+03
C248_258	248	258	3.5472168414634671e-10
R248_262	248	262	1.8876186669865558e+03
C248_262	248	262	4.6906655310497965e-10
R248_272	248	272	9.2079506419677637e+02
C248_272	248	272	9.6158072097439457e-10
R248_320	248	320	6.0192069477168536e+02
C248_320	248	320	1.4709891010407084e-09
R248_321	248	321	9.0054646396957878e+02
C248_321	248	321	9.8320166379545106e-10
R249_253	249	253	8.7905024090270999e+03
C249_253	249	253	1.0072447972834294e-10
R249_263	249	263	8.9962231606706464e+03
C249_263	249	263	9.8421166959356987e-11
R249_272	249	272	9.4881401369168980e+03
C249_272	249	272	9.3318476426688860e-11
R249_321	249	321	4.2743585680459410e+03
C249_321	249	321	2.0714658529566851e-10
R250_251	250	251	2.5967687079675334e+03
C250_251	250	251	3.4096944367178887e-10
R250_252	250	252	9.2468501013057028e+02
C250_252	250	252	9.5753556292101489e-10
R250_257	250	257	2.6105689821539299e+03
C250_257	250	257	3.3916697384853553e-10
R250_315	250	315	1.9516882940308230e+03
C250_315	250	315	4.5366813153925510e-10
R250_316	250	316	4.2125020945990773e+03
C250_316	250	316	2.1018833031209902e-10
R250_318	250	318	3.6251801704773648e+03
C250_318	250	318	2.4424131768971021e-10
R250_322	250	322	4.9240318470753646e+03
C250_322	250	322	1.7981581135099594e-10
R251_252	251	252	8.1623706803154919e+03
C251_252	251	252	1.0847568878920077e-10
R251_253	251	253	9.7978418362871562e+03
C251_253	251	253	9.0368756354157004e-11
R251_254	251	254	1.1061495930205281e+04
C251_254	251	254	8.0045121137929891e-11
R251_315	251	315	8.0204070304047063e+03
C251_315	251	315	1.1039574155569039e-10
R251_324	251	324	1.0902247054818328e+04
C251_324	251	324	8.1214338406382274e-11
R252_253	252	253	1.6092374306518275e+03
C252_253	252	253	5.5021015844837646e-10
R252_257	252	257	2.8394058918661926e+03
C252_257	252	257	3.1183240981375179e-10
R252_258	252	258	1.2546082908574190e+03
C252_258	252	258	7.0573324610734967e-10
R252_315	252	315	5.6793129796199682e+03
C252_315	252	315	1.5590244539740929e-10
R252_322	252	322	2.4960954311103342e+03
C252_322	252	322	3.5472152653480112e-10
R252_324	252	324	7.2617891034269705e+03
C252_324	252	324	1.2192846268175907e-10
R253_254	253	254	3.1668312785536241e+03
C253_254	253	254	2.7959139714711750e-10
R253_258	253	258	1.1415624314969036e+03
C253_258	253	258	7.7562011263717890e-10
R253_263	253	263	1.0792549014213675e+03
C253_263	253	263	8.2039820299533766e-10
R253_321	253	321	5.8857520050560936e+02
C253_321	253	321	1.5043426582353291e-09
R253_322	253	322	3.5112687227975698e+03
C253_322	253	322	2.5216491576143197e-10
R253_323	253	323	1.8644594508169546e+03
C253_323	253	323	4.7489302130546969e-10
R253_324	253	324	1.9646600303100640e+03
C253_324	253	324	4.5067277189950405e-10
R253_325	253	325	1.8128872362230716e+03
C253_325	253	325	4.8840256801888109e-10
R254_263	254	263	5.3946169791456005e+03
C254_263	254	263	1.6413005503872355e-10
R254_324	254	324	4.8862298147998163e+03
C254_324	254	324	1.8120694589889544e-10
R254_325	254	325	5.9555532188831630e+03
C254_325	254	325	1.4867112242278670e-10
R254_326	254	326	7.9686147027110201e+03
C254_326	254	326	1.1111326306174269e-10
R255_259	255	259	2.3420623124485132e+03
C255_259	255	259	3.7805090709748767e-10
R255_261	255	261	1.7783069253800138e+03
C255_261	255	261	4.9789986703830179e-10
R255_268	255	268	5.0693576747531915e+03
C255_268	255	268	1.7466094099251101e-10
R255_269	255	269	1.2534799005250550e+03
C255_269	255	269	7.0636855152533177e-10
R255_270	255	270	2.2047669443272325e+03
C255_270	255	270	4.0159291392595640e-10
R255_279	255	279	2.0872351594473530e+03
C255_279	255	279	4.2420652876240191e-10
R255_280	255	280	2.6059632996385390e+03
C255_280	255	280	3.3976640493088003e-10
R255_328	255	328	4.8834991827434815e+03
C255_328	255	328	1.8130826863425095e-10
R256_258	256	258	1.4206767813139040e+03
C256_258	256	258	6.2323731431798746e-10
R256_257	256	257	4.3012575922264114e+03
C256_257	256	257	2.0585114067574150e-10
R256_262	256	262	2.6581822747460942e+03
C256_262	256	262	3.3309182372927165e-10
R256_283	256	283	1.8375878237752149e+03
C256_283	256	283	4.8183753192321438e-10
R256_284	256	284	3.4411632653780784e+03
C256_284	256	284	2.5730217179995378e-10
R256_320	256	320	2.8003239337301384e+03
C256_320	256	320	3.1618441389406997e-10
R256_329	256	329	2.2649800675877955e+03
C256_329	256	329	3.9091680954304008e-10
R257_258	257	258	1.4217551452957648e+03
C257_258	257	258	6.2276460516399835e-10
R257_284	257	284	4.3268493821062984e+03
C257_284	257	284	2.0463360369363736e-10
R257_314	257	314	1.4597950524081937e+03
C257_314	257	314	6.0653636292255057e-10
R257_318	257	318	2.2337506186313249e+03
C257_318	257	318	3.9638210922691020e-10
R257_322	257	322	9.9430376482632971e+02
C257_322	257	322	8.9049122916139395e-10
R257_329	257	329	4.1002115056416387e+03
C257_329	257	329	2.1594466053317450e-10
R258_320	258	320	3.0452004560802675e+03
C258_320	258	320	2.9075878401768549e-10
R258_321	258	321	1.4262686220656897e+03
C258_321	258	321	6.2079384486327165e-10
R258_322	258	322	1.5131188840887235e+03
C258_322	258	322	5.8516141131451402e-10
R258_323	258	323	1.2720424599163796e+03
C258_323	258	323	6.9606071306629559e-10
R258_329	258	329	4.1468278937851710e+03
C258_329	258	329	2.1351712788152416e-10
R259_260	259	260	2.0194479275471224e+03
C259_260	259	260	4.3844595823545415e-10
R259_261	259	261	9.7642555648454629e+02
C259_261	259	261	9.0679599260777170e-10
R259_267	259	267	1.2106481768440729e+03
C259_267	259	267	7.3135928227151576e-10
R259_268	259	268	8.1595046339316741e+02
C259_268	259	268	1.0851379114584303e-09
R259_269	259	269	1.1693513889340823e+03
C259_269	259	269	7.5718795058438358e-10
R259_283	259	283	3.8693916954977904e+03
C259_283	259	283	2.2882635085257051e-10
R259_330	259	330	2.7103426054387683e+03
C259_330	259	330	3.2668149772772459e-10
R260_261	260	261	1.1443505263613890e+03
C260_261	260	261	7.7373039230846862e-10
R260_283	260	283	1.8590819104887605e+03
C260_283	260	283	4.7626668663954659e-10
R260_288	260	288	2.0573454076584812e+03
C260_288	260	288	4.3036953270171510e-10
R260_293	260	293	3.4385853611167481e+03
C260_293	260	293	2.5749507099990761e-10
R260_330	260	330	3.4568595278135558e+03
C260_330	260	330	2.5613386213006530e-10
R261_269	261	269	1.1398645025812325e+03
C261_269	261	269	7.7677546734279557e-10
R261_280	261	280	9.5056684422639955e+02
C261_280	261	280	9.3146398601834358e-10
R261_288	261	288	3.0875553420239653e+03
C261_288	261	288	2.8677017368685842e-10
R261_330	261	330	2.3165071353677358e+03
C261_330	261	330	3.8222147826859318e-10
R262_272	262	272	4.8183068402009621e+03
C262_272	262	272	1.8376139400517532e-10
R262_273	262	273	3.1077230497117853e+03
C262_273	262	273	2.8490916582226179e-10
R262_267	262	267	1.6543392883325578e+03
C262_267	262	267	5.3520991004960754e-10
R262_283	262	283	2.8611779729209370e+03
C262_283	262	283	3.0945952683820241e-10
R262_320	262	320	1.3786160736104641e+03
C262_320	262	320	6.4225189205952925e-10
R262_329	262	329	5.5584522819360673e+03
C262_329	262	329	1.5929232397612658e-10
R262_331	262	331	1.0221174689053295e+03
C262_331	262	331	8.6625931816650075e-10
R262_332	262	332	3.8984478807215505e+03
C262_332	262	332	2.2712084624204874e-10
R262_333	262	333	2.1032417780668470e+03
C262_333	262	333	4.2097812573588908e-10
R263_321	263	321	1.1835635412147767e+03
C263_321	263	321	7.4809568803651266e-10
R263_272	263	272	6.1221493734244541e+03
C263_272	263	272	1.4462547835626176e-10
R263_325	263	325	1.5957627661910574e+03
C263_325	263	325	5.5485614808109307e-10
R263_326	263	326	6.2903323116718275e+03
C263_326	263	326	1.4075866549325050e-10
R263_334	263	334	4.2411348594570891e+03
C263_334	263	334	2.0876930610344777e-10
R264_265	264	265	2.3679793282408168e+03
C264_265	264	265	3.7391322261152591e-10
R264_291	264	291	4.6659391804434808e+03
C264_291	264	291	1.8976217808647993e-10
R264_294	264	294	2.7802067179600740e+03
C264_294	264	294	3.1847228336663405e-10
R264_295	264	295	7.9259475042919148e+03
C264_295	264	295	1.1171141131335328e-10
R264_309	264	309	2.8735074149691736e+03
C264_309	264	309	3.0813171982348913e-10
R264_310	264	310	4.5868066344294703e+03
C264_310	264	310	1.9303599481475260e-10
R264_316	264	316	3.8296632564741194e+03
C264_316	264	316	2.3120016628176971e-10
R264_319	264	319	1.5162545950514132e+03
C264_319	264	319	5.8395126028948805e-10
R264_335	264	335	2.1195668325115535e+03
C264_335	264	335	4.1773572228002576e-10
R265_310	265	310	7.1506124641566466e+03
C265_310	265	310	1.2382418794729459e-10
R265_316	265	316	1.1921471013468195e+04
C265_316	265	316	7.4270933570169685e-11
R265_335	265	335	1.6610317534087637e+04
C265_335	265	335	5.3305349514417579e-11
R266_275	266	275	9.0683293093487173e+03
C266_275	266	275	9.7638578341790543e-11
R266_271	266	271	2.4531214232740344e+03
C266_271	266	271	3.6093557102374681e-10
R266_276	266	276	1.1717703820565584e+04
C266_276	266	276	7.5562481801768486e-11
R266_279	266	279	1.3823222194792841e+04
C266_279	266	279	6.4052994969113223e-11
R266_311	266	311	1.2134251318875324e+04
C266_311	266	311	7.2968554749042896e-11
R266_337	266	337	6.8971860601081489e+03
C266_337	266	337	1.2837391567860888e-10
R267_268	267	268	2.5976308497852874e+03
C267_268	267	268	3.4085627747036740e-10
R267_269	267	269	7.2562775342258292e+03
C267_269	267	269	1.2202107451427095e-10
R267_273	267	273	4.1739969377047837e+03
C267_273	267	273	2.1212731942895925e-10
R267_274	267	274	5.1751137459809261e+03
C267_274	267	274	1.7109165617618169e-10
R267_283	267	283	2.8013937137013959e+03
C267_283	267	283	3.1606367122532146e-10
R267_330	267	330	4.1328362148651386e+03
C267_330	267	330	2.1423998815033924e-10
R267_331	267	331	3.8416914308658634e+03
C267_331	267	331	2.3047628827920710e-10
R267_332	267	332	4.2600544281147804e+03
C267_332	267	332	2.0784212893069267e-10
R267_339	267	339	2.8312405784890520e+03
C267_339	267	339	3.1273173619619487e-10
R268_269	268	269	1.1089377419981131e+03
C268_269	268	269	7.9843867528994849e-10
R268_270	268	270	7.4047491651448752e+02
C268_270	268	270	1.1957444633881488e-09
R268_274	268	274	1.5119906467112453e+03
C268_274	268	274	5.8559805487281855e-10
R268_275	268	275	3.6716142825489642e+03
C268_275	268	275	2.4115245054698698e-10
R268_336	268	336	2.0778164372906799e+03
C268_336	268	336	4.2612945292439850e-10
R268_339	268	339	8.6338834235446791e+02
C268_339	268	339	1.0255162575920994e-09
R269_270	269	270	3.1005513817558785e+03
C269_270	269	270	2.8556816923271785e-10
R269_280	269	280	4.5184594087363093e+03
C269_280	269	280	1.9595590036463946e-10
R269_328	269	328	2.6249038340712091e+03
C269_328	269	328	3.3731475043286487e-10
R269_330	269	330	2.6851756045787511e+03
C269_330	269	330	3.2974334348568769e-10
R269_339	269	339	3.3350944260727488e+03
C269_339	269	339	2.6548537120210651e-10
R270_275	270	275	9.7196588380423073e+03
C270_275	270	275	9.1095664616798137e-11
R270_271	270	271	3.6269419833101419e+03
C270_271	270	271	2.4412267573464723e-10
R270_279	270	279	5.8408004651817637e+03
C270_279	270	279	1.5159202697954967e-10
R270_281	270	281	1.8452024852295979e+03
C270_281	270	281	4.7984911617427598e-10
R270_328	270	328	4.0802315800686470e+03
C270_328	270	328	2.1700209027966584e-10
R270_336	270	336	2.0749606325592563e+03
C270_336	270	336	4.2671594236847019e-10
R270_339	270	339	2.4018817675410369e+03
C270_339	270	339	3.6863545644316247e-10
R270_341	270	341	6.3708295504411917e+03
C270_341	270	341	1.3898013982161602e-10
R270_342	270	342	5.6662708628573118e+03
C270_342	270	342	1.5626128773757786e-10
R271_275	271	275	2.3052715154842690e+03
C271_275	271	275	3.8408438040930722e-10
R271_279	271	279	2.0337447586970995e+03
C271_279	271	279	4.3536376819834347e-10
R271_281	271	281	1.9083029980470358e+03
C271_281	271	281	4.6398228300544558e-10
R271_282	271	282	3.2052579413657622e+03
C271_282	271	282	2.7623947834997721e-10
R271_311	271	311	1.8858664036475145e+03
C271_311	271	311	4.6950238892186807e-10
R271_312	271	312	1.1619804631787895e+03
C271_312	271	312	7.6199110893636790e-10
R271_336	271	336	2.6821992088922711e+03
C271_336	271	336	3.3010925466109263e-10
R271_337	271	337	4.5804640953806506e+02
C271_337	271	337	1.9330329051000213e-09
R271_342	271	342	9.2057090553418550e+02
C271_342	271	342	9.6181486551132363e-10
R272_273	272	273	4.0503917177744329e+03
C272_273	272	273	2.1860077824435972e-10
R272_320	272	320	2.1736096355673158e+03
C272_320	272	320	4.0734949238891462e-10
R272_321	272	321	2.1209718158908986e+03
C272_321	272	321	4.1745900396516411e-10
R272_333	272	333	3.5912365532072799e+03
C272_333	272	333	2.4654983557383476e-10
R272_334	272	334	4.2090803015113497e+03
C272_334	272	334	2.1035920397671527e-10
R272_343	272	343	8.5070867185630796e+03
C272_343	272	343	1.0408014059242540e-10
R273_274	273	274	7.6694763500675872e+03
C273_274	273	274	1.1544709720529972e-10
R273_332	273	332	2.9175749614638685e+03
C273_332	273	332	3.0347764612558532e-10
R273_333	273	333	6.1883974269006367e+03
C273_333	273	333	1.4307723318659714e-10
R273_343	273	343	7.6112643908496220e+03
C273_343	273	343	1.1633005191154100e-10
R273_345	273	345	1.2181973230110811e+04
C273_345	273	345	7.2682706239368905e-11
R274_275	274	275	2.5245213828685351e+03
C274_275	274	275	3.5072738448898624e-10
R274_332	274	332	2.7510104514094323e+03
C274_332	274	332	3.2185220570367927e-10
R274_336	274	336	1.6311517008422145e+03
C274_336	274	336	5.4281817027982787e-10
R274_339	274	339	2.5849405121462828e+03
C274_339	274	339	3.4252965495319452e-10
R274_344	274	344	2.3275642322463823e+03
C274_344	274	344	3.8040573464452291e-10
R274_345	274	345	3.0275639796546820e+03
C274_345	274	345	2.9245254192811117e-10
R274_346	274	346	3.5380384066825577e+03
C274_346	274	346	2.5025697291121643e-10
R275_276	275	276	3.5939099472879702e+03
C275_276	275	276	2.4636643507669225e-10
R275_336	275	336	1.1485062859801581e+03
C275_336	275	336	7.7093072324316078e-10
R275_337	275	337	1.7260844571403698e+03
C275_337	275	337	5.1296376491732441e-10
R275_346	275	346	5.0555136153050880e+03
C275_346	275	346	1.7513923392857227e-10
R275_347	275	347	3.7702070979623554e+03
C275_347	275	347	2.3484619244882680e-10
R276_337	276	337	2.4972337258676180e+03
C276_337	276	337	3.5455983656170485e-10
R276_311	276	311	9.2905790708234908e+03
C276_311	276	311	9.5302862711820073e-11
R276_338	276	338	1.0916837132864313e+04
C276_338	276	338	8.1105797487306447e-11
R276_347	276	347	9.6850037046587076e+03
C276_347	276	347	9.1421625504809413e-11
R277_278	277	278	3.1151337904363795e+03
C277_278	277	278	2.8423138178471854e-10
R277_279	277	279	1.2518953580441018e+03
C277_279	277	279	7.0726261265425068e-10
R277_282	277	282	3.0567982943304964e+03
C277_282	277	282	2.8965561232555108e-10
R277_296	277	296	7.8219419738679198e+02
C277_296	277	296	1.1319679750349312e-09
R277_302	277	302	3.4781300682292399e+03
C277_302	277	302	2.5456747284634413e-10
R277_297	277	297	1.6934012580615529e+03
C277_297	277	297	5.2286413363926784e-10
R277_308	277	308	4.8204120284330484e+03
C277_308	277	308	1.8368114104715228e-10
R277_349	277	349	3.3888784749691135e+03
C277_349	277	349	2.6127191878961364e-10
R278_279	278	279	3.2793303752317165e+03
C278_279	278	279	2.6999987204321758e-10
R278_280	278	280	7.3987032669383541e+02
C278_280	278	280	1.1967215737067853e-09
R278_290	278	290	2.0701091437173800e+03
C278_290	278	290	4.2771598994535001e-10
R278_296	278	296	1.9766601907851875e+03
C278_296	278	296	4.4793677022871884e-10
R278_304	278	304	2.6634795717437423e+03
C278_304	278	304	3.3242934959712453e-10
R278_349	278	349	3.5107347293547905e+03
C278_349	278	349	2.5220327081297994e-10
R278_350	278	350	4.4771256293845991e+03
C278_350	278	350	1.9776500705916195e-10
R279_280	279	280	2.2649227337003290e+03
C279_280	279	280	3.9092670514788058e-10
R279_281	279	281	2.9970919745408446e+03
C279_281	279	281	2.9542596264021780e-10
R279_282	279	282	1.0889336525889473e+03
C279_282	279	282	8.1310627107070375e-10
R279_296	279	296	4.7949565362878056e+03
C279_296	279	296	1.8465626851864651e-10
R279_328	279	328	3.1887784674399281e+03
C279_328	279	328	2.7766707243568657e-10
R279_349	279	349	1.6324324174746646e+03
C279_349	279	349	5.4239230501788412e-10
R279_351	279	351	2.7224557222983135e+03
C279_351	279	351	3.2522798238662412e-10
R280_288	280	288	3.5963121325313127e+03
C280_288	280	288	2.4620187266025374e-10
R280_290	280	290	1.9916184293255781e+03
C280_290	280	290	4.4457249875912694e-10
R280_327	280	327	2.5753618910988862e+03
C280_327	280	327	3.4380363581531404e-10
R280_328	280	328	1.6793463359227969e+03
C280_328	280	328	5.2724013073423859e-10
R280_330	280	330	5.5638463145821906e+03
C280_330	280	330	1.5913789339928763e-10
R280_349	280	349	5.8877602512303965e+03
C280_349	280	349	1.5038295445453462e-10
R280_350	280	350	2.5365113190576590e+03
C280_350	280	350	3.4906951727262256e-10
R280_351	280	351	5.2406009964741606e+03
C280_351	280	351	1.6895367197306252e-10
R281_282	281	282	2.3395262478129957e+03
C281_282	281	282	3.7846071721900762e-10
R281_312	281	312	4.2535066819847298e+03
C281_312	281	312	2.0816207611712383e-10
R281_328	281	328	1.2180607675633401e+03
C281_328	281	328	7.2690854617313480e-10
R281_339	281	339	3.8230642599164585e+03
C281_339	281	339	2.3159924121164220e-10
R281_340	281	340	9.8020246943675522e+02
C281_340	281	340	9.0330192925220855e-10
R281_341	281	341	1.6377521190351290e+03
C281_341	281	341	5.4063052119367060e-10
R281_342	281	342	1.2180607675633398e+03
C281_342	281	342	7.2690854617313480e-10
R281_348	281	348	1.1458885772966071e+03
C281_348	281	348	7.7269186484857888e-10
R281_351	281	351	1.3067030393755288e+03
C281_351	281	351	6.7759755278685220e-10
R282_308	282	308	1.7985196684540724e+03
C282_308	282	308	4.9230419729636135e-10
R282_297	282	297	2.4427582357257788e+03
C282_297	282	297	3.6246680852431123e-10
R282_312	282	312	1.4658531196424731e+03
C282_312	282	312	6.0402967380248632e-10
R282_340	282	340	1.7876429690882549e+03
C282_340	282	340	4.9529956317372879e-10
R282_349	282	349	1.0703996229035959e+03
C282_349	282	349	8.2718525189516451e-10
R282_351	282	351	1.9359731679786753e+03
C282_351	282	351	4.5735075069478075e-10
R282_353	282	353	1.9745470267485346e+03
C282_353	282	353	4.4841615302422536e-10
R282_354	282	354	1.5910277996475500e+03
C282_354	282	354	5.5650742362650173e-10
R282_355	282	355	1.2753848812357467e+03
C282_355	282	355	6.9423653575232888e-10
R283_284	283	284	2.9492612098442655e+03
C283_284	283	284	3.0021714548192031e-10
R283_293	283	293	1.7872339973118771e+03
C283_293	283	293	4.9541290230139466e-10
R283_329	283	329	1.9959654845323366e+03
C283_329	283	329	4.4360425496408695e-10
R283_330	283	330	1.4692349234390456e+03
C283_330	283	330	6.0263935166167712e-10
R283_331	283	331	2.9404318880946971e+03
C283_331	283	331	3.0111861637907978e-10
R283_356	283	356	4.1336259073595047e+03
C283_356	283	356	2.1419905950453840e-10
R284_287	284	287	1.3758344973729063e+03
C284_287	284	287	6.4355035681302310e-10
R284_292	284	292	1.5931829056175409e+03
C284_292	284	292	5.5575463343099258e-10
R284_293	284	293	2.5033002711001768e+03
C284_293	284	293	3.5370058954648171e-10
R284_314	284	314	3.3480078319324007e+03
C284_314	284	314	2.6446138305147112e-10
R284_329	284	329	3.1089918179447009e+03
C284_329	284	329	2.8479289542979072e-10
R284_357	284	357	4.8733135724508902e+03
C284_357	284	357	1.8168721723660903e-10
R285_286	285	286	1.1057881024267906e+03
C285_286	285	286	8.0071288500648328e-10
R285_287	285	287	9.7433199522828215e+02
C285_287	285	287	9.0874443827799167e-10
R285_288	285	288	2.3270391561836423e+03
C285_288	285	288	3.8049156987632824e-10
R285_289	285	289	1.5770485001811514e+03
C285_289	285	289	5.6144042595918531e-10
R285_298	285	298	2.4619714843449701e+03
C285_298	285	298	3.5963811414151038e-10
R285_358	285	358	4.3133460751390985e+03
C285_358	285	358	2.0527422707936715e-10
R286_287	286	287	2.3826547219081108e+03
C286_287	286	287	3.7161019326834176e-10
R286_291	286	291	6.4643481646629834e+03
C286_291	286	291	1.3696953801778423e-10
R286_292	286	292	2.3135176297733065e+03
C286_292	286	292	3.8271538124685007e-10
R286_298	286	298	1.7561396346869760e+03
C286_298	286	298	5.0418472666487135e-10
R286_299	286	299	1.2839027545310171e+03
C286_299	286	299	6.8963072053180923e-10
R286_300	286	300	2.4815586495219745e+03
C286_300	286	300	3.5679945822378982e-10
R286_358	286	358	2.4213168933956417e+03
C286_358	286	358	3.6567653912425046e-10
R287_288	287	288	6.9218864110212853e+03
C287_288	287	288	1.2791582079275431e-10
R287_292	287	292	3.4061744394736434e+03
C287_292	287	292	2.5994522518841519e-10
R287_293	287	293	5.0532964038847485e+03
C287_293	287	293	1.7521607895775315e-10
R287_358	287	358	4.6687750299524832e+03
C287_358	287	358	1.8964691509434576e-10
R288_289	288	289	2.6848656078930248e+03
C288_289	288	289	3.2978141591036336e-10
R288_290	288	290	1.6959882752115648e+03
C288_290	288	290	5.2206657005901133e-10
R288_293	288	293	8.0779926573673959e+02
C288_293	288	293	1.0960876287656301e-09
R288_298	288	298	5.2371962922292223e+03
C288_298	288	298	1.6906350884990788e-10
R288_327	288	327	1.5145741987731315e+03
C288_327	288	327	5.8459914503840511e-10
R288_330	288	330	3.4018452384180459e+03
C288_330	288	330	2.6027603246047277e-10
R288_358	288	358	2.8322981186513239e+03
C288_358	288	358	3.1261496657760601e-10
R288_359	288	359	1.6409702404262523e+03
C288_359	288	359	5.3957028585113582e-10
R289_290	289	290	4.6123511095457952e+03
C289_290	289	290	1.9196690812794443e-10
R289_298	289	298	2.1545091690111540e+03
C289_298	289	298	4.1096078607378453e-10
R289_305	289	305	3.2795628601432909e+03
C289_305	289	305	2.6998073202393635e-10
R289_306	289	306	1.1279527569394215e+04
C289_306	289	306	7.8497860504591398e-11
R289_307	289	307	3.5362285744127107e+03
C289_307	289	307	2.5038505375661374e-10
R289_359	289	359	4.4893035404218344e+03
C289_359	289	359	1.9722853973398340e-10
R290_304	290	304	1.6153351461646109e+03
C290_304	290	304	5.4813317459370835e-10
R290_305	290	305	1.5785927003647478e+03
C290_305	290	305	5.6089121753535040e-10
R290_327	290	327	2.1661988022408582e+03
C290_327	290	327	4.0874308525333168e-10
R290_350	290	350	1.3860449986490614e+03
C290_350	290	350	6.3880954987968829e-10
R290_359	290	359	1.5916503804325666e+03
C290_359	290	359	5.5628974339161570e-10
R291_292	291	292	2.3801312492058464e+03
C291_292	291	292	3.7200418338082341e-10
R291_294	291	294	2.1969285975113935e+03
C291_294	291	294	4.0302574362360814e-10
R291_295	291	295	1.9026138849821793e+03
C291_295	291	295	4.6536966259357099e-10
R291_299	291	299	2.8719624176774801e+03
C291_299	291	299	3.0829748197611407e-10
R291_360	291	360	4.8988640360094259e+03
C291_360	291	360	1.8073961130410445e-10
R292_293	292	293	1.0220352822292485e+04
C292_293	292	293	8.6632897816280622e-11
R292_294	292	294	5.6213884090304937e+03
C292_294	292	294	1.5750891368360472e-10
R292_299	292	299	5.0358013175140668e+03
C292_299	292	299	1.7582480441009317e-10
R292_314	292	314	7.7932786856611638e+03
C292_314	292	314	1.1361312964838281e-10
R292_357	292	357	4.9930773036028595e+03
C292_357	292	357	1.7732927568758202e-10
R292_358	292	358	2.7806005737194196e+03
C292_358	292	358	3.1842717363595873e-10
R292_360	292	360	2.9928341024000947e+03
C292_360	292	360	2.9584626190604453e-10
R293_329	293	329	4.0937460720423046e+03
C293_329	293	329	2.1628571145309914e-10
R293_330	293	330	1.9129363952044880e+03
C293_330	293	330	4.6285845358980216e-10
R293_327	293	327	2.0523527457404784e+03
C293_327	293	327	4.3141647240593891e-10
R293_356	293	356	1.9756702367898442e+03
C293_356	293	356	4.4816121901935793e-10
R293_357	293	357	2.2778662709582900e+03
C293_357	293	357	3.8870533928557079e-10
R293_358	293	358	1.7345021457186294e+03
C293_358	293	358	5.1047430750404657e-10
R293_359	293	359	4.1142894901122063e+03
C293_359	293	359	2.1520575638343144e-10
R293_362	293	362	2.4782119443699289e+03
C293_362	293	362	3.5728129860382566e-10
R294_295	294	295	3.2603505207134385e+03
C294_295	294	295	2.7157165343873837e-10
R294_309	294	309	2.9256999411581687e+03
C294_309	294	309	3.0263485644720556e-10
R294_314	294	314	1.6074832536280974e+03
C294_314	294	314	5.5081057902258434e-10
R294_319	294	319	9.1924112063985012e+02
C294_319	294	319	9.6320623808005075e-10
R294_317	294	317	2.4030147900523502e+03
C294_317	294	317	3.6846164466624490e-10
R294_357	294	357	3.5695555085750116e+03
C294_357	294	357	2.4804734919319540e-10
R294_360	294	360	1.3791088476642319e+03
C294_360	294	360	6.4202240686049948e-10
R294_361	294	361	2.0622825107364988e+03
C294_361	294	361	4.2933922830184522e-10
R294_363	294	363	2.8067509059668996e+03
C294_363	294	363	3.1546040648554866e-10
R294_364	294	364	3.5305440370411507e+03
C294_364	294	364	2.5078819932863510e-10
R295_299	295	299	2.8346944396185845e+03
C295_299	295	299	3.1235069618972246e-10
R295_300	295	300	8.3560825203143831e+03
C295_300	295	300	1.0596099063735524e-10
R295_309	295	309	5.0049179776741967e+03
C295_309	295	309	1.7690974870110810e-10
R295_360	295	360	5.6390040514841785e+03
C295_360	295	360	1.5701687276975072e-10
R295_364	295	364	3.6383174066722963e+03
C295_364	295	364	2.4335941115973941e-10
R296_301	296	301	3.0499308498277546e+03
C296_301	296	301	2.9030782181504355e-10
R296_302	296	302	4.7328166172847459e+03
C296_302	296	302	1.8708072872850329e-10
R296_297	296	297	4.3633155684351368e+03
C296_297	296	297	2.0292338883422711e-10
R296_304	296	304	3.5244637857598268e+03
C296_304	296	304	2.5122084819751259e-10
R296_349	296	349	2.9317832109267288e+03
C296_349	296	349	3.0200690774135429e-10
R296_366	296	366	4.2400692405362233e+03
C296_366	296	366	2.0882177423782467e-10
R297_302	297	302	2.2591169464653763e+03
C297_302	297	302	3.9193136197987879e-10
R297_308	297	308	2.0527555624599863e+03
C297_308	297	308	4.3133181460676673e-10
R297_349	297	349	1.6824852070074910e+03
C297_349	297	349	5.2625650318484959e-10
R297_354	297	354	1.1656797345959089e+03
C297_354	297	354	7.5957293879432218e-10
R297_365	297	365	6.5767342653170172e+03
C297_365	297	365	1.3462894287356771e-10
R297_366	297	366	1.6010844353933571e+03
C297_366	297	366	5.5301192249893353e-10
R298_299	298	299	3.0631689201788740e+03
C298_299	298	299	2.8905320103871250e-10
R298_300	298	300	2.8549413552166275e+03
C298_300	298	300	3.1013554099181004e-10
R298_307	298	307	1.7852888535159279e+03
C298_307	298	307	4.9595267452449849e-10
R298_305	298	305	4.6618067988074281e+03
C298_305	298	305	1.8993038963487414e-10
R298_358	298	358	1.4285705710518641e+03
C298_358	298	358	6.1979351922954800e-10
R298_359	298	359	2.1927506165370519e+03
C298_359	298	359	4.0379365305951499e-10
R298_368	298	368	1.8105790339863981e+03
C298_368	298	368	4.8902520413624286e-10
R299_300	299	300	8.8303771560996495e+02
C299_300	299	300	1.0026964489148577e-09
R299_358	299	358	2.1761310286241442e+03
C299_358	299	358	4.0687751337280674e-10
R299_360	299	360	7.1107070690067849e+02
C299_360	299	360	1.2451909115469639e-09
R299_364	299	364	2.6469373204471754e+03
C299_364	299	364	3.3450689400926829e-10
R299_368	299	368	3.5475915266763072e+03
C299_368	299	368	2.4958306925756394e-10
R300_307	300	307	9.2987677394629045e+03
C300_307	300	307	9.5218937229971250e-11
R300_364	300	364	8.4357308982209306e+03
C300_364	300	364	1.0496052948852742e-10
R300_368	300	368	6.1092219276450496e+03
C300_368	300	368	1.4493151373227433e-10
R301_302	301	302	3.8722477872377076e+03
C301_302	301	302	2.2865757315897887e-10
R301_303	301	303	5.0239109269068967e+03
C301_303	301	303	1.7624093949554386e-10
R301_304	301	304	1.4726728733834964e+03
C301_304	301	304	6.0123249209156147e-10
R301_306	301	306	2.8177429702369295e+03
C301_306	301	306	3.1422978996041998e-10
R301_366	301	366	5.0303415658031454e+03
C301_366	301	366	1.7601563832547304e-10
R301_372	301	372	5.0029902754882214e+03
C301_372	301	372	1.7697791379648357e-10
R302_303	302	303	6.5419101109150897e+03
C302_303	302	303	1.3534560498205113e-10
R302_308	302	308	1.0671399390641207e+04
C302_308	302	308	8.2971197055609244e-11
R302_365	302	365	7.0102165342843327e+03
C302_365	302	365	1.2630405599737891e-10
R302_366	302	366	1.1347332424161020e+03
C302_366	302	366	7.8028804357114308e-10
R302_367	302	367	5.5780220232222200e+03
C302_367	302	367	1.5873346824624504e-10
R302_372	302	372	6.7524792885216912e+03
C302_372	302	372	1.3112499037280915e-10
R303_306	303	306	5.6922903981076515e+03
C303_306	303	306	1.5554701530939976e-10
R303_367	303	367	1.8034073568736170e+04
C303_367	303	367	4.9096992885454348e-11
R303_372	303	372	5.7686201718231086e+03
C303_372	303	372	1.5348883360787704e-10
R304_305	304	305	1.4144810981212643e+03
C304_305	304	305	6.2596720654381817e-10
R304_306	304	306	5.5386841755455753e+03
C304_306	304	306	1.5986085388462939e-10
R304_349	304	349	2.3027410874647480e+03
C304_349	304	349	3.8450644170110366e-10
R304_350	304	350	1.2572788444419896e+03
C304_350	304	350	7.0423421631099671e-10
R304_366	304	366	2.3048825081178043e+03
C304_366	304	366	3.8414920438744808e-10
R304_370	304	370	2.7324087756197732e+03
C304_370	304	370	3.2404330918574472e-10
R304_371	304	371	4.3572597717796316e+03
C304_371	304	371	2.0320541534717113e-10
R304_372	304	372	2.8677284691357931e+03
C304_372	304	372	3.0875265605841206e-10
R304_373	304	373	2.7812220615751644e+03
C304_373	304	373	3.1835601836069757e-10
R305_306	305	306	2.9166668246849936e+03
C305_306	305	306	3.0357213727887045e-10
R305_307	305	307	3.4677717848643679e+03
C305_307	305	307	2.5532786948799475e-10
R305_350	305	350	3.6805753324719831e+03
C305_350	305	350	2.4056531974454296e-10
R305_359	305	359	7.7582079307376318e+02
C305_359	305	359	1.1412671452024573e-09
R305_368	305	368	4.2804685867481448e+03
C305_368	305	368	2.0685090049280075e-10
R305_369	305	369	3.6566926759784278e+03
C305_369	305	369	2.4213650425601788e-10
R305_371	305	371	3.3486469708194763e+03
C305_371	305	371	2.6441090667832374e-10
R305_372	305	372	6.3040832556236519e+03
C305_372	305	372	1.4045163202915334e-10
R305_373	305	373	1.5495011620506664e+03
C305_373	305	373	5.7142182489763644e-10
R305_374	305	374	1.0248277176944850e+03
C305_374	305	374	8.6396841772770576e-10
R306_307	306	307	6.8342913235740334e+03
C306_307	306	307	1.2955531741028639e-10
R306_372	306	372	4.9947995138133792e+03
C306_372	306	372	1.7726813243481109e-10
R306_374	306	374	9.0058989119213566e+03
C306_374	306	374	9.8315425296185232e-11
R307_368	307	368	5.6655372632959661e+03
C307_368	307	368	1.5628152116060771e-10
R307_374	307	374	9.8483113431705842e+03
C307_374	307	374	8.9905644820419208e-11
R308_312	308	312	5.8206928820316352e+03
C308_312	308	312	1.5211570162605052e-10
R308_313	308	313	8.6319958366602095e+03
C308_313	308	313	1.0257405106008206e-10
R308_354	308	354	1.7931473356791414e+03
C308_354	308	354	4.9377915806603488e-10
R308_355	308	355	2.6611059170967501e+03
C308_355	308	355	3.3272587010215149e-10
R308_365	308	365	6.7933147146401616e+03
C308_365	308	365	1.3033678239458692e-10
R308_375	308	375	7.6665913750451873e+03
C308_375	308	375	1.1549054050044260e-10
R309_310	309	310	6.0662331430365039e+03
C309_310	309	310	1.4595858102097214e-10
R309_319	309	319	6.0365927193784219e+03
C309_319	309	319	1.4667525587036294e-10
R309_335	309	335	4.5098464082803348e+03
C309_335	309	335	1.9633014110509858e-10
R309_361	309	361	3.4664949546921562e+03
C309_361	309	361	2.5542191558695928e-10
R309_364	309	364	5.9320257936787466e+03
C309_364	309	364	1.4926077743011757e-10
R309_378	309	378	8.5440406729882270e+03
C309_378	309	378	1.0362998206448496e-10
R309_379	309	379	5.0978668868752675e+03
C309_379	309	379	1.7368417052621723e-10
R310_335	310	335	6.4081769211230267e+03
C310_335	310	335	1.3817015238474896e-10
R310_379	310	379	2.1224456667381364e+04
C310_379	310	379	4.1716911559896319e-11
R311_312	311	312	2.2342995052121328e+03
C311_312	311	312	3.9628473247857389e-10
R311_313	311	313	3.9535105945912915e+03
C311_313	311	313	2.2395760945002180e-10
R311_337	311	337	1.2456480489516800e+03
C311_337	311	337	7.1080975275894034e-10
R311_338	311	338	5.3772238501693564e+03
C311_338	311	338	1.6466094891551033e-10
R311_382	311	382	1.7933728809062884e+03
C311_382	311	382	4.9371705746579050e-10
R311_383	311	383	8.4947693099166700e+03
C311_383	311	383	1.0423105671232005e-10
R312_313	312	313	1.2255804941051026e+03
C312_313	312	313	7.2244849355775450e-10
R312_337	312	337	5.0616700483601535e+03
C312_337	312	337	1.7492621471580357e-10
R312_340	312	340	1.8847672079430297e+03
C312_340	312	340	4.6977620258276645e-10
R312_342	312	342	1.8731356067142995e+03
C312_342	312	342	4.7269336962374477e-10
R312_355	312	355	1.9389766923837244e+03
C312_355	312	355	4.5664230270426332e-10
R312_382	312	382	2.9902798920807468e+03
C312_382	312	382	2.9609896519883735e-10
R312_385	312	385	1.9560667110007726e+03
C312_385	312	385	4.5265265070995335e-10
R312_386	312	386	3.3370374621832475e+03
C312_386	312	386	2.6533078868126261e-10
R313_355	313	355	4.5720030682149418e+03
C313_355	313	355	1.9366102088940553e-10
R313_375	313	375	3.8522482757092980e+03
C313_375	313	375	2.2984468246324850e-10
R313_382	313	382	3.4833942499269997e+03
C313_382	313	382	2.5418276490482109e-10
R313_383	313	383	6.4136325311882401e+03
C313_383	313	383	1.3805262109956903e-10
R313_385	313	385	4.2000416416126991e+03
C313_385	313	385	2.1081190551244726e-10
R313_386	313	386	4.0290766034260309e+03
C313_386	313	386	2.1975724684586657e-10
R313_389	313	389	3.0734335295859223e+03
C313_389	313	389	2.8808782528616806e-10
R313_387	313	387	1.2150573873980638e+04
C313_387	313	387	7.2870531950432791e-11
R314_318	314	318	1.3002161301023871e+03
C314_318	314	318	6.8097815524737168e-10
R314_319	314	319	3.0804067143343050e+03
C314_319	314	319	2.8743567451006047e-10
R314_317	314	317	1.5923561690263848e+03
C314_317	314	317	5.5604317609506435e-10
R314_322	314	322	3.0561268237043746e+03
C314_322	314	322	2.8971925341330292e-10
R314_329	314	329	3.7191594638598031e+03
C314_329	314	329	2.3806959349387470e-10
R314_357	314	357	1.7789435797652377e+03
C314_357	314	357	4.9772167693865051e-10
R314_392	314	392	4.9839483140098637e+03
C314_392	314	392	1.7765408586021862e-10
R315_316	315	316	9.0986288810594106e+03
C315_316	315	316	9.7313429668856363e-11
R315_318	315	318	1.0476569657705488e+04
C315_318	315	318	8.4514188386918916e-11
R315_322	315	322	6.2279722256183622e+03
C315_322	315	322	1.4216806845378778e-10
R315_324	315	324	5.9035203966531453e+03
C315_324	315	324	1.4998148938419294e-10
R315_393	315	393	6.7625456560698212e+03
C315_393	315	393	1.3092980465208092e-10
R316_318	316	318	1.3554203389262600e+03
C316_318	316	318	6.5324295074501637e-10
R316_319	316	319	2.7798769537244020e+03
C316_319	316	319	3.1851006229385107e-10
R316_335	316	335	4.7566091553685683e+03
C316_335	316	335	1.8614495174586045e-10
R316_393	316	393	8.6400835406663027e+03
C316_393	316	393	1.0247803479359862e-10
R316_395	316	395	6.2882932490775484e+03
C316_395	316	395	1.4080430835980578e-10
R317_319	317	319	1.5518435555671533e+03
C317_319	317	319	5.7055930575192894e-10
R317_318	317	318	2.3191986794348531e+03
C317_318	317	318	3.8177789145506096e-10
R317_322	317	322	5.9946459477752351e+03
C317_322	317	322	1.4770159729426581e-10
R317_357	317	357	3.7663234239856160e+03
C317_357	317	357	2.3508835594448984e-10
R317_361	317	361	2.3281998238504952e+03
C317_361	317	361	3.8030188501416923e-10
R317_363	317	363	4.1171301960101273e+03
C317_363	317	363	2.1505727036712402e-10
R317_390	317	390	6.4524857501030856e+03
C317_390	317	390	1.3722134631383797e-10
R317_392	317	392	1.5029341836340284e+03
C317_392	317	392	5.8912678368862204e-10
R317_393	317	393	6.4827442227377242e+03
C317_393	317	393	1.3658086009231433e-10
R317_394	317	394	2.3191986794348554e+03
C317_394	317	394	3.8177789145506060e-10
R317_395	317	395	1.8408749051310454e+03
C317_395	317	395	4.8097715886727799e-10
R318_319	318	319	8.9630877502332658e+02
C318_319	318	319	9.8785017660566480e-10
R318_322	318	322	1.6377923911181340e+03
C318_322	318	322	5.4061722749579859e-10
R318_393	318	393	3.0195804272397768e+03
C318_393	318	393	2.9322576531249031e-10
R318_395	318	395	3.8968970637720831e+03
C318_395	318	395	2.2721123170827113e-10
R319_335	319	335	2.8366298125813832e+03
C319_335	319	335	3.1213758586787652e-10
R319_361	319	361	3.3773924526320475e+03
C319_361	319	361	2.6216046672632951e-10
R319_395	319	395	4.5195393364671254e+03
C319_395	319	395	1.9590907740436270e-10
R320_321	320	321	5.6288938590006173e+03
C320_321	320	321	1.5729889457485740e-10
R320_323	320	323	7.1187409600859019e+03
C320_323	320	323	1.2437856450522058e-10
R320_329	320	329	7.8971948558608156e+03
C320_329	320	329	1.1211813787814755e-10
R320_331	320	331	8.4433407885009201e+03
C320_331	320	331	1.0486592971657165e-10
R320_333	320	333	3.8353467226944517e+03
C320_333	320	333	2.3085755883837430e-10
R320_334	320	334	2.0771880838888461e+04
C320_334	320	334	4.2625835790582193e-11
R320_391	320	391	5.7898543369493518e+03
C320_391	320	391	1.5292591664171700e-10
R320_396	320	396	1.1823073140529152e+04
C320_396	320	396	7.4889055592899143e-11
R321_323	321	323	2.9075222331033715e+03
C321_323	321	323	3.0452691698076539e-10
R321_325	321	325	4.5603389167276619e+03
C321_325	321	325	1.9415635501392628e-10
R321_334	321	334	7.4170425114337440e+03
C321_334	321	334	1.1937625816962523e-10
R321_396	321	396	8.9537374054864522e+03
C321_396	321	396	9.8888178377607396e-11
R322_323	322	323	2.6255819764580187e+03
C322_323	322	323	3.3722762787031848e-10
R322_324	322	324	8.2654719202950637e+03
C322_324	322	324	1.0712259266478664e-10
R322_329	322	329	1.0144259902955402e+04
C322_329	322	329	8.7282738235250087e-11
R322_392	322	392	4.4606204872463195e+03
C322_392	322	392	1.9849677510820845e-10
R322_393	322	393	4.9618235489430854e+03
C322_393	322	393	1.7844624520930462e-10
R322_397	322	397	1.6855960064764695e+04
C322_397	322	397	5.2528528680538281e-11
R323_324	323	324	5.8145619534563530e+03
C323_324	323	324	1.5227609384636105e-10
R323_325	323	325	1.8392556425432324e+03
C323_325	323	325	4.8140060642993949e-10
R323_329	323	329	3.9870458319920308e+03
C323_329	323	329	2.2207389104870713e-10
R323_391	323	391	1.9803222740055346e+03
C323_391	323	391	4.4710842943209021e-10
R323_392	323	392	3.8005890460368305e+03
C323_392	323	392	2.3296882956164254e-10
R323_396	323	396	1.3664297793139770e+03
C323_396	323	396	6.4797971699982198e-10
R323_397	323	397	4.4503854975938384e+03
C323_397	323	397	1.9895327768318356e-10
R324_325	324	325	2.0218162147742712e+03
C324_325	324	325	4.3793237744848831e-10
R324_326	324	326	7.8510511631068839e+03
C324_326	324	326	1.1277709994563513e-10
R324_393	324	393	8.0224989344768292e+03
C324_393	324	393	1.1036695535039555e-10
R324_397	324	397	3.9734412724074573e+03
C324_397	324	397	2.2283424392064465e-10
R325_326	325	326	1.4225776369322509e+03
C325_326	325	326	6.2240454138543974e-10
R325_334	325	334	2.2089849594191951e+03
C325_334	325	334	4.0082607983569160e-10
R325_396	325	396	1.5134059103323423e+03
C325_396	325	396	5.8505043204540095e-10
R325_397	325	397	2.0641661408677851e+03
C325_397	325	397	4.2894743992252763e-10
R325_398	325	398	6.4581765743607393e+03
C325_398	325	398	1.3710042943315512e-10
R326_334	326	334	1.2048287591063221e+04
C326_334	326	334	7.3489180516968781e-11
R326_397	326	397	1.2168143977894497e+04
C326_397	326	397	7.2765311070325421e-11
R326_398	326	398	1.2369241869859861e+04
C326_398	326	398	7.1582299951422277e-11
R327_330	327	330	2.5914047292083987e+03
C327_330	327	330	3.4167522028505002e-10
R327_328	327	328	2.8922078305296141e+03
C327_328	327	328	3.0613940407521283e-10
R327_350	327	350	1.8618830035058252e+03
C327_350	327	350	4.7555017153752652e-10
R327_352	327	352	1.6450349418049534e+03
C327_352	327	352	5.3823706670236877e-10
R327_356	327	356	6.8000432573903990e+03
C327_356	327	356	1.3020781606612757e-10
R327_359	327	359	1.9287025101646029e+03
C327_359	327	359	4.5907483245015065e-10
R327_362	327	362	2.1062466686143130e+03
C327_362	327	362	4.2037753454703939e-10
R327_369	327	369	6.1528425827208439e+03
C327_369	327	369	1.4390401993812421e-10
R327_371	327	371	6.1405796458784798e+03
C327_371	327	371	1.4419140093627607e-10
R327_399	327	399	3.7100607324563866e+03
C327_399	327	399	2.3865344681669805e-10
R328_330	328	330	3.2218265414769794e+03
C328_330	328	330	2.7481888621294248e-10
R328_339	328	339	2.8130670189681059e+03
C328_339	328	339	3.1475211067839777e-10
R328_348	328	348	1.8559399352292030e+03
C328_348	328	348	4.7707297251010095e-10
R328_350	328	350	3.1407494751722334e+03
C328_350	328	350	2.8191321488685282e-10
R328_351	328	351	7.3797499914686216e+02
C328_351	328	351	1.1997950916001091e-09
R328_352	328	352	1.6021061186331765e+03
C328_352	328	352	5.5265925983441575e-10
R328_399	328	399	3.3882470507772491e+03
C328_399	328	399	2.6132060868964345e-10
R329_331	329	331	4.7779137832694951e+03
C329_331	329	331	1.8531493489907928e-10
R329_356	329	356	3.5120052814695669e+03
C329_356	329	356	2.5211203023291143e-10
R329_357	329	357	3.8199906072960143e+03
C329_357	329	357	2.3178559130718521e-10
R329_390	329	390	6.4000328849375392e+03
C329_390	329	390	1.3834597378145212e-10
R329_391	329	391	3.5156124428764829e+03
C329_391	329	391	2.5185335303215285e-10
R329_392	329	392	7.9652016327908923e+03
C329_392	329	392	1.1116087483020340e-10
R329_402	329	402	8.5208023322668323e+03
C329_402	329	402	1.0391260672097385e-10
R330_331	330	331	4.8175957009091098e+03
C330_331	330	331	1.8378851955819293e-10
R330_339	330	339	2.5987094282613834e+03
C330_339	330	339	3.4071480715424669e-10
R330_356	330	356	2.1858707164728862e+03
C330_356	330	356	4.0506456993426802e-10
R330_399	330	399	4.1993912122261800e+03
C330_399	330	399	2.1084455744970287e-10
R330_403	330	403	7.0653777713824575e+03
C330_403	330	403	1.2531796746754183e-10
R331_332	331	332	9.5454850333770980e+02
C331_332	331	332	9.2757861816765905e-10
R331_333	331	333	5.2729354523312509e+02
C331_333	331	333	1.6791762192130416e-09
R331_339	331	339	3.7418959914260399e+03
C331_339	331	339	2.3662303381194895e-10
R331_356	331	356	1.8398612711342541e+03
C331_356	331	356	4.8124214341125242e-10
R331_391	331	391	2.4745420447760202e+03
C331_391	331	391	3.5781116896728364e-10
R331_401	331	401	2.2680015474679203e+03
C331_401	331	401	3.9039602185832449e-10
R331_402	331	402	1.1496245229995245e+03
C331_402	331	402	7.7018084077558102e-10
R331_403	331	403	1.0008046167294716e+03
C331_403	331	403	8.8470693170207312e-10
R332_333	332	333	1.2227229417903338e+03
C332_333	332	333	7.2413688452066933e-10
R332_339	332	339	2.5262502690725173e+03
C332_339	332	339	3.5048735770152783e-10
R332_343	332	343	2.4275170047921270e+03
C332_343	332	343	3.6474256614973553e-10
R332_344	332	344	2.3518651457458973e+03
C332_344	332	344	3.7647514922425046e-10
R332_345	332	345	1.2746239634338101e+03
C332_345	332	345	6.9465097715148910e-10
R332_401	332	401	6.5056775372048969e+02
C332_401	332	401	1.3609939574109480e-09
R332_403	332	403	1.2534110147602805e+03
C332_403	332	403	7.0640737258028623e-10
R333_334	333	334	2.5491399040765277e+03
C333_334	333	334	3.4734020690039730e-10
R333_343	333	343	6.9485921085808070e+02
C333_343	333	343	1.2742419872460170e-09
R333_391	333	391	1.1393490814149375e+03
C333_391	333	391	7.7712686668462836e-10
R333_396	333	396	2.5801536232525700e+03
C333_396	333	396	3.4316514091274586e-10
R333_401	333	401	7.1743532312761999e+02
C333_401	333	401	1.2341443934486880e-09
R333_402	333	402	1.5591844822720016e+03
C333_402	333	402	5.6787300782380268e-10
R333_406	333	406	1.1959184450412592e+03
C333_406	333	406	7.4036719257177514e-10
R334_343	334	343	3.0779652088924704e+03
C334_343	334	343	2.8766367441125037e-10
R334_396	334	396	8.4094568049062138e+02
C334_396	334	396	1.0528846300553356e-09
R334_398	334	398	2.2819125096005719e+03
C334_398	334	398	3.8801609525992946e-10
R334_404	334	404	4.7321381645453375e+03
C334_404	334	404	1.8710755073337356e-10
R334_406	334	406	2.4718905290264524e+03
C334_406	334	406	3.5819498125134212e-10
R335_361	335	361	4.2299870248667103e+03
C335_361	335	361	2.0931950299017765e-10
R335_379	335	379	4.4848200641548819e+03
C335_379	335	379	1.9742570917766535e-10
R335_395	335	395	5.6632980916466140e+03
C335_395	335	395	1.5634331221342493e-10
R335_410	335	410	9.5792545185701183e+03
C335_410	335	410	9.2430865051507722e-11
R336_337	336	337	3.2212344069508222e+03
C336_337	336	337	2.7486940403636306e-10
R336_339	336	339	2.2642037050704935e+03
C336_339	336	339	3.9105084923109134e-10
R336_341	336	341	1.5012072098609851e+03
C336_341	336	341	5.8980450925358365e-10
R336_342	336	342	2.3028680210423618e+03
C336_342	336	342	3.8448524779080792e-10
R336_344	336	344	1.9139176225059807e+03
C336_344	336	344	4.6262115531423989e-10
R336_346	336	346	1.1934039116672973e+03
C336_346	336	346	7.4192716568440492e-10
R336_347	336	347	5.4106307879417764e+03
C336_347	336	347	1.6364428038099722e-10
R336_412	336	412	2.8081080362465964e+03
C336_412	336	412	3.1530794765413578e-10
R337_338	337	338	9.6197825272416867e+03
C337_338	337	338	9.2041455115293461e-11
R337_342	337	342	3.1170547095675211e+03
C337_342	337	342	2.8405622108020318e-10
R337_347	337	347	2.4537891685473464e+03
C337_347	337	347	3.6083735027006082e-10
R337_382	337	382	3.5149513781384726e+03
C337_382	337	382	2.5190071965345943e-10
R337_412	337	412	6.2467166084055352e+03
C337_412	337	412	1.4174146791109224e-10
R338_347	338	347	1.3201204547471862e+04
C338_347	338	347	6.7071059956385945e-11
R338_382	338	382	8.9118769249759771e+03
C338_382	338	382	9.9352671626172268e-11
R338_383	338	383	1.2291054788468820e+04
C338_383	338	383	7.2037656404451080e-11
R338_413	338	413	1.1966939628530779e+04
C338_413	338	413	7.3988739743371290e-11
R338_411	338	411	4.1766794519377720e+04
C338_411	338	411	2.1199107853230385e-11
R339_341	339	341	2.2829158343544150e+03
C339_341	339	341	3.8784556503388892e-10
R339_344	339	344	1.7045666628475865e+03
C339_344	339	344	5.1943922229527354e-10
R339_348	339	348	2.7727600593815223e+03
C339_348	339	348	3.1932758794047867e-10
R339_399	339	399	4.2046702616871544e+03
C339_399	339	399	2.1057983779796306e-10
R339_403	339	403	1.5806193905809362e+03
C339_403	339	403	5.6017203570720190e-10
R339_418	339	418	3.8384751815324039e+03
C339_418	339	418	2.3066940381949304e-10
R340_342	340	342	2.8927658649686177e+03
C340_342	340	342	3.0608034767777713e-10
R340_341	340	341	6.9806002417486898e+03
C340_341	340	341	1.2683992078569399e-10
R340_348	340	348	4.1570016172992146e+03
C340_348	340	348	2.1299457234160345e-10
R340_351	340	351	4.0249474825292673e+03
C340_351	340	351	2.1998269183467837e-10
R340_353	340	353	1.6253400921429695e+03
C340_353	340	353	5.4475908517865824e-10
R340_355	340	355	3.9860213072720803e+03
C340_355	340	355	2.2213097057074078e-10
R340_385	340	385	4.1717195763266618e+03
C340_385	340	385	2.1224312073239616e-10
R340_386	340	386	2.8180615557820934e+03
C340_386	340	386	3.1419426587162353e-10
R340_419	340	419	1.9744385492871352e+03
C340_419	340	419	4.4844078941817549e-10
R341_342	341	342	8.9558514951542656e+02
C341_342	341	342	9.8864835150412329e-10
R341_344	341	344	1.1791892525887979e+03
C341_344	341	344	7.5087080361031722e-10
R341_346	341	346	3.3428379906842324e+03
C341_346	341	346	2.6487038383776631e-10
R341_348	341	348	6.5884459084681725e+02
C341_348	341	348	1.3438962602120868e-09
R341_412	341	412	1.5970512903118815e+03
C341_412	341	412	5.5440848210146734e-10
R341_414	341	414	1.2838306961106261e+03
C341_414	341	414	6.8966942789448971e-10
R341_418	341	418	1.4614328029138203e+03
C341_418	341	418	6.0585664967601836e-10
R341_419	341	419	2.1522731700478112e+03
C341_419	341	419	4.1138773368639402e-10
R341_420	341	420	6.7661852568882296e+02
C341_420	341	420	1.3085937616009118e-09
R342_382	342	382	3.2372167266549181e+03
C342_382	342	382	2.7351235844345871e-10
R342_385	342	385	1.7183593419298447e+03
C342_385	342	385	5.1526986241749016e-10
R342_412	342	412	1.5381584554609171e+03
C342_412	342	412	5.7563561059428023e-10
R342_419	342	419	3.9029041590248867e+03
C342_419	342	419	2.2686152301552180e-10
R342_420	342	420	3.7419195226416123e+03
C342_420	342	420	2.3662154579822114e-10
R343_345	343	345	7.0806899494515201e+03
C343_345	343	345	1.2504696407001774e-10
R343_401	343	401	1.6660741486509905e+03
C343_401	343	401	5.3144020175627705e-10
R343_404	343	404	7.5045507241833448e+03
C343_404	343	404	1.1798424905660858e-10
R343_406	343	406	7.6234084654910266e+03
C343_406	343	406	1.1614473836841298e-10
R343_423	343	423	1.1533947554142398e+04
C343_423	343	423	7.6766326320081385e-11
R344_345	344	345	1.5134895092274267e+03
C344_345	344	345	5.8501811628147285e-10
R344_346	344	346	1.7249194754954171e+03
C344_346	344	346	5.1331021202928752e-10
R344_401	344	401	4.2765686252199857e+03
C344_401	344	401	2.0703953550013577e-10
R344_403	344	403	3.2781414146416323e+03
C344_403	344	403	2.7009779924237788e-10
R344_414	344	414	2.6691822147472944e+03
C344_414	344	414	3.3171912236191314e-10
R344_418	344	418	1.3549441034214635e+03
C344_418	344	418	6.5347255245745383e-10
R344_423	344	423	8.1336644284106233e+03
C344_423	344	423	1.0885853350517652e-10
R344_424	344	424	3.5890808225148198e+03
C344_424	344	424	2.4669792224951884e-10
R345_346	345	346	1.0777497306125530e+04
C345_346	345	346	8.2154396011471121e-11
R345_401	345	401	3.7065116543932795e+03
C345_401	345	401	2.3888196348999060e-10
R345_423	345	423	7.3783101713370888e+03
C345_423	345	423	1.2000292223274013e-10
R345_424	345	424	1.2669136128465687e+04
C345_424	345	424	6.9887857603060563e-11
R346_347	346	347	4.3248451502391536e+03
C346_347	346	347	2.0472843557208947e-10
R346_412	346	412	2.0786048146550911e+03
C346_412	346	412	4.2596782969874928e-10
R346_414	346	414	2.5297574868246697e+03
C346_414	346	414	3.5000144729737334e-10
R346_424	346	424	5.2141817793672126e+03
C346_424	346	424	1.6980972646631693e-10
R346_426	346	426	4.9840100105908214e+03
C346_426	346	426	1.7765188669736234e-10
R347_382	347	382	4.2765641952333544e+03
C347_382	347	382	2.0703974996724826e-10
R347_412	347	412	1.6277135489315117e+03
C347_412	347	412	5.4396474261777815e-10
R347_413	347	413	5.3966951507708754e+03
C347_413	347	413	1.6406685146436796e-10
R347_426	347	426	8.2303869291317078e+03
C347_426	347	426	1.0757924133141699e-10
R348_351	348	351	9.9537233124531576e+02
C348_351	348	351	8.8953525621135955e-10
R348_352	348	352	1.8147082341444950e+03
C348_352	348	352	4.8791247267217674e-10
R348_353	348	353	2.4384099591559198e+03
C348_353	348	353	3.6311317478644841e-10
R348_399	348	399	1.2847681614851365e+03
C348_399	348	399	6.8916619219182265e-10
R348_418	348	418	1.7369661454164604e+03
C348_418	348	418	5.0975016642463645e-10
R348_419	348	419	9.5032987548089716e+02
C348_419	348	419	9.3169625047507861e-10
R348_420	348	420	2.1163366279178135e+03
C348_420	348	420	4.1837332020810487e-10
R348_421	348	421	1.6045657139594989e+03
C348_421	348	421	5.5181210342273899e-10
R348_428	348	428	1.1596930406323772e+03
C348_428	348	428	7.6349408910584127e-10
R349_350	349	350	1.0658103762850426e+03
C349_350	349	350	8.3074700847461233e-10
R349_351	349	351	7.7233138531294151e+02
C349_351	349	351	1.1464234116825858e-09
R349_353	349	353	1.3064586283601434e+03
C349_353	349	353	6.7772431708103215e-10
R349_354	349	354	9.2130831238954067e+02
C349_354	349	354	9.6104503757655678e-10
R349_366	349	366	1.2501707305786342e+03
C349_366	349	366	7.0823829101341170e-10
R349_370	349	370	1.0559892821069855e+03
C349_370	349	370	8.3847326549882121e-10
R349_429	349	429	2.0659821776394351e+03
C349_429	349	429	4.2857038714228809e-10
R350_351	350	351	1.5919279325879552e+03
C350_351	350	351	5.5619275444246899e-10
R350_352	350	352	1.2769721671422317e+03
C350_352	350	352	6.9337359457215194e-10
R350_359	350	359	3.6384761603008756e+03
C350_359	350	359	2.4334879292620744e-10
R350_370	350	370	3.4950487296983461e+03
C350_370	350	370	2.5333517503672107e-10
R350_371	350	371	8.2121064019645075e+02
C350_371	350	371	1.0781871767859575e-09
R350_429	350	429	1.6182977068767261e+03
C350_429	350	429	5.4712972646351698e-10
R351_352	351	352	4.3861406142774340e+03
C351_352	351	352	2.0186739540858578e-10
R351_353	351	353	2.2254456162317956e+03
C351_353	351	353	3.9786134302361566e-10
R351_428	351	428	7.3752127344156288e+03
C351_428	351	428	1.2005332097992098e-10
R351_429	351	429	4.3502714318710614e+03
C351_429	351	429	2.0353184751030112e-10
R352_362	352	362	3.3676863046281219e+03
C352_362	352	362	2.6291605025182794e-10
R352_369	352	369	4.1111393999069305e+03
C352_369	352	369	2.1537065411113144e-10
R352_371	352	371	1.6700874896517437e+03
C352_371	352	371	5.3016311252330418e-10
R352_399	352	399	1.0191979695505393e+03
C352_399	352	399	8.6874072373835752e-10
R352_400	352	400	1.7086742871690474e+03
C352_400	352	400	5.1819049911904086e-10
R352_428	352	428	1.2445456806487550e+03
C352_428	352	428	7.1143935933187300e-10
R352_429	352	429	2.4369717543329871e+03
C352_429	352	429	3.6332746989197019e-10
R353_354	353	354	2.5380400162366573e+03
C353_354	353	354	3.4885926779550042e-10
R353_355	353	355	1.8495193424418087e+03
C353_355	353	355	4.7872912782357553e-10
R353_370	353	370	3.7154186754199895e+03
C353_370	353	370	2.3830928868330369e-10
R353_386	353	386	2.7095407021452879e+03
C353_386	353	386	3.2677818089204816e-10
R353_419	353	419	2.7426940568619270e+03
C353_419	353	419	3.2282812568349617e-10
R353_428	353	428	2.1652547302961716e+03
C353_428	353	428	4.0892130118052629e-10
R353_429	353	429	1.3173472018924031e+03
C353_429	353	429	6.7212256603883421e-10
R353_430	353	430	8.8742370407673388e+02
C353_430	353	430	9.9774073831077156e-10
R354_355	354	355	1.4193409434082821e+03
C354_355	354	355	6.2382388517154460e-10
R354_365	354	365	3.6616440954227523e+03
C354_365	354	365	2.4180907773281954e-10
R354_366	354	366	3.9221631927315934e+03
C354_366	354	366	2.2574756280942748e-10
R354_370	354	370	2.4872675452747308e+03
C354_370	354	370	3.5598051499610637e-10
R354_375	354	375	9.0914555736051898e+03
C354_375	354	375	9.7390211559807428e-11
R354_376	354	376	1.9876532949604607e+03
C354_376	354	376	4.4545936856538811e-10
R354_430	354	430	6.0867206648561223e+03
C354_430	354	430	1.4546729354811445e-10
R355_375	355	375	4.0905405357120076e+03
C355_375	355	375	2.1645520291754844e-10
R355_376	355	376	2.8428058558763787e+03
C355_376	355	376	3.1145946173909352e-10
R355_386	355	386	5.9724094733967308e+02
C355_386	355	386	1.4825151986714496e-09
R355_430	355	430	3.8989026651645368e+03
C355_430	355	430	2.2709435390909782e-10
R356_357	356	357	6.6495808760643349e+03
C356_357	356	357	1.3315407364802965e-10
R356_362	356	362	5.4864933652767977e+03
C356_362	356	362	1.6138154605338341e-10
R356_390	356	390	5.2010141888556300e+03
C356_390	356	390	1.7023963972203991e-10
R356_399	356	399	3.1656649184690268e+03
C356_399	356	399	2.7969441002246213e-10
R356_402	356	402	4.0557386378730494e+03
C356_402	356	402	2.1831258391056977e-10
R356_403	356	403	7.5155132174578039e+03
C356_403	356	403	1.1781215148996858e-10
R356_405	356	405	3.7643942771607858e+03
C356_405	356	405	2.3520883215448100e-10
R356_407	356	407	9.9620825781477943e+03
C356_407	356	407	8.8878883983776607e-11
R356_431	356	431	7.1889054708814483e+03
C356_431	356	431	1.2316461598867522e-10
R357_358	357	358	2.5518255006227341e+03
C357_358	357	358	3.4697465852736686e-10
R357_360	357	360	3.4576356831475237e+03
C357_360	357	360	2.5607636629142885e-10
R357_362	357	362	2.6851865835206581e+03
C357_362	357	362	3.2974199526168173e-10
R357_363	357	363	1.0664231205063907e+03
C357_363	357	363	8.3026967877399311e-10
R357_390	357	390	1.5102812450141155e+03
C357_390	357	390	5.8626086010339407e-10
R357_392	357	392	4.5889043239291532e+03
C357_392	357	392	1.9294775379885863e-10
R357_431	357	431	3.8843431015402234e+03
C357_431	357	431	2.2794556468220149e-10
R358_359	358	359	1.2583288285324620e+03
C358_359	358	359	7.0364658396377072e-10
R358_360	358	360	9.5300868502124456e+02
C358_360	358	360	9.2907734799947014e-10
R358_362	358	362	2.4552956200103454e+03
C358_362	358	362	3.6061595780318690e-10
R358_363	358	363	3.3530744786921382e+03
C358_363	358	363	2.6406176997456869e-10
R358_368	358	368	2.8561685010828437e+03
C358_368	358	368	3.1000229200914311e-10
R358_432	358	432	2.6847682019990348e+03
C358_432	358	432	3.2979338068766297e-10
R359_362	359	362	2.6904542528799448e+03
C359_362	359	362	3.2909638985766835e-10
R359_368	359	368	3.4997197679415026e+03
C359_368	359	368	2.5299705130985213e-10
R359_369	359	369	2.0123349477152121e+03
C359_369	359	369	4.3999572869581032e-10
R359_371	359	371	4.7765391086079571e+03
C359_371	359	371	1.8536826802158033e-10
R359_432	359	432	4.7560751563564345e+03
C359_432	359	432	1.8616585158807866e-10
R360_363	360	363	1.6080809988149351e+03
C360_363	360	363	5.5060583537303383e-10
R360_364	360	364	1.2127446519289019e+03
C360_364	360	364	7.3009497942680557e-10
R360_368	360	368	4.0823340765776084e+03
C360_368	360	368	2.1689032918204569e-10
R360_432	360	432	4.0933096446718396e+03
C360_432	360	432	2.1630877176676042e-10
R361_363	361	363	1.3745628612451155e+03
C361_363	361	363	6.4414571836893968e-10
R361_364	361	364	4.7078304369130701e+03
C361_364	361	364	1.8807363467418556e-10
R361_378	361	378	1.1466973550959576e+03
C361_378	361	378	7.7214687708589567e-10
R361_379	361	379	4.3130591416429625e+03
C361_379	361	379	2.0528788329174639e-10
R361_394	361	394	1.3228068432245207e+03
C361_394	361	394	6.6934850408066540e-10
R361_395	361	395	3.2625835466340754e+03
C361_395	361	395	2.7138578033149966e-10
R361_410	361	410	1.5528201190366610e+03
C361_410	361	410	5.7020048287968891e-10
R361_409	361	409	2.6773342185851302e+03
C361_409	361	409	3.3070909696433438e-10
R361_433	361	433	3.3537600323642746e+03
C361_433	361	433	2.6400779219609616e-10
R362_363	362	363	4.2606721903277730e+03
C362_363	362	363	2.0781199354177134e-10
R362_369	362	369	1.2604644566828144e+03
C362_369	362	369	7.0245438259335904e-10
R362_399	362	399	1.9019558396979994e+03
C362_399	362	399	4.6553067280499555e-10
R362_400	362	400	2.9566898281541639e+03
C362_400	362	400	2.9946285649203837e-10
R362_431	362	431	1.1155127318026355e+03
C362_431	362	431	7.9373256481724764e-10
R362_432	362	432	1.4903543875692901e+03
C362_432	362	432	5.9409949008442469e-10
R362_434	362	434	2.6375404304041267e+03
C362_434	362	434	3.3569865754222210e-10
R363_364	363	364	3.4415785395025796e+03
C363_364	363	364	2.5727112472870423e-10
R363_378	363	378	5.9844970523483198e+03
C363_378	363	378	1.4795207917306289e-10
R363_390	363	390	4.3777015930780854e+03
C363_390	363	390	2.0225654098945497e-10
R363_394	363	394	3.3528484089159251e+03
C363_394	363	394	2.6407957465225281e-10
R363_431	363	431	3.5544874877201187e+03
C363_431	363	431	2.4909886017573683e-10
R363_432	363	432	1.3615028614653770e+03
C363_432	363	432	6.5032458378165233e-10
R363_433	363	433	8.7291456077007660e+02
C363_433	363	433	1.0143246790601045e-09
R363_435	363	435	5.1011322837210982e+03
C363_435	363	435	1.7357298977044325e-10
R364_368	364	368	3.2618356997107367e+03
C364_368	364	368	2.7144800143628329e-10
R364_378	364	378	4.4847008433709816e+03
C364_378	364	378	1.9743095752056095e-10
R364_432	364	432	5.5584065091131188e+03
C364_432	364	432	1.5929363572965352e-10
R364_435	364	435	4.7436947622536527e+03
C364_435	364	435	1.8665171898188326e-10
R365_366	365	366	3.9941931235395496e+03
C365_366	365	366	2.2167650744823406e-10
R365_367	365	367	8.2334780391675831e+03
C365_367	365	367	1.0753885265594482e-10
R365_370	365	370	6.8214135762059050e+03
C365_370	365	370	1.2979989730991701e-10
R365_375	365	375	8.2521251646643250e+03
C365_375	365	375	1.0729584973957635e-10
R365_376	365	376	3.6516069958767744e+03
C365_376	365	376	2.4247373353698088e-10
R365_380	365	380	7.2958969405734833e+03
C365_380	365	380	1.2135845515800323e-10
R365_377	365	377	6.6387484275959605e+03
C365_377	365	377	1.3337134120333435e-10
R365_438	365	438	4.8392504571028576e+03
C365_438	365	438	1.8296609971910382e-10
R365_439	365	439	6.6822489878511187e+03
C365_439	365	439	1.3250311134915276e-10
R366_367	366	367	5.1096616549364180e+03
C366_367	366	367	1.7328325073042780e-10
R366_370	366	370	1.4122981692041460e+03
C366_370	366	370	6.2693473730051535e-10
R366_372	366	372	2.6977492943722086e+03
C366_372	366	372	3.2820647328018130e-10
R366_439	366	439	6.3160171785485427e+03
C366_439	366	439	1.4018625292964680e-10
R367_372	367	372	6.5367670221045882e+03
C367_372	367	372	1.3545209408655490e-10
R367_377	367	377	2.1127998947053351e+04
C367_377	367	377	4.1907365856977492e-11
R367_439	367	439	6.5514178797333379e+03
C367_439	367	439	1.3514918418484991e-10
R368_369	368	369	3.1569804129595668e+03
C368_369	368	369	2.8046381854803745e-10
R368_374	368	374	3.6556283753944076e+03
C368_374	368	374	2.4220699994005046e-10
R368_432	368	432	1.6054398338683884e+03
C368_432	368	432	5.5151165619613359e-10
R368_435	368	435	5.8221956589466308e+03
C368_435	368	435	1.5207643878120589e-10
R368_442	368	442	4.0331484673149612e+03
C368_442	368	442	2.1953538008221673e-10
R369_371	369	371	9.8494088056730300e+02
C369_371	369	371	8.9895627155816642e-10
R369_373	369	373	3.6324149210858154e+03
C369_373	369	373	2.4375485756327837e-10
R369_374	369	374	6.3602079107616182e+03
C369_374	369	374	1.3921223867569661e-10
R369_400	369	400	2.6619341414219393e+03
C369_400	369	400	3.3262234700781564e-10
R369_432	369	432	1.5804251094493438e+03
C369_432	369	432	5.6024089746871979e-10
R369_434	369	434	1.4039088358403903e+03
C369_434	369	434	6.3068110912627861e-10
R369_441	369	441	4.5688631873581980e+03
C369_441	369	441	1.9379411144328129e-10
R369_442	369	442	1.7608478845852048e+03
C369_442	369	442	5.0283661039157519e-10
R370_371	370	371	2.0011026939265357e+03
C370_371	370	371	4.4246543887392587e-10
R370_372	370	372	3.4690773070411360e+03
C370_372	370	372	2.5523178163336927e-10
R370_373	370	373	3.3062419856325355e+03
C370_373	370	373	2.6780217102911354e-10
R370_376	370	376	1.9604692915348751e+03
C370_376	370	376	4.5163613912401302e-10
R370_429	370	429	1.0000798887020910e+03
C370_429	370	429	8.8534805239319548e-10
R370_430	370	430	1.6801706205270145e+03
C370_430	370	430	5.2698146895478575e-10
R370_438	370	438	2.2699659700133257e+03
C370_438	370	438	3.9005817417377513e-10
R370_439	370	439	2.3486328193868799e+03
C370_439	370	439	3.7699327642502340e-10
R370_440	370	440	8.5411070421296574e+02
C370_440	370	440	1.0366557605853723e-09
R370_443	370	443	3.2556655864237950e+03
C370_443	370	443	2.7196244767651135e-10
R371_373	371	373	1.4467088840431761e+03
C371_373	371	373	6.1202277214575775e-10
R371_400	371	400	4.5395779748189034e+03
C371_400	371	400	1.9504429411972420e-10
R371_428	371	428	5.7779260942036663e+03
C371_428	371	428	1.5324162463556602e-10
R371_429	371	429	1.8265479403341278e+03
C371_429	371	429	4.8474981802997841e-10
R371_440	371	440	2.6159176098882726e+03
C371_440	371	440	3.3847349715949838e-10
R371_441	371	441	2.3487140182486232e+03
C371_441	371	441	3.7698024315460713e-10
R371_442	371	442	8.5712104111235767e+03
C371_442	371	442	1.0330148709812539e-10
R371_443	371	443	5.3228448855072420e+03
C371_443	371	443	1.6634314933932626e-10
R372_373	372	373	4.5597836194976981e+03
C372_373	372	373	1.9417999966356677e-10
R372_374	372	374	8.4746067541279372e+03
C372_374	372	374	1.0447904043083974e-10
R372_439	372	439	8.3034970728631179e+03
C372_439	372	439	1.0663203394069484e-10
R372_443	372	443	7.9864620145002436e+03
C372_443	372	443	1.1086495873797825e-10
R373_374	373	374	2.8598104661189227e+03
C373_374	373	374	3.0960750447969748e-10
R373_442	373	442	8.4732805549017885e+03
C373_442	373	442	1.0449539301372310e-10
R373_443	373	443	3.2523404494367410e+03
C373_443	373	443	2.7224049740959379e-10
R374_442	374	442	1.2863735274564375e+04
C374_442	374	442	6.8830612788709193e-11
R374_443	374	443	1.8675314090494630e+04
C374_443	374	443	4.7411185558087127e-11
R375_376	375	376	1.9800626145522526e+03
C375_376	375	376	4.4716706188618082e-10
R375_380	375	380	3.6271128295160001e+03
C375_380	375	380	2.4411117693798068e-10
R375_386	375	386	2.3607091378419832e+03
C375_386	375	386	3.7506474961561590e-10
R375_387	375	387	6.3913197541550735e+03
C375_387	375	387	1.3853457748290229e-10
R375_388	375	388	2.4450079642320084e+03
C375_388	375	388	3.6213329144640041e-10
R375_389	375	389	2.3679925316515696e+03
C375_389	375	389	3.7391113775281199e-10
R375_444	375	444	2.8319429616645652e+03
C375_444	375	444	3.1265417195393184e-10
R376_380	376	380	4.1956661202839196e+03
C376_380	376	380	2.1103175427125844e-10
R376_386	376	386	1.9129195985488022e+03
C376_386	376	386	4.6286251778261110e-10
R376_430	376	430	6.9452065855290004e+02
C376_430	376	430	1.2748631315659561e-09
R376_438	376	438	8.6858296367694390e+02
C376_438	376	438	1.0193830857006288e-09
R376_444	376	444	1.2881775483343927e+03
C376_444	376	444	6.8734219350806291e-10
R377_380	377	380	2.8739100429751938e+03
C377_380	377	380	3.0808855129765191e-10
R377_438	377	438	3.0446946459275860e+03
C377_438	377	438	2.9080708729996519e-10
R377_439	377	439	3.1865449279851468e+03
C377_439	377	439	2.7786169713911761e-10
R377_446	377	446	3.0613479054600848e+03
C377_446	377	446	2.8922514168376817e-10
R377_447	377	447	9.8494639361636073e+03
C377_447	377	447	8.9895123982237069e-11
R378_379	378	379	4.4733623068263578e+03
C378_379	378	379	1.9793138158043889e-10
R378_410	378	410	4.2870598134351039e+03
C378_410	378	410	2.0653287339850249e-10
R378_409	378	409	2.0840941551419669e+03
C378_409	378	409	4.2484586385670582e-10
R378_433	378	433	5.1100392045860463e+03
C378_433	378	433	1.7327044788724397e-10
R378_435	378	435	3.4392861823637527e+03
C378_435	378	435	2.5744260138639275e-10
R378_449	378	449	6.9616977060367208e+03
C378_449	378	449	1.2718431898188052e-10
R378_450	378	450	4.1501107619439490e+03
C378_450	378	450	2.1334822911696507e-10
R379_410	379	410	4.9707331986125419e+03
C379_410	379	410	1.7812639430077296e-10
R379_450	379	450	1.6341539184993133e+04
C379_450	379	450	5.4182092132000855e-11
R380_438	380	438	4.6895393547010372e+03
C380_438	380	438	1.8880719719569268e-10
R380_444	380	444	4.8964674482219243e+03
C380_444	380	444	1.8082807474223611e-10
R380_388	380	388	4.6605926299794692e+03
C380_388	380	388	1.8997986994282754e-10
R380_445	380	445	4.3062926005357212e+03
C380_445	380	445	2.0561045517200806e-10
R380_446	380	446	7.7210426525722933e+03
C380_446	380	446	1.1467606404233755e-10
R380_447	380	447	4.6564889653678274e+03
C380_447	380	447	1.9014729515847975e-10
R380_451	380	451	3.5711251144443522e+03
C380_451	380	451	2.4793832568864405e-10
R380_452	380	452	1.0932963005867008e+04
C380_452	380	452	8.0986168271570433e-11
R381_455	381	455	2.2858650301453090e+03
C381_455	381	455	3.8734517131298668e-10
R381_384	381	384	1.0461552931537562e+04
C381_384	381	384	8.4635501774387903e-11
R381_411	381	411	1.3764114070515183e+04
C381_411	381	411	6.4328061883525168e-11
R381_417	381	417	1.4676412435355773e+04
C381_417	381	417	6.0329374470767021e-11
R381_456	381	456	6.1757865515980484e+03
C381_456	381	456	1.4336939502400534e-10
R381_457	381	457	4.3063921577404963e+03
C381_457	381	457	2.0560570177254062e-10
R381_416	381	416	2.7528228141030286e+04
C381_416	381	416	3.2164030941762675e-11
R382_383	382	383	1.8749209673346923e+03
C382_383	382	383	4.7224325564968930e-10
R382_385	382	385	1.1930704829304198e+03
C382_385	382	385	7.4213451289586361e-10
R382_389	382	389	3.8389902208154222e+03
C382_389	382	389	2.3063845719094647e-10
R382_412	382	412	2.4195276592937507e+03
C382_412	382	412	3.6594695592711255e-10
R382_413	382	413	3.1908689943895001e+03
C382_413	382	413	2.7748515631849205e-10
R382_415	382	415	2.0147047611225910e+03
C382_415	382	415	4.3947818002209200e-10
R382_458	382	458	6.4232603568146769e+03
C382_458	382	458	1.3784569401123937e-10
R383_387	383	387	5.9492767252504536e+03
C383_387	383	387	1.4882797062406362e-10
R383_389	383	389	5.9903266622621113e+03
C383_389	383	389	1.4780809655639745e-10
R383_413	383	413	6.6624310819871353e+03
C383_413	383	413	1.3289725188960832e-10
R383_411	383	411	6.4315341005202690e+03
C383_411	383	411	1.3766836463300031e-10
R383_458	383	458	2.9348332736090765e+03
C383_458	383	458	3.0169304323416185e-10
R383_384	383	384	1.0271441687519506e+04
C383_384	383	384	8.6201996626806874e-11
R384_455	384	455	1.3078457495426528e+03
C384_455	384	455	6.7700551231643843e-10
R384_411	384	411	5.7720660337731197e+03
C384_411	384	411	1.5339720240885988e-10
R384_457	384	457	8.4213476101875076e+03
C384_457	384	457	1.0513979741542643e-10
R384_454	384	454	8.9473153787143801e+03
C384_454	384	454	9.8959156375152171e-11
R384_458	384	458	3.4574335333392623e+03
C384_458	384	458	2.5609133860769953e-10
R384_387	384	387	1.0337524244111341e+04
C384_387	384	387	8.5650950923222203e-11
R384_459	384	459	6.9156963666538568e+03
C384_459	384	459	1.2803031462880836e-10
R385_386	385	386	1.5165035656872835e+03
C385_386	385	386	5.8385539060617101e-10
R385_389	385	389	2.3220771329586210e+03
C385_389	385	389	3.8130463847764792e-10
R385_412	385	412	5.0976789132419135e+03
C385_412	385	412	1.7369057501836855e-10
R385_415	385	415	2.6490018635663605e+03
C385_415	385	415	3.3424619056626773e-10
R385_419	385	419	2.9056791382200022e+03
C385_419	385	419	3.0472008077340607e-10
R385_420	385	420	6.6686745176841641e+03
C385_420	385	420	1.3277282904601559e-10
R385_422	385	422	6.0300198013030576e+03
C385_422	385	422	1.4683513667876602e-10
R385_460	385	460	3.1245787574263854e+03
C385_460	385	460	2.8337220804422636e-10
R386_389	386	389	2.1168778153469998e+03
C386_389	386	389	4.1826636156365101e-10
R386_419	386	419	2.8608798685886468e+03
C386_419	386	419	3.0949177259120713e-10
R386_430	386	430	1.5391463850958487e+03
C386_430	386	430	5.7526612820837151e-10
R386_444	386	444	3.1555585949925553e+03
C386_444	386	444	2.8059018872444322e-10
R386_460	386	460	2.3772533592134682e+03
C386_460	386	460	3.7245452962276905e-10
R387_388	387	388	1.2887552423435891e+04
C387_388	387	388	6.8703408731814322e-11
R387_389	387	389	4.8299189685807751e+03
C387_389	387	389	1.8331959344654840e-10
R387_458	387	458	8.7485334391258712e+03
C387_458	387	458	1.0120768102001660e-10
R387_459	387	459	9.2978714403641297e+03
C387_459	387	459	9.5228116174654755e-11
R387_454	387	454	2.9096159952463218e+04
C387_454	387	454	3.0430777915250030e-11
R387_453	387	453	1.2476982065173092e+04
C387_453	387	453	7.0964178442755248e-11
R387_462	387	462	7.7265409298573859e+03
C387_462	387	462	1.1459445950496540e-10
R388_389	388	389	7.6440130853855189e+03
C388_389	388	389	1.1583166745133126e-10
R388_444	388	444	5.4910935582322500e+03
C388_444	388	444	1.6124634780126440e-10
R388_451	388	451	2.6138154764274036e+03
C388_451	388	451	3.3874571089088568e-10
R388_452	388	452	7.0627841039836285e+03
C388_452	388	452	1.2536398800589084e-10
R388_453	388	453	3.1558781780926006e+03
C388_453	388	453	2.8056177448368540e-10
R388_462	388	462	4.1999226569339971e+03
C388_462	388	462	2.1081787785739086e-10
R389_415	389	415	5.4224898009197286e+03
C389_415	389	415	1.6328638950133586e-10
R389_444	389	444	5.9180050733334974e+03
C389_444	389	444	1.4961440058402329e-10
R389_458	389	458	4.4781145820705251e+03
C389_458	389	458	1.9772133237613881e-10
R389_460	389	460	3.4364140508469586e+03
C389_460	389	460	2.5765777016357343e-10
R389_461	389	461	4.7742938588371762e+03
C389_461	389	461	1.8545544281089812e-10
R389_462	389	462	3.5618717787438704e+03
C389_462	389	462	2.4858244111534299e-10
R389_463	389	463	8.1251264892466925e+03
C389_463	389	463	1.0897292280579500e-10
R390_392	390	392	1.0457566016678063e+03
C390_392	390	392	8.4667768798963871e-10
R390_391	390	391	1.5036117637230748e+03
C390_391	390	391	5.8886130253970967e-10
R390_394	390	394	1.1506371085296712e+03
C390_394	390	394	7.6950306498581694e-10
R390_402	390	402	9.3444401072900644e+02
C390_402	390	402	9.4753540237177042e-10
R390_405	390	405	5.9161553864170617e+02
C390_405	390	405	1.4966117755000799e-09
R390_431	390	431	7.2310195886661950e+02
C390_431	390	431	1.2244729402860336e-09
R390_408	390	408	8.6095843763993889e+02
C390_408	390	408	1.0284105979925252e-09
R390_433	390	433	2.3792857295637100e+03
C390_433	390	433	3.7213638139306591e-10
R390_468	390	468	8.3517807615424078e+02
C390_468	390	468	1.0601556805431284e-09
R390_469	390	469	8.3299079359257905e+02
C390_469	390	469	1.0629394568471830e-09
R391_392	391	392	1.1879439925580784e+03
C391_392	391	392	7.4533714320434344e-10
R391_396	391	396	6.2911910510675591e+02
C391_396	391	396	1.4073945211849074e-09
R391_402	391	402	5.8349152442558523e+02
C391_402	391	402	1.5174492595614739e-09
R391_406	391	406	6.9231905854011291e+02
C391_406	391	406	1.2789172431090874e-09
R391_468	391	468	1.8727856070893258e+03
C391_468	391	468	4.7278170995563857e-10
R391_469	391	469	2.7580358292568981e+03
C391_469	391	469	3.2103237104739138e-10
R391_470	391	470	1.2610404777501979e+03
C391_470	391	470	7.0213351381048582e-10
R392_393	392	393	2.2372972381987806e+03
C392_393	392	393	3.9575375438841531e-10
R392_394	392	394	3.4238105103483263e+03
C392_394	392	394	2.5860624559211390e-10
R392_395	392	395	2.6756460177454105e+03
C392_395	392	395	3.3091775811438759e-10
R392_396	392	396	4.8877867604927906e+03
C392_396	392	396	1.8114922460543909e-10
R392_397	392	397	3.4868852575709793e+03
C392_397	392	397	2.5392828163115329e-10
R392_469	392	469	1.0569098630182818e+03
C392_469	392	469	8.3774294543099050e-10
R392_470	392	470	1.8542258968105282e+03
C392_470	392	470	4.7751397670748604e-10
R392_471	392	471	1.9251170935416048e+03
C392_471	392	471	4.5992983214912416e-10
R393_395	393	395	3.9180470994999118e+03
C393_395	393	395	2.2598472126917833e-10
R393_397	393	397	6.7690520446730216e+03
C393_397	393	397	1.3080395539236399e-10
R393_471	393	471	9.1917537569063807e+03
C393_471	393	471	9.6327513238126697e-11
R394_395	394	395	2.1111681817586291e+03
C394_395	394	395	4.1939755882567118e-10
R394_410	394	410	2.2288010722168369e+03
C394_410	394	410	3.9726236349093917e-10
R394_409	394	409	1.2399664658995264e+03
C394_409	394	409	7.1406671555240677e-10
R394_433	394	433	1.3475493125072514e+03
C394_433	394	433	6.5705853840152900e-10
R394_408	394	408	1.0686225991022000e+03
C394_408	394	408	8.2856078698305836e-10
R394_469	394	469	1.1769189662631613e+03
C394_469	394	469	7.5231923954059078e-10
R394_472	394	472	9.8938102436636575e+02
C394_472	394	472	8.9492193593166312e-10
R394_473	394	473	2.3524188298700137e+03
C394_473	394	473	3.7638653901989259e-10
R395_410	395	410	6.6077981786242644e+03
C395_410	395	410	1.3399603888694180e-10
R395_469	395	469	9.7156809579070668e+03
C395_469	395	469	9.1132961810505488e-11
R395_471	395	471	9.6259121587253303e+03
C395_471	395	471	9.1982844545014819e-11
R395_473	395	473	9.4301817634854287e+03
C395_473	395	473	9.3892016496270187e-11
R396_397	396	397	1.2581214318778755e+03
C396_397	396	397	7.0376257749494139e-10
R396_398	396	398	3.1450975543124732e+03
C396_398	396	398	2.8152347150120592e-10
R396_406	396	406	8.8216163676657231e+02
C396_406	396	406	1.0036922314433965e-09
R396_470	396	470	1.4388041699387659e+03
C396_470	396	470	6.1538519292565196e-10
R396_476	396	476	4.3969623645597358e+03
C396_476	396	476	2.0137056183073706e-10
R397_398	397	398	4.2777681259360352e+03
C397_398	397	398	2.0698148091097338e-10
R397_470	397	470	2.2183522681195359e+03
C397_470	397	470	3.9913353457183625e-10
R397_471	397	471	3.2817418205794079e+03
C397_471	397	471	2.6980147437182451e-10
R397_476	397	476	4.1585375762974900e+03
C397_476	397	476	2.1291590263525362e-10
R398_404	398	404	5.8122317061545618e+03
C398_404	398	404	1.5233714457089376e-10
R398_406	398	406	8.7359387763289487e+03
C398_406	398	406	1.0135359282726960e-10
R398_476	398	476	4.3653787810973845e+03
C398_476	398	476	2.0282748098148320e-10
R398_478	398	478	1.7685141716250906e+04
C398_478	398	478	5.0065687677604948e-11
R399_400	399	400	2.3651851415065735e+03
C399_400	399	400	3.7435495689610445e-10
R399_403	399	403	4.5902497519567651e+03
C399_403	399	403	1.9289119972667224e-10
R399_405	399	405	4.2018769042827980e+03
C399_405	399	405	2.1071982875022573e-10
R399_407	399	407	2.3781775382809305e+03
C399_407	399	407	3.7230979077366371e-10
R399_418	399	418	6.1221562269643191e+03
C399_418	399	418	1.4462531645309486e-10
R399_421	399	421	2.7955382359449527e+03
C399_421	399	421	3.1672569178818952e-10
R399_428	399	428	5.0746078410301006e+03
C399_428	399	428	1.7448023757443054e-10
R399_431	399	431	3.9364957533653210e+03
C399_431	399	431	2.2492562857283741e-10
R399_480	399	480	4.9916154873512769e+03
C399_480	399	480	1.7738120733530975e-10
R400_428	400	428	1.7985714896698566e+03
C400_428	400	428	4.9229001281596331e-10
R400_421	400	421	7.1779931322124366e+03
C400_421	400	421	1.2335185690364289e-10
R400_431	400	431	7.1851306370879065e+03
C400_431	400	431	1.2322932266946998e-10
R400_434	400	434	1.6458382394862310e+03
C400_434	400	434	5.3797436495119630e-10
R400_441	400	441	3.1335923712695671e+03
C400_441	400	441	2.8255710277379665e-10
R400_480	400	480	4.6275436969669145e+03
C400_480	400	480	1.9133666577375391e-10
R400_481	400	481	3.0588819718671771e+03
C400_481	400	481	2.8945830203429854e-10
R401_402	401	402	4.2790654249600602e+03
C401_402	401	402	2.0691872962149541e-10
R401_403	401	403	1.7687510537740475e+03
C401_403	401	403	5.0058982569126974e-10
R401_406	401	406	4.8095945242750158e+03
C401_406	401	406	1.8409426766250435e-10
R401_404	401	404	8.2526821872701494e+03
C401_404	401	404	1.0728860770450704e-10
R401_418	401	418	6.9286467536841546e+03
C401_418	401	418	1.2779101218130341e-10
R401_423	401	423	2.7680595677025617e+03
C401_423	401	423	3.1986984385414851e-10
R401_482	401	482	3.5957823846500346e+03
C401_482	401	482	2.4623814429920651e-10
R402_403	402	403	3.8204942828578619e+03
C402_403	402	403	2.3175503381140419e-10
R402_405	402	405	1.3153379940307593e+03
C402_405	402	405	6.7314924811583794e-10
R402_406	402	406	2.2486360602920590e+03
C402_406	402	406	3.9375815292448860e-10
R402_407	402	407	4.2890553396783025e+03
C402_407	402	407	2.0643678189668926e-10
R402_468	402	468	2.6585213057309888e+03
C402_468	402	468	3.3304934581163523e-10
R402_482	402	482	5.0101165209089913e+03
C402_482	402	482	1.7672618550982479e-10
R403_407	403	407	2.0934229128007942e+03
C403_407	403	407	4.2295265628644371e-10
R403_418	403	418	1.9985849307907276e+03
C403_418	403	418	4.4302284484337112e-10
R403_482	403	482	6.6394226387777881e+03
C403_482	403	482	1.3335779778932581e-10
R404_406	404	406	2.4989241765194047e+03
C404_406	404	406	3.5431998698465704e-10
R404_423	404	423	3.8085678114647076e+03
C404_423	404	423	2.3248077112731878e-10
R404_476	404	476	6.1678167828489741e+03
C404_476	404	476	1.4355465035247313e-10
R404_475	404	475	2.6720393259826392e+03
C404_475	404	475	3.3136442757046194e-10
R404_477	404	477	8.1953198944430278e+03
C404_477	404	477	1.0803956320245325e-10
R404_478	404	478	5.3853751694254534e+03
C404_478	404	478	1.6441171763237852e-10
R404_482	404	482	6.4406891278676112e+03
C404_482	404	482	1.3747267786438645e-10
R405_407	405	407	1.3140388525187068e+03
C405_407	405	407	6.7381476582892369e-10
R405_431	405	431	2.6043824722424924e+03
C405_431	405	431	3.3997263886421949e-10
R405_408	405	408	6.0202402143514473e+03
C405_408	405	408	1.4707366320521233e-10
R405_468	405	468	1.4785367630282374e+03
C405_468	405	468	5.9884799880562061e-10
R405_480	405	480	2.8411087796180868e+03
C405_480	405	480	3.1164550546319507e-10
R405_482	405	482	6.8627950800428853e+03
C405_482	405	482	1.2901722568910905e-10
R405_483	405	483	4.7530763320267315e+03
C405_483	405	483	1.8628330787240984e-10
R406_468	406	468	2.2161337328576378e+03
C406_468	406	468	3.9953310063029417e-10
R406_470	406	470	1.4783424798868739e+03
C406_470	406	470	5.9892669915549895e-10
R406_476	406	476	3.4449151895973591e+03
C406_476	406	476	2.5702193899394294e-10
R406_475	406	475	6.0272647192896902e+03
C406_475	406	475	1.4690225549017306e-10
R406_482	406	482	3.2274967477530868e+03
C406_482	406	482	2.7433607247363122e-10
R406_484	406	484	3.3526985287750545e+03
C406_484	406	484	2.6409138015266095e-10
R407_418	407	418	2.3053753967004172e+03
C407_418	407	418	3.8406707340039332e-10
R407_421	407	421	1.7654829269397922e+03
C407_421	407	421	5.0151647925292870e-10
R407_480	407	480	5.3865393306101332e+03
C407_480	407	480	1.6437618429116874e-10
R407_482	407	482	2.3075635123470952e+03
C407_482	407	482	3.8370288703317764e-10
R407_483	407	483	3.5589892605512428e+03
C407_483	407	483	2.4878377451548134e-10
R407_487	407	487	4.4292339460240955e+03
C407_487	407	487	1.9990336760034917e-10
R408_431	408	431	1.4413356388301054e+03
C408_431	408	431	6.1430437009014176e-10
R408_433	408	433	1.3137741934516421e+03
C408_433	408	433	6.7395050543180804e-10
R408_409	408	409	3.1569978304348938e+03
C408_409	408	409	2.8046227120087332e-10
R408_436	408	436	1.0756466674239869e+03
C408_436	408	436	8.2315021141695718e-10
R408_468	408	468	3.7330648642232431e+03
C408_468	408	468	2.3718280123810100e-10
R408_469	408	469	2.8879990712849813e+03
C408_469	408	469	3.0658554931807628e-10
R408_472	408	472	1.2011130323584191e+03
C408_472	408	472	7.3716524410817136e-10
R408_474	408	474	2.3038832573179629e+03
C408_474	408	474	3.8431581934006028e-10
R408_480	408	480	2.1383034956940119e+03
C408_480	408	480	4.1407535622656168e-10
R408_488	408	488	5.6727260623515022e+03
C408_488	408	488	1.5608347238487476e-10
R409_410	409	410	2.3138965197163079e+03
C409_410	409	410	3.8265271335839846e-10
R409_433	409	433	7.5897601697495099e+02
C409_433	409	433	1.1665965220205664e-09
R409_435	409	435	4.2026728027940289e+03
C409_435	409	435	2.1067992281277625e-10
R409_436	409	436	1.3519691133126046e+03
C409_436	409	436	6.5491051014511763e-10
R409_437	409	437	2.4258772996988669e+03
C409_437	409	437	3.6498910386354260e-10
R409_449	409	449	1.0446092548606111e+03
C409_449	409	449	8.4760763661637982e-10
R409_450	409	450	3.8011952195220783e+03
C409_450	409	450	2.3293167821339181e-10
R409_472	409	472	1.1243626214743817e+03
C409_472	409	472	7.8748507357790542e-10
R409_489	409	489	3.5591144856208830e+03
C409_489	409	489	2.4877502122428633e-10
R409_490	409	490	2.2762696989812798e+03
C409_490	409	490	3.8897797659752700e-10
R410_450	410	450	5.5656286113427732e+03
C410_450	410	450	1.5908693222819667e-10
R410_472	410	472	7.5042248512394035e+03
C410_472	410	472	1.1798937255375063e-10
R410_473	410	473	8.6029324573685208e+03
C410_473	410	473	1.0292057808051575e-10
R410_490	410	490	8.2551754267803281e+03
C410_490	410	490	1.0725620425068660e-10
R411_413	411	413	6.0818887428160733e+03
C411_413	411	413	1.4558286399859855e-10
R411_455	411	455	5.1884459273210523e+03
C411_455	411	455	1.7065202068264936e-10
R411_417	411	417	8.3466173556249651e+03
C411_417	411	417	1.0608115167796652e-10
R411_458	411	458	6.9658021083221147e+03
C411_458	411	458	1.2710937921164618e-10
R411_500	411	500	9.4611565443334021e+03
C411_500	411	500	9.3584624411516198e-11
R412_413	412	413	5.2297822065753489e+03
C412_413	412	413	1.6930318447807878e-10
R412_414	412	414	2.2118678363287004e+03
C412_414	412	414	4.0030365610344730e-10
R412_415	412	415	3.4027576032063462e+03
C412_415	412	415	2.6020624591821902e-10
R412_420	412	420	1.8840572317616952e+03
C412_420	412	420	4.6995323006832743e-10
R412_422	412	422	4.5253207644127542e+03
C412_422	412	422	1.9565878924273338e-10
R412_425	412	425	3.8245358527607095e+03
C412_425	412	425	2.3151012718598728e-10
R412_426	412	426	1.7952350423093555e+03
C412_426	412	426	4.9320493463686758e-10
R412_501	412	501	4.1893146873540418e+03
C412_501	412	501	2.1135170016536237e-10
R413_415	413	415	3.4427311181518148e+03
C413_415	413	415	2.5718499392288450e-10
R413_426	413	426	5.5435576986090537e+03
C413_426	413	426	1.5972031497429213e-10
R413_458	413	458	4.4038290881975436e+03
C413_458	413	458	2.0105657235267402e-10
R413_417	413	417	1.0343896910736816e+04
C413_417	413	417	8.5598183096831545e-11
R413_500	413	500	5.4628451909355790e+03
C413_500	413	500	1.6208015251268019e-10
R413_501	413	501	4.2032502450416359e+03
C413_501	413	501	2.1065097961856643e-10
R413_502	413	502	4.5528861108685669e+03
C413_502	413	502	1.9447417750827206e-10
R413_503	413	503	2.9848476821481945e+03
C413_503	413	503	2.9663784420073470e-10
R414_418	414	418	1.5640957042409220e+03
C414_418	414	418	5.6608990057274423e-10
R414_420	414	420	9.8661092708573631e+02
C414_420	414	420	8.9743459898154699e-10
R414_424	414	424	1.2272923306155315e+03
C414_424	414	424	7.2144081700236030e-10
R414_425	414	425	8.1360396287202718e+02
C414_425	414	425	1.0882675381452987e-09
R414_426	414	426	2.7979529160321449e+03
C414_426	414	426	3.1645235222744106e-10
R414_479	414	479	2.2873266028726894e+03
C414_479	414	479	3.8709766265472917e-10
R414_504	414	504	3.4780196222999216e+03
C414_504	414	504	2.5457555674010151e-10
R415_422	415	422	2.3951778532334106e+03
C415_422	415	422	3.6966723807366286e-10
R415_458	415	458	3.4121446162049247e+03
C415_458	415	458	2.5949040304299468e-10
R415_460	415	460	5.1725631566843276e+03
C415_460	415	460	1.7117602141905285e-10
R415_461	415	461	2.6734964283485501e+03
C415_461	415	461	3.3118382815530207e-10
R415_501	415	501	2.2543061556584598e+03
C415_501	415	501	3.9276776114794324e-10
R415_502	415	502	2.3972388944892214e+03
C415_502	415	502	3.6934941433471771e-10
R415_505	415	505	5.3502483312435088e+03
C415_505	415	505	1.6549115608886333e-10
R416_457	416	457	7.4102746224479597e+03
C416_457	416	457	1.1948528587831271e-10
R416_456	416	456	8.1180540690580756e+03
C416_456	416	456	1.0906785963335348e-10
R416_466	416	466	2.4399587835827918e-05
C416_466	416	466	3.9917094725095848e-11
R416_467	416	467	1.5249742412642194e-05
C416_467	416	467	5.8061228691048509e-12
R416_499	416	499	6.9066470266827223e-06
C416_499	416	499	1.4101787091960814e-10
R416_427	416	427	3.0499484825284381e-06
C416_427	416	427	2.9030614345524251e-11
R416_506	416	506	2.4399587835827884e-05
C416_506	416	506	3.9917094725095906e-11
R417_455	417	455	7.7352872225447072e+03
C417_455	417	455	1.1446488749886659e-10
R417_456	417	456	1.2506407348973073e+04
C417_456	417	456	7.0797212740132258e-11
R417_500	417	500	1.9887496375905669e+03
C417_500	417	500	4.4521379914503111e-10
R417_503	417	503	2.4289168062961133e+04
C417_503	417	503	3.6453236249379272e-11
R417_507	417	507	2.6364301908565390e+04
C417_507	417	507	3.3584002518661042e-11
R417_508	417	508	2.4313205528457896e+04
C417_508	417	508	3.6417196435231185e-11
R418_420	418	420	4.4284389272462440e+03
C418_420	418	420	1.9993925540045419e-10
R418_421	418	421	3.0618515827689375e+03
C418_421	418	421	2.8917756389069821e-10
R418_423	418	423	9.2358993649986860e+03
C418_423	418	423	9.5867088489018606e-11
R418_424	418	424	1.0093962317527317e+04
C418_424	418	424	8.7717662682626086e-11
R418_479	418	479	6.5886205310723926e+03
C418_479	418	479	1.3438606420331897e-10
R418_482	418	482	5.7541848268323811e+03
C418_482	418	482	1.5387388628380467e-10
R418_486	418	486	7.6894770791712754e+03
C418_486	418	486	1.1514681331170898e-10
R418_487	418	487	5.6722314355013195e+03
C418_487	418	487	1.5609708309120595e-10
R418_504	418	504	6.6853911328758704e+03
C418_504	418	504	1.3244083466498948e-10
R418_509	418	509	1.0499664950056547e+04
C418_509	418	509	8.4328289132238594e-11
R419_420	419	420	1.1146684408530680e+03
C419_420	419	420	7.9433376710870114e-10
R419_421	419	421	3.9855989607882730e+03
C419_421	419	421	2.2215450937514341e-10
R419_422	419	422	2.8167605663335653e+03
C419_422	419	422	3.1433938414314891e-10
R419_428	419	428	2.5674891936465278e+03
C419_428	419	428	3.4485784161859174e-10
R419_430	419	430	3.2881844942380262e+03
C419_430	419	430	2.6927284136627472e-10
R419_460	419	460	1.4656119705771735e+03
C419_460	419	460	6.0412905972057034e-10
R419_464	419	464	3.2277914886445647e+03
C419_464	419	464	2.7431102189063984e-10
R419_465	419	465	1.4276807900701642e+03
C419_465	419	465	6.2017979639306184e-10
R419_509	419	509	2.7144422226182082e+03
C419_509	419	509	3.2618811125254743e-10
R420_421	420	421	2.8054360291411963e+03
C420_421	420	421	3.1560825928761082e-10
R420_422	420	422	5.7757617185840786e+02
C420_422	420	422	1.5329904951775942e-09
R420_425	420	425	1.3208906110208934e+03
C420_425	420	425	6.7031953616179855e-10
R420_504	420	504	1.3565966305049003e+03
C420_504	420	504	6.5267653021551696e-10
R420_509	420	509	1.3535198509421141e+03
C420_509	420	509	6.5416017436589988e-10
R421_428	421	428	1.8783879249165641e+03
C421_428	421	428	4.7137163200158954e-10
R421_465	421	465	2.0000704690007417e+03
C421_465	421	465	4.4269379275539495e-10
R421_480	421	480	2.5653370114021614e+03
C421_480	421	480	3.4514715913136415e-10
R421_481	421	481	1.1475717095223779e+03
C421_481	421	481	7.7155856523207037e-10
R421_483	421	483	2.8581356439836982e+03
C421_483	421	483	3.0978892956455156e-10
R421_487	421	487	1.2710958175602120e+03
C421_487	421	487	6.9657910085764052e-10
R421_509	421	509	1.3163329706725926e+03
C421_509	421	509	6.7264043477357176e-10
R421_511	421	511	1.3643115865392435e+03
C421_511	421	511	6.4898575254790710e-10
R422_425	422	425	9.7255982185112464e+02
C422_425	422	425	9.1040032891214386e-10
R422_460	422	460	1.5134658402596690e+03
C422_460	422	460	5.8502726533166190e-10
R422_461	422	461	2.3450923039167060e+03
C422_461	422	461	3.7756244401177686e-10
R422_464	422	464	5.5595087810855193e+02
C422_464	422	464	1.5926205291955990e-09
R422_501	422	501	8.2902577443447501e+02
C422_501	422	501	1.0680232255794386e-09
R422_504	422	504	7.3352077592097396e+02
C422_504	422	504	1.2070807136830039e-09
R422_505	422	505	6.6746495940724139e+02
C422_505	422	505	1.3265397220047593e-09
R422_509	422	509	1.4457677343576427e+03
C422_509	422	509	6.1242117987464504e-10
R422_512	422	512	2.4940832188768072e+03
C422_512	422	512	3.5500771385597241e-10
R423_424	423	424	5.0348121799652026e+03
C423_424	423	424	1.7585934689347627e-10
R423_477	423	477	6.0237580497639419e+03
C423_477	423	477	1.4698777314515441e-10
R423_475	423	475	6.1334432233865518e+03
C423_475	423	475	1.4435917142331027e-10
R423_479	423	479	6.9150988270177040e+03
C423_479	423	479	1.2804137783839270e-10
R423_482	423	482	2.8856231879966272e+03
C423_482	423	482	3.0683797710771485e-10
R423_485	423	485	5.8557397595032280e+03
C423_485	423	485	1.5120528200780470e-10
R423_486	423	486	5.2557553822517666e+03
C423_486	423	486	1.6846651286130690e-10
R423_513	423	513	4.9195151509943471e+03
C423_513	423	513	1.7998090350855746e-10
R424_425	424	425	1.9560417725136851e+03
C424_425	424	425	4.5265842178930526e-10
R424_426	424	426	3.5937724631898432e+03
C424_426	424	426	2.4637586012167837e-10
R424_479	424	479	8.8961631602321995e+02
C424_479	424	479	9.9528163518629704e-10
R424_513	424	513	5.5420849100861597e+03
C424_513	424	513	1.5976276005598675e-10
R424_514	424	514	4.5789478944724751e+03
C424_514	424	514	1.9336729792641725e-10
R425_426	425	426	3.2594473080769203e+03
C425_426	425	426	2.7164690759256318e-10
R425_479	425	479	1.9992708272587217e+03
C425_479	425	479	4.4287085552787878e-10
R425_501	425	501	2.3410439727773432e+03
C425_501	425	501	3.7821535690744256e-10
R425_504	425	504	2.5879540944534124e+03
C425_504	425	504	3.4213079111320342e-10
R425_512	425	512	3.0643520818500970e+03
C425_512	425	512	2.8894159615151990e-10
R425_514	425	514	3.5350790121892155e+03
C425_514	425	514	2.5046647575542443e-10
R426_501	426	501	2.5910667798537493e+03
C426_501	426	501	3.4171978452441763e-10
R426_503	426	503	6.7195357796749640e+03
C426_503	426	503	1.3176784985328689e-10
R426_514	426	514	7.4337473100488896e+03
C426_514	426	514	1.1910800095439037e-10
R427_499	427	499	8.7291318521663436e-06
C427_499	427	499	1.0143262774525074e-11
R427_467	427	467	1.9853514686376954e-05
C427_467	427	467	4.4597583636289600e-12
R427_506	427	506	2.4816893357971164e-05
C427_506	427	506	3.5678066909031717e-12
R427_515	427	515	2.0484705628236318e-05
C427_515	427	515	4.3223407637331635e-12
R427_516	427	516	1.9853514686376924e-05
C427_516	427	516	4.4597583636289657e-12
R428_429	428	429	8.7060407023434527e+02
C428_429	428	429	1.0170165887941082e-09
R428_430	428	430	3.1183201475596084e+03
C428_430	428	430	2.8394094890895895e-10
R428_441	428	441	3.8485066714357504e+03
C428_441	428	441	2.3006814260495473e-10
R428_465	428	465	2.6255880990884430e+03
C428_465	428	465	3.3722684148644699e-10
R428_481	428	481	3.7211188202821977e+03
C428_481	428	481	2.3794423786576439e-10
R428_518	428	518	3.2982060849989289e+03
C428_518	428	518	2.6845465652589366e-10
R429_430	429	430	2.5781939400510350e+03
C429_430	429	430	3.4342598046851097e-10
R429_440	429	440	1.2991262111823605e+03
C429_440	429	440	6.8154947077402351e-10
R429_441	429	441	5.2934872171308616e+03
C429_441	429	441	1.6726568807696269e-10
R429_518	429	518	5.7507331440676435e+03
C429_518	429	518	1.5396624387159796e-10
R430_438	430	438	3.4252851959258583e+03
C430_438	430	438	2.5849490803076628e-10
R430_440	430	440	4.4371703173779324e+03
C430_440	430	440	1.9954581825094840e-10
R430_444	430	444	2.5486062367161480e+03
C430_444	430	444	3.4741293846979384e-10
R430_460	430	460	4.9647775990002410e+03
C430_460	430	460	1.7834006942794319e-10
R430_465	430	465	5.1206393706972876e+03
C430_465	430	465	1.7291176308309928e-10
R430_518	430	518	2.0610370808608263e+03
C430_518	430	518	4.2959866657527096e-10
R430_519	430	519	6.5770676931201488e+03
C430_519	430	519	1.3462211779060449e-10
R430_520	430	520	6.5460493312954450e+03
C430_520	430	520	1.3526002278457901e-10
R431_432	431	432	5.0881696395998779e+03
C431_432	431	432	1.7401518510881007e-10
R431_433	431	433	1.9082957954247097e+03
C431_433	431	433	4.6398403424818192e-10
R431_434	431	434	2.0696919471583938e+03
C431_434	431	434	4.2780220646635146e-10
R431_436	431	436	4.9724187523598739e+03
C431_436	431	436	1.7806601289961484e-10
R431_480	431	480	1.4826108470140473e+03
C431_480	431	480	5.9720241726493381e-10
R431_521	431	521	7.0118848687330674e+03
C431_521	431	521	1.2627400453310361e-10
R432_433	432	433	3.3025280136435417e+03
C432_433	432	433	2.6810333721383161e-10
R432_434	432	434	4.1362696832001066e+03
C432_434	432	434	2.1406215008083762e-10
R432_435	432	435	4.0308538337454752e+03
C432_435	432	435	2.1966035441113172e-10
R432_437	432	437	8.2453880302194084e+03
C432_437	432	437	1.0738351893870048e-10
R432_442	432	442	6.3128841735220994e+03
C432_442	432	442	1.4025582560403686e-10
R432_521	432	521	1.0009785419816213e+04
C432_521	432	521	8.8455320924977127e-11
R433_434	433	434	1.1936997792359267e+04
C433_434	433	434	7.4174327339387330e-11
R433_435	433	435	6.6958481905178442e+03
C433_435	433	435	1.3223399881644025e-10
R433_436	433	436	3.6283352433375962e+03
C433_436	433	436	2.4402893402031121e-10
R433_437	433	437	4.0298070334354675e+03
C433_437	433	437	2.1971741434605815e-10
R433_521	433	521	7.6104906657758720e+03
C433_521	433	521	1.1634187867566798e-10
R434_441	434	441	2.8751905213254927e+03
C434_441	434	441	3.0795134274851906e-10
R434_442	434	442	6.1896093138713004e+03
C434_442	434	442	1.4304921955505678e-10
R434_480	434	480	2.7242843128175809e+03
C434_480	434	480	3.2500968328972203e-10
R434_481	434	481	5.7185182894926047e+03
C434_481	434	481	1.5483360144653166e-10
R434_521	434	521	9.4892444539985888e+02
C434_521	434	521	9.3307616427449211e-10
R434_523	434	523	4.5887778606891898e+03
C434_523	434	523	1.9295307129271643e-10
R435_437	435	437	2.3075062444622708e+03
C435_437	435	437	3.8371240980382858e-10
R435_442	435	442	7.3245750935453480e+03
C435_442	435	442	1.2088329635397684e-10
R435_449	435	449	7.2724734761141908e+03
C435_449	435	449	1.2174933117433586e-10
R435_524	435	524	1.2318022073721919e+04
C435_524	435	524	7.1879947641015140e-11
R436_437	436	437	1.2394733936585030e+03
C436_437	436	437	7.1435077689448861e-10
R436_449	436	449	4.2277454089825496e+03
C436_449	436	449	2.0943048742215656e-10
R436_472	436	472	2.4724596994204007e+03
C436_472	436	472	3.5811252329312459e-10
R436_480	436	480	2.3567912123705087e+03
C436_480	436	480	3.7568825658061906e-10
R436_488	436	488	2.0213820301889666e+03
C436_488	436	488	4.3802644353043322e-10
R436_489	436	489	1.7340687347080445e+03
C436_489	436	489	5.1060189482573945e-10
R436_521	436	521	1.4115704785864943e+03
C436_521	436	521	6.2725793372119301e-10
R436_522	436	522	3.1742368469700159e+03
C436_522	436	522	2.7893910391254547e-10
R436_525	436	525	1.6492767693950771e+03
C436_525	436	525	5.3685275760280944e-10
R437_442	437	442	5.3415591531605578e+03
C437_442	437	442	1.6576036252937589e-10
R437_449	437	449	1.8303584885479370e+03
C437_449	437	449	4.8374063727943376e-10
R437_521	437	521	8.3115301687488011e+02
C437_521	437	521	1.0652897405451987e-09
R437_524	437	524	1.2295439043936219e+03
C437_524	437	524	7.2011969522687763e-10
R437_525	437	525	3.3275120096700216e+03
C437_525	437	525	2.6609033389718833e-10
R438_439	438	439	2.2849545437146121e+03
C438_439	438	439	3.8749951684403732e-10
R438_440	438	440	4.6743021805419239e+03
C438_440	438	440	1.8942266620797443e-10
R438_444	438	444	2.7419454524575362e+03
C438_444	438	444	3.2291626403669758e-10
R438_445	438	445	2.0876251043167636e+03
C438_445	438	445	4.2412729175805694e-10
R438_446	438	446	2.8478162717565469e+03
C438_446	438	446	3.1091148346935647e-10
R438_518	438	518	7.2929016291616326e+03
C438_518	438	518	1.2140829901771002e-10
R438_520	438	520	4.0839804009352924e+03
C438_520	438	520	2.1680289687414414e-10
R438_526	438	526	3.4861714865191011e+03
C438_526	438	526	2.5398027180357664e-10
R439_440	439	440	7.2503348224939027e+03
C439_440	439	440	1.2212108866379801e-10
R439_443	439	443	6.2051239929392723e+03
C439_443	439	443	1.4269155341738638e-10
R439_446	439	446	9.9928919569532372e+03
C439_446	439	446	8.8604858885110794e-11
R439_526	439	526	6.4448352655520248e+03
C439_526	439	526	1.3738423795447635e-10
R440_441	440	441	1.3277268272031949e+03
C440_441	440	441	6.6686818670757776e-10
R440_443	440	443	2.5057872222129658e+03
C440_443	440	443	3.5334954773935270e-10
R440_518	440	518	2.2540038046617105e+03
C440_518	440	518	3.9282044682834379e-10
R440_526	440	526	4.0504712633307931e+03
C440_526	440	526	2.1859648523265918e-10
R441_442	441	442	3.1498853849247948e+03
C441_442	441	442	2.8109555539308604e-10
R441_443	441	443	3.0764296957207202e+03
C441_443	441	443	2.8780725362637336e-10
R441_481	441	481	3.6847318821829535e+03
C441_481	441	481	2.4029395082484251e-10
R441_518	441	518	1.2604595424343131e+03
C441_518	441	518	7.0245712130513866e-10
R441_521	441	521	3.0246751690265569e+03
C441_521	441	521	2.9273185787581869e-10
R441_523	441	523	1.8644137919600814e+03
C441_523	441	523	4.7490465127333580e-10
R441_526	441	526	3.8616503133460924e+03
C441_526	441	526	2.2928507499499377e-10
R441_527	441	527	1.7905760735758449e+03
C441_527	441	527	4.9448822352003561e-10
R441_528	441	528	1.8709185690601350e+03
C441_528	441	528	4.7325351105195042e-10
R442_443	442	443	4.2823987370868135e+03
C442_443	442	443	2.0675766925485405e-10
R442_521	442	521	3.0875962825372771e+03
C442_521	442	521	2.8676637120847752e-10
R442_524	442	524	5.4629592697195612e+03
C442_524	442	524	1.6207676791730005e-10
R442_528	442	528	6.2698311235324072e+03
C442_528	442	528	1.4121892029544128e-10
R443_526	443	526	4.1936765638236593e+03
C443_526	443	526	2.1113187157492746e-10
R443_528	443	528	6.6912210273643423e+03
C443_528	443	528	1.3232544225919326e-10
R444_445	444	445	2.2567811315508152e+03
C444_445	444	445	3.9233701900527589e-10
R444_451	444	451	1.9016818071922783e+03
C444_451	444	451	4.6559775581345495e-10
R444_460	444	460	4.9826915254788073e+03
C444_460	444	460	1.7769889570173958e-10
R444_462	444	462	6.4761836550515336e+03
C444_462	444	462	1.3671922058747645e-10
R444_463	444	463	2.1043386645444502e+03
C444_463	444	463	4.2075869089811012e-10
R444_519	444	519	3.0447519565079820e+03
C444_519	444	519	2.9080161351320212e-10
R444_520	444	520	2.5838413293716835e+03
C444_520	444	520	3.4267536927869670e-10
R444_529	444	529	4.3035950112927749e+03
C444_529	444	529	2.0573933638658662e-10
R445_446	445	446	1.0758415434259337e+03
C445_446	445	446	8.2300110746834791e-10
R445_447	445	447	4.4475905712476406e+03
C445_447	445	447	1.9907830262613898e-10
R445_451	445	451	1.4553507610567224e+03
C445_451	445	451	6.0838857916087675e-10
R445_494	445	494	4.2007578719702578e+03
C445_494	445	494	2.1077596202532786e-10
R445_520	445	520	2.0163017488731123e+03
C445_520	445	520	4.3913009657153276e-10
R445_526	445	526	5.5651951272032420e+03
C445_526	445	526	1.5909932382639787e-10
R445_529	445	529	1.1077194961921953e+03
C445_529	445	529	7.9931678077676004e-10
R445_530	445	530	2.5636660680940645e+03
C445_530	445	530	3.4537211874799943e-10
R445_531	445	531	3.5293359058441615e+03
C445_531	445	531	2.5087404693723023e-10
R446_447	446	447	5.8540368296014976e+03
C446_447	446	447	1.5124926738123601e-10
R446_526	446	526	5.2126674051628643e+03
C446_526	446	526	1.6985905926456018e-10
R446_530	446	530	5.4037765660308914e+03
C446_530	446	530	1.6385184895798639e-10
R446_531	446	531	9.3224719278769990e+03
C446_531	446	531	9.4976824660885405e-11
R447_451	447	451	6.8141562820566178e+03
C447_451	447	451	1.2993813834759408e-10
R447_452	447	452	6.0378701077056494e+03
C447_452	447	452	1.4664422485174222e-10
R447_494	447	494	4.6237151960243182e+03
C447_494	447	494	1.9149509521289804e-10
R447_448	447	448	8.8950671485857765e+03
C447_448	447	448	9.9540426947847433e-11
R447_531	447	531	6.2019515655692812e+03
C447_531	447	531	1.4276454311824782e-10
R448_452	448	452	6.3681743776462199e+03
C448_452	448	452	1.3903808677225092e-10
R448_494	448	494	2.5801806611432944e+03
C448_494	448	494	3.4316154486161660e-10
R448_493	448	493	2.5818025558416243e+03
C448_493	448	493	3.4294596993741394e-10
R448_531	448	531	6.5766491925770642e+03
C448_531	448	531	1.3463068437637740e-10
R448_532	448	532	2.6167056703714593e+03
C448_532	448	532	3.3837156074733800e-10
R448_517	448	517	1.2475736263557757e+04
C448_517	448	517	7.0971264781089690e-11
R449_450	449	450	1.2778201058543511e+04
C449_450	449	450	6.9291348417781272e-11
R449_489	449	489	8.1053591798252100e+03
C449_489	449	489	1.0923868542480729e-10
R449_490	449	490	1.3386060070669611e+04
C449_490	449	490	6.6144838513018028e-11
R449_524	449	524	1.3051437870789969e+04
C449_524	449	524	6.7840707703296741e-11
R449_525	449	525	1.1128744317851035e+04
C449_525	449	525	7.9561427274391252e-11
R449_533	449	533	1.2813613983960218e+04
C449_533	449	533	6.9099848240187855e-11
R449_534	449	534	1.2180051141950042e+04
C449_534	449	534	7.2694176024473008e-11
R450_490	450	490	6.5505540403338418e+03
C450_490	450	490	1.3516700667580106e-10
R450_534	450	534	1.9111901984838867e+04
C450_534	450	534	4.6328135336942755e-11
R451_452	451	452	1.5073618004141729e+03
C451_452	451	452	5.8739632479522599e-10
R451_453	451	453	3.5993549102883644e+03
C451_453	451	453	2.4599374159217447e-10
R451_462	451	462	2.3337601542747948e+03
C451_462	451	462	3.7939579184183128e-10
R451_463	451	463	2.3141812171111142e+03
C451_463	451	463	3.8260563829366143e-10
R451_494	451	494	1.4696108929116515e+03
C451_494	451	494	6.0248517888008667e-10
R451_529	451	529	1.5827761306712348e+03
C451_529	451	529	5.5940872783095714e-10
R451_536	451	536	1.3022538025667384e+03
C451_536	451	536	6.7991260993428653e-10
R452_453	452	453	6.1905169488547072e+03
C452_453	452	453	1.4302824610855952e-10
R452_494	452	494	3.4750592909191978e+03
C452_494	452	494	2.5479242440948264e-10
R452_493	452	493	6.8417442030768907e+03
C452_493	452	493	1.2941418963044641e-10
R452_536	452	536	2.8562047870176489e+03
C452_536	452	536	3.0999835366305225e-10
R452_492	452	492	1.2484038653468100e+04
C452_492	452	492	7.0924066023620356e-11
R453_459	453	459	5.5168751693313998e+03
C453_459	453	459	1.6049280698285322e-10
R453_454	453	454	6.2062262377815359e+03
C453_454	453	454	1.4266621095922209e-10
R453_462	453	462	2.6223482876928551e+03
C453_462	453	462	3.3764347240045393e-10
R453_536	453	536	2.4650043666679426e+03
C453_536	453	536	3.5919562402108873e-10
R453_492	453	492	3.6872850492415096e+03
C453_492	453	492	2.4012756537011813e-10
R453_537	453	537	2.1168719500923530e+03
C453_537	453	537	4.1826752046167541e-10
R454_455	454	455	6.4041670011051183e+03
C454_455	454	455	1.3825666656525511e-10
R454_457	454	457	5.9489917755280512e+03
C454_457	454	457	1.4883509930914430e-10
R454_459	454	459	1.2145422365406723e+03
C454_459	454	459	7.2901440152620769e-10
R454_491	454	491	2.0990234698204581e+03
C454_491	454	491	4.2182414557553046e-10
R454_495	454	495	1.1164788544858044e+04
C454_495	454	495	7.9304572419132884e-11
R454_466	454	466	8.0534624314302027e+03
C454_466	454	466	1.0994262272143733e-10
R454_492	454	492	6.3785401560726705e+03
C454_492	454	492	1.3881213569801546e-10
R454_537	454	537	3.2906345504915694e+03
C454_537	454	537	2.6907235310214940e-10
R454_539	454	539	4.8761104539093249e+03
C454_539	454	539	1.8158300351669291e-10
R455_456	455	456	3.6035976193326919e+03
C455_456	455	456	2.4570411994665501e-10
R455_457	455	457	2.0700615785442592e+03
C455_457	455	457	4.2772581785835471e-10
R455_458	455	458	4.8720342019187301e+03
C455_458	455	458	1.8173492734334660e-10
R455_459	455	459	7.7896061933886986e+03
C455_459	455	459	1.1366669376065312e-10
R455_500	455	500	2.8454813942539495e+03
C455_500	455	500	3.1116660382597443e-10
R455_539	455	539	3.3337217862694065e+03
C455_539	455	539	2.6559468319965178e-10
R456_457	456	457	6.6410126261270161e+03
C456_457	456	457	1.3332586934356865e-10
R456_499	456	499	7.7026738607100497e+03
C456_499	456	499	1.1494953540956232e-10
R456_500	456	500	8.9294869415341727e+03
C456_500	456	500	9.9156736271331228e-11
R456_506	456	506	5.8312858875492466e+03
C456_506	456	506	1.5183937107088418e-10
R456_508	456	508	6.7139223980542583e+03
C456_508	456	508	1.3187801842282254e-10
R456_539	456	539	5.4934008449582507e+03
C456_539	456	539	1.6117862262183587e-10
R457_466	457	466	3.7271248072977774e+03
C457_466	457	466	2.3756080825797257e-10
R457_499	457	499	3.9598987738876385e+03
C457_499	457	499	2.2359631704189713e-10
R457_539	457	539	3.1931307524446670e+03
C457_539	457	539	2.7728860806032510e-10
R458_459	458	459	2.7931527935511781e+03
C458_459	458	459	3.1699618572397903e-10
R458_461	458	461	3.6322430184878990e+03
C458_461	458	461	2.4376639371134349e-10
R458_462	458	462	5.5644755561911588e+03
C458_462	458	462	1.5911989777991988e-10
R458_500	458	500	1.9740501018251691e+03
C458_500	458	500	4.4852903220711497e-10
R458_502	458	502	3.1080044773069276e+03
C458_502	458	502	2.8488336749991155e-10
R458_539	458	539	8.7132059145703570e+03
C458_539	458	539	1.0161802560173509e-10
R458_542	458	542	2.6586017711800891e+03
C458_542	458	542	3.3303926571409153e-10
R459_462	459	462	2.8211912577081312e+03
C459_462	459	462	3.1384571296995055e-10
R459_537	459	537	2.2890121719405024e+03
C459_537	459	537	3.8681261399732500e-10
R459_491	459	491	5.0454860305419334e+03
C459_491	459	491	1.7548731209248787e-10
R459_539	459	539	3.8486692732973811e+03
C459_539	459	539	2.3005842248986221e-10
R459_541	459	541	5.4287406695942436e+03
C459_541	459	541	1.6309837503550862e-10
R459_542	459	542	2.9434462567683945e+03
C459_542	459	542	3.0081024230151906e-10
R459_543	459	543	5.2346797096451119e+03
C459_543	459	543	1.6914478646488717e-10
R460_461	460	461	1.3580172621023144e+03
C460_461	460	461	6.5199376061634462e-10
R460_463	460	463	3.0386766790081469e+03
C460_463	460	463	2.9138301808042615e-10
R460_464	460	464	1.0893259032187941e+03
C460_464	460	464	8.1281348316763677e-10
R460_465	460	465	2.9654818518351790e+03
C460_465	460	465	2.9857501274272217e-10
R460_519	460	519	3.0272244930022521e+03
C460_519	460	519	2.9248533887947148e-10
R460_545	460	545	5.0036503514741762e+03
C460_545	460	545	1.7695456706704891e-10
R461_462	461	462	3.7590908887748587e+03
C461_462	461	462	2.3554066871433663e-10
R461_463	461	463	3.7209567060267959e+03
C461_463	461	463	2.3795460459561283e-10
R461_464	461	464	4.0588998192829154e+03
C461_464	461	464	2.1814255614134052e-10
R461_502	461	502	2.5617265313876956e+03
C461_502	461	502	3.4563360719864432e-10
R461_505	461	505	1.5975155080014026e+03
C461_505	461	505	5.5424737804750172e-10
R461_540	461	540	2.2244346393401497e+03
C461_540	461	540	3.9804216587934834e-10
R461_541	461	541	2.6689944871959901e+03
C461_541	461	541	3.3174245430166074e-10
R461_542	461	542	2.4193606255252794e+03
C461_542	461	542	3.6597222107297981e-10
R461_545	461	545	2.6874197029012857e+03
C461_545	461	545	3.2946799517176991e-10
R462_463	462	463	1.2531191337589992e+03
C462_463	462	463	7.0657191151809883e-10
R462_536	462	536	3.9486759912241450e+03
C462_536	462	536	2.2423181432658084e-10
R462_537	462	537	2.4473312740688370e+03
C462_537	462	537	3.6178950969230147e-10
R462_541	462	541	2.0631155517423081e+03
C462_541	462	541	4.2916587049729756e-10
R462_542	462	542	5.5438127622011843e+03
C462_542	462	542	1.5971296645098862e-10
R462_546	462	546	5.1263730054708749e+03
C462_546	462	546	1.7271836847515378e-10
R463_519	463	519	1.4917197182345651e+03
C463_519	463	519	5.9355572690819167e-10
R463_529	463	529	3.6193489221838986e+03
C463_529	463	529	2.4463482265361213e-10
R463_536	463	536	5.4679146843735734e+03
C463_536	463	536	1.6192988237917928e-10
R463_541	463	541	2.8569325871580004e+03
C463_541	463	541	3.0991938195531272e-10
R463_545	463	545	2.6626676470211537e+03
C463_545	463	545	3.3253071696370291e-10
R463_546	463	546	1.4001598170635377e+03
C463_546	463	546	6.3236979872549841e-10
R464_465	464	465	1.7410576089371555e+03
C464_465	464	465	5.0855225993384106e-10
R464_505	464	505	1.7410576089371559e+03
C464_505	464	505	5.0855225993384096e-10
R464_504	464	504	2.8291815313781481e+03
C464_504	464	504	3.1295933890417271e-10
R464_509	464	509	8.5349672173710167e+02
C464_509	464	509	1.0374015027239099e-09
R464_510	464	510	1.5450514094874268e+03
C464_510	464	510	5.7306752141906999e-10
R464_519	464	519	6.7955202661935800e+03
C464_519	464	519	1.3029448033652258e-10
R464_545	464	545	2.9107733529958587e+03
C464_545	464	545	3.0418678279732749e-10
R464_547	464	547	3.4208823536406185e+03
C464_547	464	547	2.5882760357359487e-10
R465_481	465	481	4.7299050596540355e+03
C465_481	465	481	1.8719588882504193e-10
R465_509	465	509	2.4667427663050180e+03
C465_509	465	509	3.5894248634051387e-10
R465_511	465	511	5.9642710248770018e+03
C465_511	465	511	1.4845381405488021e-10
R465_518	465	518	4.7515212675171842e+03
C465_518	465	518	1.8634427414920500e-10
R465_519	465	519	8.4947892655617779e+03
C465_519	465	519	1.0423081185657235e-10
R465_547	465	547	2.2538000637080409e+03
C465_547	465	547	3.9285595734844124e-10
R466_491	466	491	4.5482869484776165e+03
C466_491	466	491	1.9467082700144144e-10
R466_495	466	495	6.7189026027458829e-06
C466_495	466	495	1.4495829400741737e-10
R466_467	466	467	1.1198171015774642e-06
C466_467	466	467	7.9068160367682185e-11
R466_499	466	499	2.3723950355938843e-06
C466_499	466	499	4.1053898877858119e-10
R466_539	466	539	3.6287921498610763e+03
C466_539	466	539	2.4399820798055276e-10
R466_544	466	544	4.9058448261694874e-06
C466_544	466	544	2.8877188308891934e-10
R466_549	466	549	2.3430020753737608e-06
C466_549	466	549	3.7789927333237894e-11
R466_496	466	496	8.3986282618309820e-06
C466_496	466	496	1.0542421382357626e-11
R467_499	467	499	2.5284063147281443e-06
C467_499	467	499	3.5018848693043266e-11
R467_515	467	515	2.5148490066996163e-06
C467_515	467	515	3.5207631923078630e-11
R467_496	467	496	8.1076192334035679e-06
C467_496	467	496	1.0920823440401039e-11
R467_549	467	549	2.8272725167120678e-06
C467_549	467	549	3.1317065350661139e-11
R467_550	467	550	6.3944365260174928e-06
C467_550	467	550	1.3846705305423464e-11
R468_469	468	469	1.3689541028314845e+03
C468_469	468	469	6.4678485558327972e-10
R468_470	468	470	2.4310763648237721e+03
C468_470	468	470	3.6420854338904483e-10
R468_474	468	474	1.4331776352510713e+03
C468_474	468	474	6.1780114336272637e-10
R468_480	468	480	5.3875260621363150e+03
C468_480	468	480	1.6434607860605042e-10
R468_482	468	482	4.3019280822702849e+03
C468_482	468	482	2.0581905712211079e-10
R468_483	468	483	2.3074624209443355e+03
C468_483	468	483	3.8371969730178317e-10
R468_484	468	484	1.6242206382935074e+03
C468_484	468	484	5.4513454688660298e-10
R468_553	468	553	6.0324924105055024e+03
C468_553	468	553	1.4677495162000627e-10
R469_470	469	470	1.9279062397550085e+03
C469_470	469	470	4.5926444110296361e-10
R469_471	469	471	2.2377261649708548e+03
C469_471	469	471	3.9567789641121356e-10
R469_472	469	472	3.7561817897499477e+03
C469_472	469	472	2.3572309096332188e-10
R469_473	469	473	2.0954177654972759e+03
C469_473	469	473	4.2255000233324650e-10
R469_474	469	474	1.7176524803640752e+03
C469_474	469	474	5.1548191023618808e-10
R469_553	469	553	4.8182662795146907e+03
C469_553	469	553	1.8376294092844989e-10
R470_471	470	471	3.1915472925190679e+03
C470_471	470	471	2.7742618252137646e-10
R470_476	470	476	4.3676116727401713e+03
C470_476	470	476	2.0272378774564955e-10
R470_484	470	484	9.9185497217821594e+03
C470_484	470	484	8.9268976466945468e-11
R470_553	470	553	8.9984506412269238e+03
C470_553	470	553	9.8396803739012840e-11
R471_473	471	473	5.6799985236772454e+03
C471_473	471	473	1.5588362884411060e-10
R471_476	471	476	8.8826776261147552e+03
C471_476	471	476	9.9679265528774839e-11
R471_553	471	553	6.1094129493120208e+03
C471_553	471	553	1.4492698219060582e-10
R472_473	472	473	1.5172111260339259e+03
C472_473	472	473	5.8358310620522122e-10
R472_474	472	474	2.0161297976867288e+03
C472_474	472	474	4.3916754899209044e-10
R472_488	472	488	4.1571717030150803e+03
C472_488	472	488	2.1298585792302741e-10
R472_489	472	489	2.6526030967654342e+03
C472_489	472	489	3.3379241047395043e-10
R472_490	472	490	2.0092060209988476e+03
C472_490	472	490	4.4068093189359786e-10
R472_554	472	554	4.2584477230603661e+03
C472_554	472	554	2.0792054741103807e-10
R473_474	473	474	6.9294420004937338e+03
C473_474	473	474	1.2777634644130258e-10
R473_490	473	490	1.4194313654102640e+04
C473_490	473	490	6.2378414573365719e-11
R473_553	473	553	1.3423856161759946e+04
C473_553	473	553	6.5958601688705548e-11
R473_554	473	554	1.3053277602875982e+04
C473_554	473	554	6.7831146217630343e-11
R474_480	474	480	5.5224333659583972e+03
C474_480	474	480	1.6033127482495914e-10
R474_483	474	483	2.7771641790176568e+03
C474_483	474	483	3.1882118759474698e-10
R474_484	474	484	3.8418116049606156e+03
C474_484	474	484	2.3046907884726350e-10
R474_488	474	488	2.5078555594471268e+03
C474_488	474	488	3.5305812504416983e-10
R474_553	474	553	2.0585333375493760e+03
C474_553	474	553	4.3012117683460266e-10
R474_554	474	554	2.7609764994208113e+03
C474_554	474	554	3.2069044480666181e-10
R474_555	474	555	3.3372364597672508e+03
C474_555	474	555	2.6531496715151908e-10
R475_476	475	476	1.0211264660419371e+04
C475_476	475	476	8.6710002251928342e-11
R475_477	475	477	3.1624236798068137e+03
C475_477	475	477	2.7998107507027285e-10
R475_478	475	478	1.1025952969820404e+04
C475_478	475	478	8.0303152400841612e-11
R475_482	475	482	3.5632519408802013e+03
C475_482	475	482	2.4848615713692203e-10
R475_484	475	484	3.7949084157681377e+03
C475_484	475	484	2.3331756255856307e-10
R475_485	475	485	2.5164849579169577e+03
C475_485	475	485	3.5184743660574599e-10
R475_556	475	556	3.9857217162131105e+03
C475_556	475	556	2.2214766728401917e-10
R475_558	475	558	8.3848987565685547e+03
C475_558	475	558	1.0559683633703763e-10
R475_559	475	559	4.8152034231448051e+03
C475_559	475	559	1.8387982892771203e-10
R476_478	476	478	9.5527518185358986e+03
C476_478	476	478	9.2687300844763665e-11
R476_484	476	484	5.4310632477317695e+03
C476_484	476	484	1.6302862649772799e-10
R476_553	476	553	7.3137091533123466e+03
C476_553	476	553	1.2106289204828412e-10
R476_559	476	559	9.1872520633689001e+03
C476_559	476	559	9.6374713090795880e-11
R477_478	477	478	1.2466701353070683e+04
C477_478	477	478	7.1022699319087485e-11
R477_485	477	485	3.9750238628105631e+03
C477_485	477	485	2.2274552612973743e-10
R477_513	477	513	1.8315916452048023e+04
C477_513	477	513	4.8341494896969551e-11
R477_557	477	557	1.2330331619592000e+04
C477_557	477	557	7.1808188864371993e-11
R477_558	477	558	7.9241559752347348e+03
C477_558	477	558	1.1173666753496377e-10
R477_559	477	559	1.3626589632649368e+04
C477_559	477	559	6.4977283793630419e-11
R477_560	477	560	1.2466701353070674e+04
C477_560	477	560	7.1022699319087524e-11
R478_559	478	559	8.0709539548075309e+03
C478_559	478	559	1.0970435299938653e-10
R478_560	478	560	2.6012805579932843e+04
C478_560	478	560	3.4037804149162667e-11
R479_486	479	486	4.4076328696397695e+03
C479_486	479	486	2.0088306079184950e-10
R479_504	479	504	3.7664534435987721e+03
C479_504	479	504	2.3508024059206203e-10
R479_512	479	512	5.5863243854336797e+03
C479_512	479	512	1.5849755950598327e-10
R479_513	479	513	4.5997896769742529e+03
C479_513	479	513	1.9249114500435801e-10
R479_514	479	514	9.5793327233928558e+03
C479_514	479	514	9.2430110454123368e-11
R479_562	479	562	9.1078517838650059e+03
C479_562	479	562	9.7214886969127180e-11
R480_481	480	481	7.8601440800823491e+02
C480_481	480	481	1.1264663505897508e-09
R480_483	480	483	5.8236831562162854e+02
C480_483	480	483	1.5203759510077240e-09
R480_488	480	488	1.6482800184523367e+03
C480_488	480	488	5.3717740419578080e-10
R480_521	480	521	1.8887665337471360e+03
C480_521	480	521	4.6878148563094877e-10
R480_522	480	522	1.0914899525768367e+03
C480_522	480	522	8.1120195344873771e-10
R480_523	480	523	2.3226916242373759e+03
C480_523	480	523	3.8120376052534105e-10
R480_563	480	563	2.7259831879072594e+03
C480_563	480	563	3.2480713220382595e-10
R481_483	481	483	4.5022351934517174e+03
C481_483	481	483	1.9666204532979503e-10
R481_511	481	511	1.0923108013671435e+03
C481_511	481	511	8.1059235209594572e-10
R481_518	481	518	3.6017881547613738e+03
C481_518	481	518	2.4582755666224377e-10
R481_523	481	523	8.0383218719581328e+02
C481_523	481	523	1.1014970485180539e-09
R481_522	481	522	2.8445720220602198e+03
C481_522	481	522	3.1126607968910682e-10
R481_547	481	547	2.4121481628921169e+03
C481_547	481	547	3.6706649919812587e-10
R481_552	481	552	1.2498086327530302e+03
C481_552	481	552	7.0844348366328192e-10
R481_563	481	563	3.4292328285118224e+03
C481_563	481	563	2.5819733624918191e-10
R482_483	482	483	1.2493020362478915e+03
C482_483	482	483	7.0873076006442348e-10
R482_484	482	484	9.6503986514720009e+02
C482_484	482	484	9.1749451362296292e-10
R482_485	482	485	1.2211115894296183e+03
C482_485	482	485	7.2509243984292992e-10
R482_486	482	486	1.0549587190605769e+03
C482_486	482	486	8.3929234926694657e-10
R482_487	482	487	1.1707635677070546e+03
C482_487	482	487	7.5627462804816918e-10
R482_556	482	556	2.6493471928391568e+03
C482_556	482	556	3.3420262323230893e-10
R482_564	482	564	1.6305668628720307e+03
C482_564	482	564	5.4301286372301864e-10
R483_484	483	484	2.1458101533851768e+03
C483_484	483	484	4.1262680219085802e-10
R483_487	483	487	2.0121533305285266e+03
C483_487	483	487	4.4003544275993600e-10
R483_488	483	488	4.4199223747290362e+03
C483_488	483	488	2.0032450948966742e-10
R483_511	483	511	5.2474414410307436e+03
C483_511	483	511	1.6873342783337078e-10
R483_555	483	555	1.8702845462469522e+03
C483_555	483	555	4.7341394306911490e-10
R483_563	483	563	1.8297350676425760e+03
C483_563	483	563	4.8390545569024402e-10
R483_564	483	564	3.4116502428205076e+03
C483_564	483	564	2.5952800512399519e-10
R484_553	484	553	1.4874581916260529e+03
C484_553	484	553	5.9525624766103951e-10
R484_555	484	555	1.6195618931686406e+03
C484_555	484	555	5.4670265176942122e-10
R484_556	484	556	1.6268721290565793e+03
C484_556	484	556	5.4424608172091118e-10
R484_559	484	559	3.6363968950128133e+03
C484_559	484	559	2.4348793799552510e-10
R484_564	484	564	4.8166547314367226e+03
C484_564	484	564	1.8382442401801456e-10
R485_486	485	486	2.1772997646657409e+03
C485_486	485	486	4.0665910871300239e-10
R485_513	485	513	4.0687564147653143e+03
C485_513	485	513	2.1761410402619813e-10
R485_556	485	556	1.8593242725458870e+03
C485_556	485	556	4.7620460549769349e-10
R485_557	485	557	5.0302352518719263e+03
C485_557	485	557	1.7601935841281077e-10
R485_558	485	558	1.2879337839764346e+03
C485_558	485	558	6.8747228523372634e-10
R485_561	485	561	1.6890668049876058e+03
C485_561	485	561	5.2420589824243055e-10
R485_564	485	564	2.1695401568017319e+03
C485_564	485	564	4.0811357140549849e-10
R486_487	486	487	1.4560455171383510e+03
C486_487	486	487	6.0809828489439262e-10
R486_504	486	504	2.6181425321156862e+03
C486_504	486	504	3.3818585918792775e-10
R486_513	486	513	2.3341795235842578e+03
C486_513	486	513	3.7932762786831070e-10
R486_561	486	561	2.2269379896394184e+03
C486_561	486	561	3.9759471786790320e-10
R486_562	486	562	1.8996068332606217e+03
C486_562	486	562	4.6610633642552426e-10
R486_564	486	564	2.3254625320892474e+03
C486_564	486	564	3.8074953669733827e-10
R486_565	486	565	2.0758770830444951e+03
C486_565	486	565	4.2652755740308049e-10
R487_504	487	504	3.8116074147910276e+03
C487_504	487	504	2.3229537708005100e-10
R487_509	487	509	2.7394016420231451e+03
C487_509	487	509	3.2321612432344417e-10
R487_511	487	511	9.3335242738301213e+02
C487_511	487	511	9.4864357312766474e-10
R487_563	487	563	6.5806359695734800e+03
C487_563	487	563	1.3454912044882311e-10
R487_564	487	564	1.5335424603919503e+03
C487_564	487	564	5.7736828589258636e-10
R487_565	487	565	1.6859279095482668e+03
C487_565	487	565	5.2518187562197842e-10
R488_489	488	489	1.0113520918741291e+03
C488_489	488	489	8.7548024947398596e-10
R488_522	488	522	1.7048178193029737e+03
C488_522	488	522	5.1936269768813750e-10
R488_525	488	525	3.4088949187964722e+03
C488_525	488	525	2.5973777508301770e-10
R488_554	488	554	1.7048178193029655e+03
C488_554	488	554	5.1936269768813998e-10
R488_555	488	555	2.7161792076356710e+03
C488_555	488	555	3.2597951534675169e-10
R488_563	488	563	1.9525936504755061e+03
C488_563	488	563	4.5345777985315997e-10
R488_566	488	566	2.4516134386583794e+03
C488_566	488	566	3.6115758207971672e-10
R488_567	488	567	1.0390190302220672e+03
C488_567	488	567	8.5216801227477180e-10
R488_568	488	568	3.5502594872810714e+03
C488_568	488	568	2.4939551175682894e-10
R489_490	489	490	1.0190385692653018e+03
C489_490	489	490	8.6887661409946679e-10
R489_525	489	525	1.4133055816251690e+03
C489_525	489	525	6.2648785458120924e-10
R489_533	489	533	2.0671247983616963e+03
C489_533	489	533	4.2833349123465624e-10
R489_534	489	534	2.7452391083329589e+03
C489_534	489	534	3.2252883874937542e-10
R489_554	489	554	2.4177794134491205e+03
C489_554	489	554	3.6621156453511712e-10
R489_566	489	566	2.1253869034155082e+03
C489_566	489	566	4.1659181219058396e-10
R489_568	489	568	8.7995447057236731e+02
C489_568	489	568	1.0062097657439922e-09
R490_534	490	534	3.0863694023528601e+03
C490_534	490	534	2.8688036533313564e-10
R490_554	490	554	4.1608898792940563e+03
C490_554	490	554	2.1279553350020920e-10
R490_568	490	568	5.8638754807192745e+03
C490_568	490	568	1.5099549514843941e-10
R491_495	491	495	1.7448549845122691e+03
C491_495	491	495	5.0744548375605952e-10
R491_492	491	492	2.2989840140987776e+03
C491_492	491	492	3.8513481445284958e-10
R491_537	491	537	9.9073047867274283e+02
C491_537	491	537	8.9370298053833324e-10
R491_539	491	539	2.2403022159212828e+03
C491_539	491	539	3.9522291921489180e-10
R491_543	491	543	5.5652353420247141e+02
C491_543	491	543	1.5909817416236558e-09
R491_544	491	544	9.9073047867274079e+02
C491_544	491	544	8.9370298053833531e-10
R491_569	491	569	4.6254902872161520e+03
C491_569	491	569	1.9142160651533627e-10
R491_570	491	570	1.7209782120789430e+03
C491_570	491	570	5.1448575902097765e-10
R492_495	492	495	4.9146469660413941e+03
C492_495	492	495	1.8015918291139831e-10
R492_536	492	536	1.8503660906795405e+03
C492_536	492	536	4.7851005601536562e-10
R492_493	492	493	3.3263329901632464e+03
C492_493	492	493	2.6618464967830728e-10
R492_537	492	537	1.6892322078805089e+03
C492_537	492	537	5.2415457008775681e-10
R492_569	492	569	1.8119561952242855e+03
C492_569	492	569	4.8865352486647852e-10
R492_497	492	497	4.7243674921128613e+03
C492_497	492	497	1.8741530653112200e-10
R492_570	492	570	4.7430551082621378e+03
C492_570	492	570	1.8667689105227768e-10
R493_494	493	494	2.4639234663182488e+03
C493_494	493	494	3.5935319980658697e-10
R493_532	493	532	2.4446453982265762e+03
C493_532	493	532	3.6218699953061134e-10
R493_517	493	517	3.8764575654881178e+03
C493_517	493	517	2.2840925425905171e-10
R493_536	493	536	2.6655510469796013e+03
C493_536	493	536	3.3217100933155602e-10
R493_569	493	569	8.4253109308709054e+02
C493_569	493	569	1.0509033897559389e-09
R493_497	493	497	2.1376433252165339e+03
C493_497	493	497	4.1420323552354594e-10
R493_571	493	571	2.6054483983364967e+03
C493_571	493	571	3.3983355120957840e-10
R494_529	494	529	1.3201223503465626e+03
C494_529	494	529	6.7070963647237485e-10
R494_531	494	531	6.8576341919370054e+02
C494_531	494	531	1.2911432090400044e-09
R494_532	494	532	2.0551003889646108e+03
C494_532	494	532	4.3083967403951834e-10
R494_536	494	536	8.0005732239264137e+02
C494_536	494	536	1.1066941791771592e-09
R494_538	494	538	7.0221907098030351e+02
C494_538	494	538	1.2608868347365565e-09
R494_569	494	569	1.5768361281183259e+03
C494_569	494	569	5.6151604209918151e-10
R494_572	494	572	2.5899636848154046e+03
C494_572	494	572	3.4186532687353373e-10
R495_544	495	544	2.8054014332771558e-06
C495_544	495	544	3.4717336611548609e-10
R495_549	495	549	1.3077867789824078e-06
C495_549	495	549	6.7703603976555487e-11
R495_496	495	496	6.6696674458844363e-07
C495_496	495	496	1.3275306286018109e-10
R495_570	495	570	1.9246269358426425e-06
C495_570	495	570	5.0605166162740990e-10
R495_497	495	497	4.0018004655297605e-06
C495_497	495	497	1.3275306286018109e-10
R495_573	495	573	1.6333281341574675e-06
C495_573	495	573	5.4209485723255042e-11
R495_498	495	498	5.0022505844133274e-06
C495_498	495	498	1.7700408381357479e-11
R496_549	496	549	1.7146784298858674e-06
C496_549	496	549	5.1637599579469564e-11
R496_550	496	550	3.4797927000279181e-06
C496_550	496	550	2.5444584147006692e-11
R496_573	496	573	2.6946956750505872e-06
C496_573	496	573	3.2857839565997672e-11
R496_498	496	498	1.0493760990184029e-05
C496_498	496	498	8.4375733593344621e-12
R497_569	497	569	2.7897627346430213e+03
C497_569	497	569	3.1738139258401787e-10
R497_570	497	570	4.1584231822484512e-06
C497_570	497	570	2.3421393547768286e-10
R497_517	497	517	1.5198055342415273e-05
C497_517	497	517	6.4084557988012803e-11
R497_535	497	535	6.3325230656722207e-06
C497_535	497	535	1.3982085379202794e-11
R497_571	497	571	2.5669717942096941e-06
C497_571	497	571	3.7942008599120472e-10
R497_498	497	498	1.2665046131344440e-06
C497_498	497	498	6.9910426896013977e-11
R497_573	497	573	3.8977898813828108e-06
C497_573	497	573	2.2715918729459120e-11
R497_574	497	574	2.2500128982550467e-06
C497_574	497	574	3.9351720267322430e-11
R498_573	498	573	5.1681247009300684e-06
C498_573	498	573	1.7132302971340028e-11
R498_574	498	574	4.8982189447189057e-06
C498_574	498	574	1.8076341455798517e-11
R498_535	498	535	1.9983329059535986e-05
C498_535	498	535	4.4307871779626273e-12
R499_506	499	506	4.9950439770332386e-06
C499_506	499	506	1.9498540220551060e-10
R499_515	499	515	1.4132868557000634e-06
C499_515	499	515	6.2649615548954706e-11
R499_516	499	516	5.4112644587575285e-06
C499_516	499	516	1.6362511728049964e-11
R499_539	499	539	3.0069710898315684e+03
C499_539	499	539	2.9445536895720389e-10
R499_544	499	544	9.7523238165855545e-06
C499_544	499	544	9.9869597976191765e-11
R499_549	499	549	4.3826025968782765e-06
C499_549	499	549	2.0203036030022045e-11
R499_575	499	575	4.9018072451337585e-06
C499_575	499	575	1.0837865346128635e-10
R500_502	500	502	1.2424718014887674e+03
C500_502	500	502	7.1262686254856220e-10
R500_503	500	503	4.5252150424805859e+03
C500_503	500	503	1.9566336039019273e-10
R500_507	500	507	2.9039088522647035e+03
C500_507	500	507	3.0490584475799883e-10
R500_508	500	508	3.4056717528486788e+03
C500_508	500	508	2.5998359382679511e-10
R500_539	500	539	2.1426880240774367e+03
C500_539	500	539	4.1322804428387522e-10
R500_540	500	540	3.2177824192084677e+03
C500_540	500	540	2.7516427972709280e-10
R500_542	500	542	2.0772124099385751e+03
C500_542	500	542	4.2625336603211549e-10
R500_576	500	576	3.0802061086606773e+03
C500_576	500	576	2.8745439443498618e-10
R501_502	501	502	5.0891032277819409e+02
C501_502	501	502	1.7398326228998606e-09
R501_503	501	503	5.3056441969209743e+02
C501_503	501	503	1.6688242724867140e-09
R501_505	501	505	7.0774764233950509e+02
C501_505	501	505	1.2510374160671052e-09
R501_512	501	512	1.0961683672149491e+03
C501_512	501	512	8.0773976715784686e-10
R501_514	501	514	1.1255870543876183e+03
C501_514	501	514	7.8662843380134391e-10
R501_577	501	577	1.0876312769011697e+03
C501_577	501	577	8.1407991890661302e-10
R502_503	502	503	1.4389928639604743e+03
C502_503	502	503	6.1530449794108254e-10
R502_505	502	505	1.0734810091454872e+03
C502_505	502	505	8.2481084821874186e-10
R502_507	502	507	2.8036670702157003e+03
C502_507	502	507	3.1580739065137301e-10
R502_540	502	540	8.7249246290374504e+02
C502_540	502	540	1.0148153930788524e-09
R502_542	502	542	2.3851775832749786e+03
C502_542	502	542	3.7121713196896306e-10
R502_577	502	577	2.0135786569553645e+03
C502_577	502	577	4.3972396044304493e-10
R503_507	503	507	2.4357898352964135e+03
C503_507	503	507	3.6350376738978901e-10
R503_514	503	514	4.4280991646902867e+03
C503_514	503	514	1.9995459649150127e-10
R503_577	503	577	4.3380493142423802e+03
C503_577	503	577	2.0410528271153005e-10
R504_505	504	505	3.1663039353373892e+03
C504_505	504	505	2.7963796267892185e-10
R504_509	504	509	7.7247465773875672e+02
C504_509	504	509	1.1462107822305286e-09
R504_510	504	510	3.9114406666245450e+03
C504_510	504	510	2.2636641001743479e-10
R504_512	504	512	1.4260564990242872e+03
C504_512	504	512	6.2088618670144329e-10
R504_562	504	562	2.8002969524999321e+03
C504_562	504	562	3.1618746037256978e-10
R504_565	504	565	1.3589900429914821e+03
C504_565	504	565	6.5152705589436746e-10
R504_578	504	578	3.6167155937381904e+03
C504_578	504	578	2.4481294112065992e-10
R505_510	505	510	1.0305146602030161e+03
C505_510	505	510	8.5920056831172948e-10
R505_512	505	512	1.5815742210178887e+03
C505_512	505	512	5.5983384777867192e-10
R505_540	505	540	7.9454836257438103e+02
C505_540	505	540	1.1143673858079501e-09
R505_545	505	545	1.8272647132522791e+03
C505_545	505	545	4.8455966739711015e-10
R505_577	505	577	8.5980397274347126e+02
C505_577	505	577	1.0297914522013630e-09
R505_578	505	578	2.0545332033753839e+03
C505_578	505	578	4.3095861397876154e-10
R505_579	505	579	1.6702896303692669e+03
C505_579	505	579	5.3009895146403579e-10
R506_516	506	516	1.4894783935412231e-06
C506_516	506	516	5.9444889267236984e-11
R506_508	506	508	4.7964111832887684e+03
C506_508	506	508	1.8460026629595431e-10
R506_539	506	539	6.4383293172441054e+03
C506_539	506	539	1.3752306507971530e-10
R506_575	506	575	8.6922907643603538e-06
C506_575	506	575	1.6298005750147552e-10
R506_581	506	581	1.7873740704620960e-05
C506_581	506	581	5.4491148494967160e-11
R507_508	507	508	4.6966687911574236e+03
C507_508	507	508	1.8852059216247220e-10
R507_540	507	540	5.1091673306899920e+03
C507_540	507	540	1.7330001630234813e-10
R507_576	507	576	2.0877230938441103e+03
C507_576	507	576	4.2410738488775555e-10
R507_577	507	577	1.4440713450930659e+03
C507_577	507	577	6.1314060742818602e-10
R507_514	507	514	8.0165539367051642e+03
C507_514	507	514	1.1044880240198456e-10
R507_584	507	584	3.1923216325500362e+03
C507_584	507	584	2.7735888911441695e-10
R507_585	507	585	6.9020236034610607e+03
C507_585	507	585	1.2828393998189190e-10
R508_539	508	539	7.3010857232891321e+03
C508_539	508	539	1.2127220734796684e-10
R508_575	508	575	9.3341327432006383e+03
C508_575	508	575	9.4858173336454326e-11
R508_576	508	576	3.0224280321707179e+03
C508_576	508	576	2.9294950029433434e-10
R508_581	508	581	7.6434002152926769e+03
C508_581	508	581	1.1584095517182025e-10
R508_585	508	585	1.2142897640599591e+04
C508_585	508	585	7.2916597661139471e-11
R509_510	509	510	3.6368549405620020e+03
C509_510	509	510	2.4345727178306887e-10
R509_511	509	511	1.5025871157539761e+03
C509_511	509	511	5.8926286031389913e-10
R509_547	509	547	4.2329215539626921e+03
C509_547	509	547	2.0917438946420032e-10
R509_565	509	565	2.6250369008568719e+03
C509_565	509	565	3.3729765147719614e-10
R509_587	509	587	6.1051416437683592e+03
C509_587	509	587	1.4502837663132103e-10
R510_545	510	545	2.0562942336367551e+03
C510_545	510	545	4.3058953685536121e-10
R510_547	510	547	5.7845892312918686e+03
C510_547	510	547	1.5306510908506814e-10
R510_548	510	548	5.8983775641851489e+03
C510_548	510	548	1.5011225918738203e-10
R510_565	510	565	7.6391714617119651e+03
C510_565	510	565	1.1590508030062920e-10
R510_578	510	578	2.9126219231272025e+03
C510_578	510	578	3.0399372286168549e-10
R510_579	510	579	6.3705565381251226e+03
C510_579	510	579	1.3898609586166265e-10
R510_580	510	580	2.3584182499812387e+03
C510_580	510	580	3.7542907485007959e-10
R510_587	510	587	2.2086246405500210e+03
C510_587	510	587	4.0089147130021220e-10
R511_547	511	547	2.1902202362117760e+03
C511_547	511	547	4.0426015934882796e-10
R511_552	511	552	1.1377162042466955e+03
C511_552	511	552	7.7824221751878227e-10
R511_563	511	563	2.0925682263392887e+03
C511_563	511	563	4.2312540664394017e-10
R511_564	511	564	3.4855470375893929e+03
C511_564	511	564	2.5402577332950193e-10
R511_565	511	565	1.1914905003841998e+03
C511_565	511	565	7.4311862445776459e-10
R511_587	511	587	2.0862003171918782e+03
C511_587	511	587	4.2441695287047723e-10
R511_589	511	589	1.1314675217945983e+03
C511_589	511	589	7.8254016544430278e-10
R512_514	512	514	8.2385641682287951e+02
C512_514	512	514	1.0747246287338875e-09
R512_513	512	513	5.1248515238307145e+03
C512_513	512	513	1.7276964563417615e-10
R512_562	512	562	1.1613805959481226e+03
C512_562	512	562	7.6238468662993809e-10
R512_577	512	577	1.0894936148982968e+03
C512_577	512	577	8.1268836236608247e-10
R512_578	512	578	2.6309174762808279e+03
C512_578	512	578	3.3654373034598719e-10
R512_583	512	583	2.5434027734601900e+03
C512_583	512	583	3.4812369906140584e-10
R512_584	512	584	4.3779499245841826e+03
C512_584	512	584	2.0224506834305493e-10
R512_590	512	590	3.7772373010310625e+03
C512_590	512	590	2.3440909615562402e-10
R513_514	513	514	8.4930205828763574e+03
C513_514	513	514	1.0425251805996833e-10
R513_557	513	557	8.3673455194760518e+03
C513_557	513	557	1.0581836015246132e-10
R513_561	513	561	5.1173137110578318e+03
C513_561	513	561	1.7302413564889099e-10
R513_562	513	562	3.8007065075745736e+03
C513_562	513	562	2.3296162961686598e-10
R513_590	513	590	6.3759325831902834e+03
C513_590	513	590	1.3886890586552735e-10
R514_577	514	577	2.5929743796490698e+03
C514_577	514	577	3.4146838806013638e-10
R514_584	514	584	5.3966418746604095e+03
C514_584	514	584	1.6406847114636753e-10
R514_590	514	590	1.0644695826861143e+04
C514_590	514	590	8.3179340781697839e-11
R515_516	515	516	5.3160022329671592e-06
C515_516	515	516	1.6655726293888297e-11
R515_549	515	549	2.6914679595471705e-06
C515_549	515	549	3.2897243995019296e-11
R515_550	515	550	6.5800714544827062e-06
C515_550	515	550	1.3456066363790080e-11
R515_575	515	575	5.1050704697813997e-06
C515_575	515	575	1.7343909098632169e-11
R515_591	515	591	5.9181916829021515e-06
C515_591	515	591	1.4960968301483099e-11
R516_575	516	575	3.1319671464491010e-06
C516_575	516	575	2.8270372590078167e-11
R516_581	516	581	9.6062198307841041e-06
C516_581	516	581	9.2171405328721078e-12
R516_591	516	591	9.6704987372216897e-06
C516_591	516	591	9.1558750562887560e-12
R516_592	516	592	7.6849758646272853e-06
C516_592	516	592	1.1521425666090132e-11
R517_532	517	532	5.0371494579928349e+03
C517_532	517	532	1.7577774673630889e-10
R517_535	517	535	2.0974835199800216e-06
C517_535	517	535	4.2213384432619225e-11
R517_571	517	571	7.4635630460761593e-06
C517_571	517	571	1.8981149349837476e-10
R517_594	517	594	1.6779868143060301e-05
C517_594	517	594	5.8043403594851435e-11
R518_519	518	519	1.8594850134962799e+03
C518_519	518	519	4.7616344056207229e-10
R518_520	518	520	1.1462236714281016e+03
C518_520	518	520	7.7246597132027493e-10
R518_523	518	523	2.6476209444804354e+03
C518_523	518	523	3.3442052327991124e-10
R518_526	518	526	2.4266118860074212e+03
C518_526	518	526	3.6487861400728847e-10
R518_527	518	527	1.6786839617725691e+03
C518_527	518	527	5.2744816884118065e-10
R518_547	518	547	1.1240038813645051e+03
C518_547	518	547	7.8773640943759902e-10
R518_595	518	595	1.5770164596000996e+03
C518_595	518	595	5.6145183286452506e-10
R519_520	519	520	6.1186855824995689e+02
C519_520	519	520	1.4470735091086248e-09
R519_529	519	529	2.0017454493838268e+03
C519_529	519	529	4.4232336432814067e-10
R519_545	519	545	1.6328776015229535e+03
C519_545	519	545	5.4224442840920044e-10
R519_546	519	546	2.2902469855071367e+03
C519_546	519	546	3.8660405943245409e-10
R519_547	519	547	1.6990561468189164e+03
C519_547	519	547	5.2112390950572091e-10
R519_548	519	548	1.7427371694643725e+03
C519_548	519	548	5.0806214339947328e-10
R519_595	519	595	2.3147892226643121e+03
C519_595	519	595	3.8250514259820462e-10
R519_596	519	596	1.3205711847194248e+03
C519_596	519	596	6.7048167637257704e-10
R520_526	520	526	3.4091238103626620e+03
C520_526	520	526	2.5972033606072219e-10
R520_529	520	529	1.5941712649244298e+03
C520_529	520	529	5.5541007492816192e-10
R520_530	520	530	2.5777497986204389e+03
C520_530	520	530	3.4348515211750143e-10
R520_595	520	595	1.6889055617429719e+03
C520_595	520	595	5.2425594524434909e-10
R520_596	520	596	2.1207597579626590e+03
C520_596	520	596	4.1750074631300608e-10
R521_522	521	522	1.6563511263164621e+03
C521_522	521	522	5.3455983313699389e-10
R521_523	521	523	1.3842264519360122e+03
C521_523	521	523	6.3964879479194481e-10
R521_524	521	524	9.3195267661750347e+02
C521_524	521	524	9.5006839286475670e-10
R521_525	521	525	1.3985463522914727e+03
C521_525	521	525	6.3309934651023192e-10
R521_527	521	527	3.7718715777737011e+03
C521_527	521	527	2.3474255775765490e-10
R521_528	521	528	2.8448891180564297e+03
C521_528	521	528	3.1123138546253788e-10
R521_597	521	597	2.8547405319190088e+03
C521_597	521	597	3.1015735819073035e-10
R522_523	522	523	7.6821831423075662e+02
C522_523	522	523	1.1525614077381121e-09
R522_525	522	525	7.4452535876981608e+02
C522_525	522	525	1.1892392532646344e-09
R522_552	522	552	1.9672346439340481e+03
C522_552	522	552	4.5008295498972703e-10
R522_551	522	551	9.7977217247568888e+02
C522_551	522	551	9.0369864196359405e-10
R522_563	522	563	1.3559209954131422e+03
C522_563	522	563	6.5300174913968156e-10
R522_566	522	566	2.3123710066860290e+03
C522_566	522	566	3.8290515628326298e-10
R522_567	522	567	2.6248323384440960e+03
C522_567	522	567	3.3732393826907959e-10
R522_597	522	597	4.1592939976918260e+03
C522_597	522	597	2.1287718112529614e-10
R523_527	523	527	7.0023919577403774e+02
C523_527	523	527	1.2644519002128500e-09
R523_547	523	547	1.9919260672323735e+03
C523_547	523	547	4.4450383790108256e-10
R523_551	523	551	1.2411545558217222e+03
C523_551	523	551	7.1338317822456618e-10
R523_552	523	552	1.4431861406053583e+03
C523_552	523	552	6.1351668837992211e-10
R523_597	523	597	3.5540118871779846e+03
C523_597	523	597	2.4913219477244205e-10
R524_525	524	525	2.3318779330267789e+03
C524_525	524	525	3.7970202863523221e-10
R524_528	524	528	8.1558243670133097e+03
C524_528	524	528	1.0856275734444775e-10
R524_533	524	533	6.7023177765600531e+03
C524_533	524	533	1.3210635651991405e-10
R524_597	524	597	5.2865682100280383e+03
C524_597	524	597	1.6748460372088984e-10
R525_533	525	533	1.1100904709542287e+03
C525_533	525	533	7.9760956864974971e-10
R525_566	525	566	1.1765542738088850e+03
C525_566	525	566	7.5255243333026567e-10
R525_551	525	551	4.5924912823241521e+03
C525_551	525	551	1.9279705224653366e-10
R525_597	525	597	2.2642450047932007e+03
C525_597	525	597	3.9104371648193949e-10
R525_599	525	599	3.6714207952683482e+03
C525_599	525	599	2.4116515950476439e-10
R526_527	526	527	3.6864045731948299e+03
C526_527	526	527	2.4018491842653346e-10
R526_528	526	528	4.0239938760606251e+03
C526_528	526	528	2.2003482335485062e-10
R526_530	526	530	2.3405757104641625e+03
C526_530	526	530	3.7829102376030877e-10
R526_595	526	595	3.8307703946799920e+03
C526_595	526	595	2.3113334668390237e-10
R526_600	526	600	5.0208466062104189e+03
C526_600	526	600	1.7634850278134407e-10
R527_528	527	528	1.8706230424749972e+03
C527_528	527	528	4.7332827704747718e-10
R527_547	527	547	4.2700269138498134e+03
C527_547	527	547	2.0735672152982178e-10
R527_551	527	551	3.2859451612591142e+03
C527_551	527	551	2.6945634764054427e-10
R527_595	527	595	1.5810667100563439e+03
C527_595	527	595	5.6001355038867822e-10
R527_597	527	597	2.2981799050390118e+03
C527_597	527	597	3.8526956908752973e-10
R527_598	527	598	2.5872380508821630e+03
C527_598	527	598	3.4222547917386323e-10
R527_600	527	600	2.5487912331117082e+03
C527_600	527	600	3.4738772253976677e-10
R528_597	528	597	5.9570376363878204e+03
C528_597	528	597	1.4863407548267451e-10
R528_600	528	600	1.0232105741917045e+04
C528_600	528	600	8.6533388535340890e-11
R529_530	529	530	2.4960907080372826e+03
C529_530	529	530	3.5472219773464065e-10
R529_531	529	531	2.8282388340075813e+03
C529_531	529	531	3.1306365327194525e-10
R529_536	529	536	4.9277077215173049e+03
C529_536	529	536	1.7968167589034039e-10
R529_538	529	538	2.5658228866442537e+03
C529_538	529	538	3.4508180058289486e-10
R529_546	529	546	3.4580029509415290e+03
C529_546	529	546	2.5604916891667845e-10
R529_596	529	596	1.9316974775634144e+03
C529_596	529	596	4.5836306770811794e-10
R529_601	529	601	5.3450076562930872e+03
C529_601	529	601	1.6565341691466592e-10
R529_602	529	602	3.7105651843056148e+03
C529_602	529	602	2.3862100184764573e-10
R530_531	530	531	4.6800000472383854e+03
C530_531	530	531	1.8919204546215243e-10
R530_595	530	595	3.2547583740641835e+03
C530_595	530	595	2.7203825290243794e-10
R530_596	530	596	3.8781920275434736e+03
C530_596	530	596	2.2830710171431160e-10
R530_600	530	600	5.9583372189851652e+03
C530_600	530	600	1.4860165666333439e-10
R530_602	530	602	2.3340347945704971e+03
C530_602	530	602	3.7935114924579884e-10
R531_532	531	532	2.9434490571825118e+03
C531_532	531	532	3.0080995610894948e-10
R531_538	531	538	2.0407628201527539e+03
C531_538	531	538	4.3386657820124596e-10
R531_572	531	572	3.3409441392233439e+03
C531_572	531	572	2.6502052857005563e-10
R531_602	531	602	4.1998508975861250e+03
C531_602	531	602	2.1082147992656045e-10
R531_603	531	603	4.0016908339994493e+03
C531_603	531	603	2.2126116644925250e-10
R532_569	532	569	2.0681140215326241e+03
C532_569	532	569	4.2812861016426929e-10
R532_571	532	571	1.5671540824767351e+03
C532_571	532	571	5.6498514830187062e-10
R532_572	532	572	4.2728898279223625e+02
C532_572	532	572	2.0721778874662057e-09
R532_594	532	594	1.4481676793581075e+03
C532_594	532	594	6.1140625793586089e-10
R532_603	532	603	3.2718203791225337e+03
C532_603	532	603	2.7061961816420364e-10
R533_534	533	534	4.5981960041542907e+03
C533_534	533	534	1.9255785984330786e-10
R533_566	533	566	1.6305963187745808e+03
C533_566	533	566	5.4300305446869057e-10
R533_568	533	568	4.7702701986653728e+03
C533_568	533	568	1.8561187203771446e-10
R533_597	533	597	4.3808329776225428e+03
C533_597	533	597	2.0211196962375692e-10
R533_599	533	599	4.3972517333845717e+03
C533_599	533	599	2.0135731028946387e-10
R533_606	533	606	5.0611389179958305e+03
C533_606	533	606	1.7494457197207673e-10
R533_607	533	607	4.5981960041542907e+03
C533_607	533	607	1.9255785984330786e-10
R534_568	534	568	4.3307752063010012e+03
C534_568	534	568	2.0444810444369688e-10
R534_607	534	607	1.2967861781699035e+04
C534_607	534	607	6.8277931751983352e-11
R535_571	535	571	3.7622660110688989e-06
C535_571	535	571	2.3534188680306619e-11
R535_574	535	574	5.4903306172934005e-06
C535_574	535	574	1.6126875472874346e-11
R535_594	535	594	1.0316981112158834e-05
C535_594	535	594	8.5821498757665739e-12
R535_608	535	608	8.2535848897270530e-06
C535_608	535	608	1.0727687344708234e-11
R536_537	536	537	1.1704628913080294e+03
C536_537	536	537	7.5646890497358394e-10
R536_538	536	538	1.9291435309371498e+03
C536_538	536	538	4.5896988352643546e-10
R536_546	536	546	2.8607386431300924e+03
C536_546	536	546	3.0950705120381579e-10
R536_569	536	569	1.2892638565632385e+03
C536_569	536	569	6.8676305256880531e-10
R536_609	536	609	5.2300436766035500e+03
C536_609	536	609	1.6929472035977360e-10
R537_541	537	541	3.5238350667443920e+03
C537_541	537	541	2.5126567076194708e-10
R537_543	537	543	1.3665569060054393e+03
C537_543	537	543	6.4791943738966124e-10
R537_546	537	546	3.5745127859369381e+03
C537_546	537	546	2.4770334720397915e-10
R537_569	537	569	3.3939775641541928e+03
C537_569	537	569	2.6087938560685623e-10
R537_609	537	609	6.2341289650265817e+03
C537_609	537	609	1.4202766523875159e-10
R538_546	538	546	3.3290276533913734e+03
C538_546	538	546	2.6596918796934565e-10
R538_569	538	569	1.6008743354388514e+03
C538_569	538	569	5.5308450020049711e-10
R538_572	538	572	1.1981231760655994e+03
C538_572	538	572	7.3900480300159196e-10
R538_601	538	601	2.4037574431293551e+03
C538_601	538	601	3.6834780656874800e-10
R538_602	538	602	6.1038359557977456e+03
C538_602	538	602	1.4505940004153985e-10
R538_603	538	603	2.7029202312435245e+03
C538_603	538	603	3.2757858388319810e-10
R538_609	538	609	1.1696219452120513e+03
C538_609	538	609	7.5701279830165491e-10
R539_542	539	542	1.4467888219680417e+03
C539_542	539	542	6.1198895668517853e-10
R539_543	539	543	2.4991599520099435e+03
C539_543	539	543	3.5428655976497390e-10
R539_544	539	544	2.4483299734619327e+03
C539_544	539	544	3.6164193196884327e-10
R539_575	539	575	1.4682686656945114e+03
C539_575	539	575	6.0303594457025666e-10
R539_576	539	576	2.4460786434109691e+03
C539_576	539	576	3.6197478118091715e-10
R539_582	539	582	5.9649102426607014e+03
C539_582	539	582	1.4843790529613253e-10
R539_611	539	611	3.8187850233410231e+03
C539_611	539	611	2.3185876562523924e-10
R540_542	540	542	8.8394715702026008e+02
C540_542	540	542	1.0016648333195627e-09
R540_541	540	541	2.4767031077678926e+03
C540_541	540	541	3.5749895856430539e-10
R540_545	540	545	4.1168722646818087e+03
C540_545	540	545	2.1507074418993024e-10
R540_576	540	576	1.4959740520670100e+03
C540_576	540	576	5.9186774027036347e-10
R540_577	540	577	2.7469884356046418e+03
C540_577	540	577	3.2232344709711531e-10
R540_579	540	579	1.1473554043230527e+03
C540_579	540	579	7.7170402332519022e-10
R540_611	540	611	5.2605172747849929e+03
C540_611	540	611	1.6831401465860386e-10
R541_542	541	542	9.3100615926406601e+02
C541_542	541	542	9.5103429004153797e-10
R541_543	541	543	2.1182509947797480e+03
C541_543	541	543	4.1799521580872165e-10
R541_545	541	545	1.5954447409055510e+03
C541_545	541	545	5.5496674939518704e-10
R541_546	541	546	1.1762862494636140e+03
C541_546	541	546	7.5272390721539977e-10
R541_579	541	579	6.0016286746155974e+03
C541_579	541	579	1.4752975062335243e-10
R541_611	541	611	2.4636672376039096e+03
C541_611	541	611	3.5939057360730766e-10
R542_543	542	543	2.9056483107082036e+03
C542_543	542	543	3.0472331370488325e-10
R542_576	542	576	2.7412158516854738e+03
C542_576	542	576	3.2300221128357642e-10
R542_611	542	611	2.5374056826871524e+03
C542_611	542	611	3.4894648015540341e-10
R543_544	543	544	1.8275343764430563e+03
C543_544	543	544	4.8448816783588889e-10
R543_546	543	546	2.2844179705538309e+03
C543_546	543	546	3.8759053426870938e-10
R543_569	543	569	3.7719674784623326e+03
C543_569	543	569	2.3473658952673339e-10
R543_570	543	570	1.7748796953344956e+03
C543_570	543	570	4.9886129410767369e-10
R543_575	543	575	5.0933006970788892e+03
C543_575	543	575	1.7383987994421879e-10
R543_609	543	609	1.4829877770811647e+03
C543_609	543	609	5.9705062670354075e-10
R543_611	543	611	1.0278494397769543e+03
C543_611	543	611	8.6142848109363001e-10
R543_612	543	612	1.3079386992721882e+03
C543_612	543	612	6.7695740036799715e-10
R544_549	544	549	1.2524861461941832e-07
C544_549	544	549	7.0692900228113702e-10
R544_570	544	570	5.0825202660407817e-06
C544_570	544	570	2.7873377270339206e-10
R544_575	544	575	6.1165107182182397e-06
C544_575	544	575	2.3161408748543415e-10
R544_612	544	612	5.0484595660734345e-06
C544_612	544	612	1.9292234515281298e-10
R545_546	545	546	1.1286671049172908e+03
C545_546	545	546	7.8448178195543670e-10
R545_547	545	547	3.6114246172608287e+03
C545_547	545	547	2.4517160830884721e-10
R545_548	545	548	8.5891696975032744e+02
C545_548	545	548	1.0308549171608244e-09
R545_579	545	579	1.2048317875503114e+03
C545_579	545	579	7.3488995795857239e-10
R545_580	545	580	1.7607129518004122e+03
C545_580	545	580	5.0287514543163764e-10
R545_611	545	611	3.8725060001703168e+03
C545_611	545	611	2.2864232661254969e-10
R545_614	545	614	1.7807973432388017e+03
C545_614	545	614	4.9720356168639414e-10
R546_548	546	548	3.8256743128124017e+03
C546_548	546	548	2.3144123344077724e-10
R546_596	546	596	3.3216595311235574e+03
C546_596	546	596	2.6655916219098636e-10
R546_601	546	601	2.7831012498659406e+03
C546_601	546	601	3.1814105999293041e-10
R546_609	546	609	1.1806664508503889e+03
C546_609	546	609	7.4993134687808443e-10
R546_611	546	611	3.5836490597264869e+03
C546_611	546	611	2.4707184407381047e-10
R546_614	546	614	2.0814588011743858e+03
C546_614	546	614	4.2538376507881651e-10
R547_548	547	548	1.9609809774209436e+03
C547_548	547	548	4.5151829206649987e-10
R547_551	547	551	3.5594968247893125e+03
C547_551	547	551	2.4874829934773383e-10
R547_552	547	552	1.4396220794120827e+03
C547_552	547	552	6.1503556687710015e-10
R547_587	547	587	1.4333250959658608e+03
C547_587	547	587	6.1773758388242799e-10
R547_588	547	588	3.2430382463567689e+03
C547_588	547	588	2.7302138132187624e-10
R547_595	547	595	2.1812133459101392e+03
C547_595	547	595	4.0592947194285016e-10
R547_598	547	598	3.6531917002184073e+03
C547_598	547	598	2.4236855176449269e-10
R547_615	547	615	3.6134887620246445e+03
C547_615	547	615	2.4503155814545781e-10
R548_580	548	580	2.1163650746421908e+03
C548_580	548	580	4.1836769672155734e-10
R548_587	548	587	2.1563026700461910e+03
C548_587	548	587	4.1061897014718861e-10
R548_595	548	595	4.4114547434453661e+03
C548_595	548	595	2.0070902529728416e-10
R548_596	548	596	1.8502229917923287e+03
C548_596	548	596	4.7854706466612790e-10
R548_610	548	610	2.2457206861946784e+03
C548_610	548	610	3.9426932616465393e-10
R548_614	548	614	1.0938214695638208e+03
C548_614	548	614	8.0947284939751222e-10
R548_615	548	615	1.2066857648090465e+03
C548_615	548	615	7.3376085764972476e-10
R549_550	549	550	1.3750118239550894e-07
C549_550	549	550	6.4393539479040857e-10
R549_570	549	570	2.8792823366876260e-06
C549_570	549	570	3.0751370590443750e-11
R549_573	549	573	2.1060795333853329e-06
C549_573	549	573	4.2041089506091426e-11
R549_575	549	575	2.6779068726992161e-06
C549_575	549	575	3.3063837683329734e-11
R549_591	549	591	2.5044653563808493e-06
C549_591	549	591	3.5353604690284094e-11
R549_612	549	612	1.7845816571224315e-06
C549_612	549	612	4.9614921131023148e-11
R549_618	549	618	3.5788968878565112e-06
C549_618	549	618	2.4739991384057423e-11
R550_573	550	573	7.8947713512804773e-06
C550_573	550	573	1.1215255544498972e-11
R550_591	550	591	9.3834863050263942e-06
C550_591	550	591	9.4359255496084984e-12
R550_618	550	618	1.0073954248896161e-05
C550_618	550	618	8.7891880370314213e-12
R551_552	551	552	9.5451633489472806e+02
C551_552	551	552	9.2760987877452256e-10
R551_563	551	563	3.8035574076919384e+03
C551_563	551	563	2.3278701667797012e-10
R551_566	551	566	2.8838051973352758e+03
C551_566	551	566	3.0703141201012964e-10
R551_567	551	567	4.4222784976110934e+03
C551_567	551	567	2.0021777963063650e-10
R551_588	551	588	1.4271787182964893e+03
C551_588	551	588	6.2039797143055417e-10
R551_597	551	597	2.3355518292510587e+03
C551_597	551	597	3.7910474544421802e-10
R551_598	551	598	8.5174017184219326e+02
C551_598	551	598	1.0395409433195630e-09
R551_599	551	599	9.9974320541215786e+02
C551_599	551	599	8.8564621085369031e-10
R551_605	551	605	1.6697583111890544e+03
C551_605	551	605	5.3026762961250544e-10
R551_620	551	620	1.4179394707578740e+03
C551_620	551	620	6.2444046446267068e-10
R552_563	552	563	1.3667045647759430e+03
C552_563	552	563	6.4784943616922471e-10
R552_587	552	587	2.2552555637310656e+03
C552_587	552	587	3.9260241541547284e-10
R552_588	552	588	1.7274646134801289e+03
C552_588	552	588	5.1255393296667674e-10
R552_589	552	589	5.9466644434107127e+02
C552_589	552	589	1.4889334855291878e-09
R552_620	552	620	3.4111475292279870e+03
C552_620	552	620	2.5956625273852892e-10
R553_554	553	554	4.0429145254190448e+03
C553_554	553	554	2.1900507075603510e-10
R553_555	553	555	3.2272965501442654e+03
C553_555	553	555	2.7435309025457249e-10
R553_556	553	556	6.7302196974213593e+03
C553_556	553	556	1.3155867438313236e-10
R553_559	553	559	6.3668121634533672e+03
C553_559	553	559	1.3906783472935815e-10
R553_623	553	623	6.6741377929824366e+03
C553_623	553	623	1.3266414466764218e-10
R554_555	554	555	2.4274357707335944e+03
C554_555	554	555	3.6475477224776091e-10
R554_567	554	567	4.7680893088750736e+03
C554_567	554	567	1.8569676957432983e-10
R554_568	554	568	3.3979744920607714e+03
C554_568	554	568	2.6057252159153786e-10
R554_621	554	621	4.7266496663910611e+03
C554_621	554	621	1.8732481655998082e-10
R554_623	554	623	7.9991305219756177e+03
C554_623	554	623	1.1068937796020863e-10
R555_556	555	556	1.1697997413724668e+03
C555_556	555	556	7.5689774102803517e-10
R555_563	555	563	1.3683215175101820e+03
C555_563	555	563	6.4708386908299241e-10
R555_564	555	564	1.7034871472664779e+03
C555_564	555	564	5.1976839574093560e-10
R555_567	555	567	4.1669221715066797e+03
C555_567	555	567	2.1248747762904564e-10
R555_621	555	621	2.9896413068691031e+03
C555_621	555	621	2.9616221172273449e-10
R555_623	555	623	1.3194843048342298e+03
C555_623	555	623	6.7103396262923904e-10
R555_625	555	625	2.2832965298351101e+03
C555_625	555	625	3.8778089929648398e-10
R556_558	556	558	5.8004848097801084e+02
C556_558	556	558	1.5264565130954386e-09
R556_559	556	559	1.3272422558462677e+03
C556_559	556	559	6.6711165787548341e-10
R556_564	556	564	1.1060352132052337e+03
C556_564	556	564	8.0053398945057249e-10
R556_623	556	623	1.8985090559196590e+03
C556_623	556	623	4.6637585369383098e-10
R556_625	556	625	2.5979156987235660e+03
C556_625	556	625	3.4081890422196260e-10
R557_558	557	558	2.5974838728133664e+03
C557_558	557	558	3.4087556460590930e-10
R557_560	557	560	5.1125246714661616e+03
C557_560	557	560	1.7318621201804022e-10
R557_561	557	561	2.1943331751477390e+03
C557_561	557	561	4.0350243606027927e-10
R557_590	557	590	4.5108168747734808e+03
C557_590	557	590	1.9628790223155824e-10
R557_626	557	626	1.4233839854813150e+03
C557_626	557	626	6.2205194854752930e-10
R557_593	557	593	7.7401793275979517e+03
C557_593	557	593	1.1439254108015304e-10
R557_624	557	624	7.7609596864692039e+03
C557_624	557	624	1.1408624931317164e-10
R558_559	558	559	1.2769538418651518e+03
C558_559	558	559	6.9338354502049538e-10
R558_560	558	560	1.8550239847858520e+03
C558_560	558	560	4.7730853561023613e-10
R558_561	558	561	1.1496316429641790e+03
C558_561	558	561	7.7017607084740651e-10
R558_564	558	564	2.1555848401329918e+03
C558_564	558	564	4.1075571010481459e-10
R558_623	558	623	3.1359248521833156e+03
C558_623	558	623	2.8234693860203553e-10
R558_625	558	625	1.4445098254993957e+03
C558_625	558	625	6.1295448883076540e-10
R558_626	558	626	1.3898236802988961e+03
C558_626	558	626	6.3707274113330791e-10
R558_627	558	627	8.5830993849377626e+02
C558_627	558	627	1.0315839791553578e-09
R559_560	559	560	5.1869839595764106e+03
C559_560	559	560	1.7070011949146389e-10
R559_623	559	623	4.4484943051247110e+03
C559_623	559	623	1.9903785887282993e-10
R559_627	559	627	7.6644825278056205e+03
C559_627	559	627	1.1552231719334348e-10
R560_624	560	624	7.0261913025596687e+03
C560_624	560	624	1.2601689074099627e-10
R560_626	560	626	5.5337790860163614e+03
C560_626	560	626	1.6000255303602884e-10
R560_627	560	627	4.1533305423509037e+03
C560_627	560	627	2.1318283547902445e-10
R561_562	561	562	1.6812625383122365e+03
C561_562	561	562	5.2663921399738231e-10
R561_564	561	564	1.4419506991557203e+03
C561_564	561	564	6.1404234015658349e-10
R561_565	561	565	4.2912570340804705e+03
C561_565	561	565	2.0633086637974535e-10
R561_590	561	590	4.5251015677915439e+03
C561_590	561	590	1.9566826698480603e-10
R561_625	561	625	4.6617781645356899e+03
C561_625	561	625	1.8993155625374704e-10
R561_626	561	626	1.9046792926375545e+03
C561_626	561	626	4.6486502222318662e-10
R561_628	561	628	1.3567990874119764e+03
C561_628	561	628	6.5257914006184243e-10
R562_565	562	565	1.6193913874944949e+03
C562_565	562	565	5.4676021407641946e-10
R562_578	562	578	2.0783637769854445e+03
C562_578	562	578	4.2601723120110028e-10
R562_583	562	583	2.3130670436664027e+03
C562_583	562	583	3.8278993431013478e-10
R562_590	562	590	2.4654857609608566e+03
C562_590	562	590	3.5912548988112262e-10
R562_628	562	628	1.6342530808597887e+03
C562_628	562	628	5.4178804499127937e-10
R563_564	563	564	1.2177227202362683e+03
C563_564	563	564	7.2711034046257010e-10
R563_567	563	567	8.8705631659082599e+02
C563_567	563	567	9.9815396738606254e-10
R563_589	563	589	8.5365452089495113e+02
C563_589	563	589	1.0372097376954649e-09
R563_620	563	620	1.2525874143126814e+03
C563_620	563	620	7.0687184908834980e-10
R563_621	563	621	3.6143536007652415e+03
C563_621	563	621	2.4497292725109597e-10
R563_622	563	622	2.3916560393453437e+03
C563_622	563	622	3.7021158859547447e-10
R563_625	563	625	2.2902518603827662e+03
C563_625	563	625	3.8660323653313018e-10
R563_629	563	629	2.9293862078599564e+03
C563_629	563	629	3.0225402827537612e-10
R564_565	564	565	1.0510449208861855e+03
C564_565	564	565	8.4241763991729445e-10
R564_589	564	589	2.5422251786926031e+03
C564_589	564	589	3.4828495489740480e-10
R564_625	564	625	8.9302253615115740e+02
C564_625	564	625	9.9148537226851068e-10
R564_628	564	628	3.1938715796209617e+03
C564_628	564	628	2.7722429021553792e-10
R564_629	564	629	2.3670370213898618e+03
C564_629	564	629	3.7406207579301204e-10
R565_578	565	578	8.3900723607231237e+02
C565_578	565	578	1.0553172173400515e-09
R565_587	565	587	1.3040835816621907e+03
C565_587	565	587	6.7895861442519006e-10
R565_589	565	589	1.5277697790849379e+03
C565_589	565	589	5.7954987316893014e-10
R565_628	565	628	1.7212935968466024e+03
C565_628	565	628	5.1439149214409510e-10
R565_629	565	629	3.5531379518607973e+03
C565_629	565	629	2.4919347171316595e-10
R565_630	565	630	1.6998537760461113e+03
C565_630	565	630	5.2087938043676862e-10
R566_567	566	567	1.6234627222451436e+03
C566_567	566	567	5.4538904378138315e-10
R566_568	566	568	4.5145037211163317e+03
C566_568	566	568	1.9612760037354818e-10
R566_599	566	599	2.8880814412167565e+03
C566_599	566	599	3.0657680530192074e-10
R566_606	566	606	5.6365975272466976e+03
C566_606	566	606	1.5708391053645078e-10
R566_586	566	586	4.6423335268541668e+03
C566_586	566	586	1.9072709372951834e-10
R566_607	566	607	9.6077822369039804e+03
C566_607	566	607	9.2156416524415106e-11
R566_620	566	620	9.6247757224899124e+03
C566_620	566	620	9.1993705331862390e-11
R566_632	566	632	6.9097354260425627e+03
C566_632	566	632	1.2814076474808083e-10
R567_568	567	568	4.0086674995421868e+03
C567_568	567	568	2.2087608458449601e-10
R567_586	567	586	2.1155212741650967e+03
C567_586	567	586	4.1853456758520946e-10
R567_620	567	620	3.3767633990553372e+03
C567_620	567	620	2.6220930431421389e-10
R567_621	567	621	2.2007510653069185e+03
C567_621	567	621	4.0232573127325456e-10
R567_622	567	622	6.7007710405683902e+03
C567_622	567	622	1.3213685057128813e-10
R567_632	567	632	5.9799600782672351e+03
C567_632	567	632	1.4806432988036950e-10
R568_607	568	607	6.2781555811798862e+03
C568_607	568	607	1.4103167247945116e-10
R568_621	568	621	1.2369671517860201e+04
C568_621	568	621	7.1579813612800499e-11
R568_632	568	632	7.5634248630708098e+03
C568_632	568	632	1.1706585280210125e-10
R569_570	569	570	3.0023588806814919e+03
C569_570	569	570	2.9490770986679073e-10
R569_571	569	571	2.1423550080111759e+03
C569_571	569	571	4.1329227807204822e-10
R569_572	569	572	2.5895900749052685e+03
C569_572	569	572	3.4191464907139411e-10
R569_609	569	609	3.6374207791310237e+03
C569_609	569	609	2.4341939947666044e-10
R569_634	569	634	8.7231991792304125e+03
C569_634	569	634	1.0150161236810306e-10
R570_571	570	571	9.1510579959980417e-06
C570_571	570	571	1.0643148140050843e-10
R570_573	570	573	1.0356924253243578e-06
C570_573	570	573	8.5490514369911014e-11
R570_574	570	574	5.4678017202717314e-06
C570_574	570	574	1.6193322783036060e-11
R570_609	570	609	7.1894664153902331e+03
C570_609	570	609	1.2315500630263963e-10
R570_612	570	612	6.0316080209731721e-06
C570_612	570	612	1.6147611971954625e-10
R570_634	570	634	8.7222820218931490e-06
C570_634	570	634	1.1166351379734954e-10
R571_572	571	572	3.1277489131247235e+03
C571_572	571	572	2.8308499380643632e-10
R571_574	571	574	1.2681803620792983e-06
C571_574	571	574	6.9818048613233095e-11
R571_594	571	594	5.0463501869858490e-06
C571_594	571	594	1.9300298687312857e-10
R571_608	571	608	5.3445178978458906e-06
C571_608	571	608	1.6566859698549578e-11
R571_634	571	634	6.7000055103185607e-06
C571_634	571	634	1.4536714296668263e-10
R572_594	572	594	3.1966207587749936e+03
C572_594	572	594	2.7698586992825190e-10
R572_603	572	603	2.4731037915915326e+03
C572_603	572	603	3.5801925689912145e-10
R572_609	572	609	7.5343483099066789e+03
C572_609	572	609	1.1751763328167224e-10
R572_634	572	634	4.6158436015795596e+03
C572_634	572	634	1.9182165994467541e-10
R573_574	573	574	4.9239305352049488e-06
C573_574	573	574	1.7981951113433941e-11
R573_612	573	612	7.1188456497395837e-06
C573_612	573	612	1.2437673539563114e-11
R573_618	573	618	1.1981601553280215e-05
C573_618	573	618	7.3898199482155057e-12
R573_634	573	634	1.0864128860394438e-05
C573_634	573	634	8.1499289365742447e-12
R573_636	573	636	1.0945783806937965e-05
C573_636	573	636	8.0891309139394768e-12
R574_608	574	608	6.7632650013879289e-06
C574_608	574	608	1.3091587887186115e-11
R574_634	574	634	5.9651297079993237e-06
C574_634	574	634	1.4843244406113094e-11
R574_636	574	636	1.0934432130444811e-05
C574_636	574	636	8.0975287160521359e-12
R575_576	575	576	4.8639533521151234e+03
C575_576	575	576	1.8203685718222806e-10
R575_581	575	581	5.5610892615937175e-06
C575_581	575	581	2.2821073217482634e-10
R575_582	575	582	1.5846207448011717e+03
C575_582	575	582	5.5875753526822399e-10
R575_591	575	591	6.2803899688216561e-07
C575_591	575	591	1.4098149734261244e-10
R575_592	575	592	5.1939589419924903e-06
C575_592	575	592	1.7047088580957060e-11
R575_611	575	611	3.8831956564181905e+03
C575_611	575	611	2.2801292029583151e-10
R575_612	575	612	7.3585097141221432e-06
C575_612	575	612	1.3235841178912290e-10
R575_617	575	617	6.7178051078536562e-06
C575_617	575	617	2.1088287407129355e-10
R575_637	575	637	5.5136338237771006e-06
C575_637	575	637	1.2311682045153084e-10
R576_577	576	577	7.1428911547354191e+03
C576_577	576	577	1.2395803919159632e-10
R576_579	576	579	4.8916367109231278e+03
C576_579	576	579	1.8100665156160132e-10
R576_581	576	581	1.4241114447624228e+04
C576_581	576	581	6.2173419429805224e-11
R576_582	576	582	2.3509873441878840e+03
C576_582	576	582	3.7661571589865608e-10
R576_584	576	584	1.3856895700615989e+04
C576_584	576	584	6.3897340416630269e-11
R576_585	576	585	5.1921553982740670e+03
C576_585	576	585	1.7053010046546827e-10
R576_611	576	611	9.0300026389570940e+03
C576_611	576	611	9.8052992573904741e-11
R576_639	576	639	7.2640027087691115e+03
C576_639	576	639	1.2189130665261476e-10
R577_578	577	578	7.2374963364083269e+03
C577_578	577	578	1.2233771742942216e-10
R577_579	577	579	7.8583247321425124e+03
C577_579	577	579	1.1267271484447770e-10
R577_583	577	583	8.2120942824982994e+03
C577_583	577	583	1.0781887679821379e-10
R577_584	577	584	3.7397786663715774e+03
C577_584	577	584	2.3675700106580220e-10
R577_639	577	639	8.9573761277154081e+03
C577_639	577	639	9.8848007393636971e-11
R578_579	578	579	3.0940811895565057e+03
C578_579	578	579	2.8616533550850769e-10
R578_580	578	580	2.0127268542905556e+03
C578_580	578	580	4.3991005526285972e-10
R578_583	578	583	2.0709254813811353e+03
C578_583	578	583	4.2754738867257518e-10
R578_587	578	587	3.0427707397636791e+03
C578_587	578	587	2.9099096101100515e-10
R578_628	578	628	2.3174227408636702e+03
C578_628	578	628	3.8207046391976686e-10
R578_630	578	630	8.3954053177639673e+02
C578_630	578	630	1.0546468552584694e-09
R578_638	578	638	3.7893210339565721e+03
C578_638	578	638	2.3366159102531911e-10
R578_639	578	639	4.5143930431196695e+03
C578_639	578	639	1.9613240877407781e-10
R578_640	578	640	2.4150576876085229e+03
C578_640	578	640	3.6662427827004559e-10
R579_580	579	580	1.2951788939829555e+03
C579_580	579	580	6.8362662935090427e-10
R579_611	579	611	1.3409001759787861e+03
C579_611	579	611	6.6031670184075504e-10
R579_582	579	582	2.4767785850991704e+03
C579_582	579	582	3.5748806414383140e-10
R579_613	579	613	1.2533311989315409e+03
C579_613	579	613	7.0645235868604835e-10
R579_614	579	614	5.1346213845062175e+03
C579_614	579	614	1.7244090954237874e-10
R579_639	579	639	2.0211921857511670e+03
C579_639	579	639	4.3806758602272069e-10
R579_640	579	640	3.0903716532551680e+03
C579_640	579	640	2.8650883487342555e-10
R580_587	580	587	2.4026735281105348e+03
C580_587	580	587	3.6851397884101817e-10
R580_610	580	610	8.5623502048646162e+02
C580_610	580	610	1.0340838210482887e-09
R580_614	580	614	3.6147864045959818e+03
C580_614	580	614	2.4494359627286519e-10
R580_613	580	613	4.1995092368844153e+03
C580_613	580	613	2.1083863179138658e-10
R580_630	580	630	3.0593004074989549e+03
C580_630	580	630	2.8941871139220661e-10
R580_640	580	640	2.1748494921697861e+03
C580_640	580	640	4.0711726714322781e-10
R581_582	581	582	3.8404875791938307e+03
C581_582	581	582	2.3054853412281085e-10
R581_585	581	585	2.3438468498368879e+03
C581_585	581	585	3.7776307004086797e-10
R581_592	581	592	9.5608083581915781e-07
C581_592	581	592	9.2609196683812226e-11
R581_637	581	637	4.4497426822912518e-06
C581_637	581	637	3.1837122947197619e-10
R581_641	581	641	1.1472970018356925e-05
C581_641	581	641	8.4891763626827911e-11
R582_585	582	585	6.8105033989349677e+03
C582_585	582	585	1.3000783199645164e-10
R582_611	582	611	1.5392799943270813e+03
C582_611	582	611	5.7521619521019870e-10
R582_613	582	613	2.9935427136350809e+03
C582_613	582	613	2.9577623117487755e-10
R582_617	582	617	1.7292918497001403e+03
C582_617	582	617	5.1201234878515840e-10
R582_637	582	637	1.8595583154288906e+03
C582_637	582	637	4.7614467067454448e-10
R582_639	582	639	3.2026458440358706e+03
C582_639	582	639	2.7646478094006920e-10
R582_642	582	642	3.6875529894014512e+03
C582_642	582	642	2.4011011753453274e-10
R583_584	583	584	1.0084518256371806e+03
C583_584	583	584	8.7799809489219465e-10
R583_590	583	590	4.8043429830963640e+02
C583_590	583	590	1.8429549780589442e-09
R583_628	583	628	1.2605647820464621e+03
C583_628	583	628	7.0239847591376337e-10
R583_638	583	638	1.0073993055011114e+03
C583_638	583	638	8.7891541801248886e-10
R583_639	583	639	1.8672785705884571e+03
C583_639	583	639	4.7417605259667700e-10
R583_643	583	643	2.5227246403952749e+03
C583_643	583	643	3.5097718059362494e-10
R584_585	584	585	4.8717349226215756e+03
C584_585	584	585	1.8174609164152529e-10
R584_590	584	590	5.4831257925965392e+03
C584_590	584	590	1.6148066179614480e-10
R584_639	584	639	4.1273301908313297e+03
C584_639	584	639	2.1452579288832191e-10
R584_643	584	643	7.4357706807907571e+03
C584_643	584	643	1.1907559010491702e-10
R585_637	585	637	6.2625191450233870e+03
C585_637	585	637	1.4138380437584971e-10
R585_639	585	639	2.4178612181908175e+03
C585_639	585	639	3.6619917431097280e-10
R585_641	585	641	6.8246939724185622e+03
C585_641	585	641	1.2973750695318307e-10
R585_643	585	643	1.1050547323201534e+04
C585_643	585	643	8.0124427849921107e-11
R586_599	586	599	3.3060705998477520e+03
C586_599	586	599	2.6781605381953263e-10
R586_606	586	606	5.5822395094323401e+03
C586_606	586	606	1.5861354214628433e-10
R586_620	586	620	1.0898517319739212e+03
C586_620	586	620	8.1242131908745462e-10
R586_605	586	605	5.0243142530697251e+03
C586_605	586	605	1.7622679177741167e-10
R586_622	586	622	2.1375090961036294e+03
C586_622	586	622	4.1422924623525153e-10
R586_621	586	621	3.4507705880950093e+03
C586_621	586	621	2.5658581441335215e-10
R586_631	586	631	1.1964216761793116e+03
C586_631	586	631	7.4005578411745491e-10
R586_632	586	632	1.0898517319739278e+03
C586_632	586	632	8.1242131908744965e-10
R586_633	586	633	1.7547157747026852e+03
C586_633	586	633	5.0459384617433175e-10
R586_644	586	644	2.9152565334598644e+03
C586_644	586	644	3.0371899403623784e-10
R587_588	587	588	1.6066765246304114e+03
C587_588	587	588	5.5108714674453540e-10
R587_589	587	589	1.5063261741476438e+03
C587_589	587	589	5.8780017030575388e-10
R587_610	587	610	2.2072102102215581e+03
C587_610	587	610	4.0114837164110533e-10
R587_615	587	615	5.6197364155978621e+03
C587_615	587	615	1.5755521544435350e-10
R587_630	587	630	1.7247052239517527e+03
C587_630	587	630	5.1337397800145389e-10
R587_646	587	646	4.4504059765257944e+03
C587_646	587	646	1.9895236218229275e-10
R588_589	588	589	2.6078849110749475e+03
C588_589	588	589	3.3951604917068145e-10
R588_598	588	598	2.6981772060052308e+03
C588_598	588	598	3.2815442207774824e-10
R588_605	588	605	1.5653617627029423e+03
C588_605	588	605	5.6563204927858298e-10
R588_610	588	610	3.5503683717498702e+03
C588_610	588	610	2.4938786317083029e-10
R588_615	588	615	1.2055953828588845e+03
C588_615	588	615	7.3442449621892653e-10
R588_620	588	620	1.7134526918751117e+03
C588_620	588	620	5.1674539127838121e-10
R588_644	588	644	4.0625345986286611e+03
C588_644	588	644	2.1794738240478733e-10
R588_645	588	645	3.2715517967940391e+03
C588_645	588	645	2.7064183503610340e-10
R588_646	588	646	2.1697244667196624e+03
C588_646	588	646	4.0807890369537873e-10
R589_620	589	620	2.3107291073271049e+03
C589_620	589	620	3.8317723133032788e-10
R589_629	589	629	2.5488612052551348e+03
C589_629	589	629	3.4737818594220858e-10
R589_630	589	630	4.0359903033425103e+03
C589_630	589	630	2.1938080003976161e-10
R589_646	589	646	4.2912054301451508e+03
C589_646	589	646	2.0633334761371482e-10
R590_626	590	626	5.0607875113850259e+03
C590_626	590	626	1.7495671962280836e-10
R590_593	590	593	4.8540128969734460e+03
C590_593	590	593	1.8240964754174277e-10
R590_628	590	628	2.7385604494872719e+03
C590_628	590	628	3.2331540531295301e-10
R590_638	590	638	4.1093005772656561e+03
C590_638	590	638	2.1546702779507094e-10
R590_643	590	643	7.7851625654191166e+03
C590_643	590	643	1.1373157262417850e-10
R590_647	590	647	7.3181037381894494e+03
C590_647	590	647	1.2099019272977112e-10
R591_592	591	592	8.7213853801028450e-06
C591_592	591	592	1.0152272180518628e-11
R591_612	591	612	7.2401199695266201e-06
C591_612	591	612	1.2229338538956435e-11
R591_617	591	617	3.1771076220738913e-06
C591_617	591	617	2.7868705974839886e-11
R591_618	591	618	6.0727978128654540e-06
C591_618	591	618	1.4580080038630734e-11
R591_619	591	619	8.0638493001163106e-06
C591_619	591	619	1.0980100802320662e-11
R591_637	591	637	6.5673390373962334e-06
C591_637	591	637	1.3482154288946894e-11
R591_648	591	648	7.1735003698160391e-06
C591_648	591	648	1.2342911215639988e-11
R592_637	592	637	4.2118032127859494e-06
C592_637	592	637	2.1022320772539815e-11
R592_641	592	641	8.5548042391979207e-06
C592_641	592	641	1.0349959589291725e-11
R592_648	592	648	6.1259924093008282e-06
C592_648	592	648	1.4453475005220497e-11
R592_649	592	649	2.0531530174075005e-05
C592_649	592	649	4.3124831622048856e-12
R593_626	593	626	3.6161678834107283e+03
C593_626	593	626	2.4485002086376673e-10
R593_624	593	624	5.0748603422364376e+03
C593_624	593	624	1.7447155625760636e-10
R593_638	593	638	4.6022613425269237e+03
C593_638	593	638	1.9238776675247456e-10
R593_643	593	643	1.0173444558438123e+04
C593_643	593	643	8.7032349428356644e-11
R593_647	593	647	1.2869714603267148e+03
C593_647	593	647	6.8798633768865776e-10
R593_650	593	650	3.7988565777254794e+03
C593_650	593	650	2.3307507498220271e-10
R593_651	593	651	8.1767661592827726e+03
C593_651	593	651	1.0828471359607342e-10
R594_603	594	603	3.9330729519479610e+03
C594_603	594	603	2.2512137265632776e-10
R594_608	594	608	1.1982511721013112e-06
C594_608	594	608	7.3892586322055233e-11
R594_634	594	634	7.6645651670719400e-06
C594_634	594	634	1.8483371433531688e-10
R594_654	594	654	1.4379014050836719e-05
C594_654	594	654	6.7734870795217309e-11
R595_596	595	596	9.7343321158163246e+02
C595_596	595	596	9.0958349393213468e-10
R595_598	595	598	1.1896624585302818e+03
C595_598	595	598	7.4426050460888993e-10
R595_600	595	600	1.2807657363293361e+03
C595_600	595	600	6.9131985388491341e-10
R595_602	595	602	5.7547749667748712e+03
C595_602	595	602	1.5385810684378722e-10
R595_615	595	615	2.1445461962147551e+03
C595_615	595	615	4.1286999704777362e-10
R595_656	595	656	4.6503535665766367e+03
C595_656	595	656	1.9039816414471084e-10
R596_601	596	601	2.0650510730574924e+03
C596_601	596	601	4.2876362393742560e-10
R596_602	596	602	2.1524033519696804e+03
C596_602	596	602	4.1136285208334515e-10
R596_604	596	604	1.1633503572609816e+03
C596_604	596	604	7.6109383228681856e-10
R596_614	596	614	3.1834208324694064e+03
C596_614	596	614	2.7813438068543807e-10
R596_615	596	615	1.9396714565355987e+03
C596_615	596	615	4.5647873959099520e-10
R596_656	596	656	4.9554306104645957e+03
C596_656	596	656	1.7867645645773411e-10
R597_598	597	598	3.7965730088687365e+03
C597_598	597	598	2.3321526535422216e-10
R597_599	597	599	1.5505630408610668e+03
C597_599	597	599	5.7103049561164865e-10
R597_600	597	600	5.5437320453725551e+03
C597_600	597	600	1.5971529187437436e-10
R597_606	597	606	8.1140905915832946e+03
C597_606	597	606	1.0912113584465529e-10
R597_657	597	657	5.4184034574860407e+03
C597_657	597	657	1.6340953357334617e-10
R598_599	598	599	3.7306287944436167e+03
C598_599	598	599	2.3733767964766137e-10
R598_600	598	600	2.8628096745923726e+03
C598_600	598	600	3.0928314570058604e-10
R598_605	598	605	1.1868838237407729e+03
C598_605	598	605	7.4600290608846001e-10
R598_615	598	615	9.7674202116688048e+02
C598_615	598	615	9.0650219045784525e-10
R598_656	598	656	4.1138592494714367e+03
C598_656	598	656	2.1522826329407406e-10
R598_657	598	657	2.9976185544214532e+03
C598_657	598	657	2.9537406632141958e-10
R599_605	599	605	1.2051503161106573e+03
C599_605	599	605	7.3469572207181882e-10
R599_606	599	606	1.3937303615717840e+03
C599_606	599	606	6.3528700106774310e-10
R599_620	599	620	4.3497066356263613e+03
C599_620	599	620	2.0355827550482591e-10
R599_631	599	631	3.9291574014309390e+03
C599_631	599	631	2.2534571442150528e-10
R599_657	599	657	2.6888242615786903e+03
C599_657	599	657	3.2929589127559562e-10
R600_602	600	602	6.3885740239121506e+03
C600_602	600	602	1.3859411793397346e-10
R600_656	600	656	3.6202950485639126e+03
C600_656	600	656	2.4457088989231008e-10
R600_657	600	657	6.5676100347330766e+03
C600_657	600	657	1.3481597978829836e-10
R601_602	601	602	1.7771482924016263e+03
C601_602	601	602	4.9822447878193153e-10
R601_603	601	603	1.9351115824360695e+03
C601_603	601	603	4.5755438070675269e-10
R601_604	601	604	8.7997962318714201e+02
C601_604	601	604	1.0061810050705018e-09
R601_609	601	609	1.2412135022879916e+03
C601_609	601	609	7.1334929894644467e-10
R601_614	601	614	1.7683692807445696e+03
C601_614	601	614	5.0069789796800559e-10
R601_616	601	616	9.0598192738309729e+02
C601_616	601	616	9.7730291845611837e-10
R601_634	601	634	4.2929293114756592e+03
C601_634	601	634	2.0625049178730703e-10
R601_654	601	654	5.4788172739159390e+03
C601_654	601	654	1.6160764950409716e-10
R601_658	601	658	2.4246289661718151e+03
C601_658	601	658	3.6517702050634376e-10
R602_603	602	603	4.8403527435714068e+03
C602_603	602	603	1.8292443311614980e-10
R602_604	602	604	3.8638183804294181e+03
C602_604	602	604	2.2915641847575562e-10
R602_656	602	656	2.7508011009998590e+03
C602_656	602	656	3.2187670034673489e-10
R602_658	602	658	5.2134724793082714e+03
C602_658	602	658	1.6983282931177541e-10
R603_609	603	609	5.7234982998970272e+03
C603_609	603	609	1.5469888087778932e-10
R603_634	603	634	3.9759078668120401e+03
C603_634	603	634	2.2269600085324562e-10
R603_654	603	654	3.5345470358146868e+03
C603_654	603	654	2.5050417287654444e-10
R603_658	603	658	6.5177972481566094e+03
C603_658	603	658	1.3584632169256536e-10
R604_614	604	614	2.0855499409882977e+03
C604_614	604	614	4.2454930677920796e-10
R604_615	604	615	1.6686695203218453e+03
C604_615	604	615	5.3061362415802051e-10
R604_616	604	616	3.9167975349054809e+03
C604_616	604	616	2.2605681652150208e-10
R604_645	604	645	7.3293922577099220e+03
C604_645	604	645	1.2080384710868925e-10
R604_655	604	655	1.3013271142981973e+03
C604_655	604	655	6.8039678261641713e-10
R604_656	604	656	2.8223000981311798e+03
C604_656	604	656	3.1372240758036003e-10
R604_658	604	658	4.1684212051326003e+03
C604_658	604	658	2.1241106359639923e-10
R605_615	605	615	1.4453474812493430e+03
C605_615	605	615	6.1259924909866896e-10
R605_620	605	620	1.6296590164592526e+03
C605_620	605	620	5.4331536398561598e-10
R605_631	605	631	1.7844182255890391e+03
C605_631	605	631	4.9619465269007867e-10
R605_644	605	644	1.3364527731607552e+03
C605_644	605	644	6.6251408166556828e-10
R605_645	605	645	3.6669033572931107e+03
C605_645	605	645	2.4146226268521340e-10
R605_656	605	656	4.4540087244273973e+03
C605_656	605	656	1.9879143407242166e-10
R605_657	605	657	1.3687647936988269e+03
C605_657	605	657	6.4687431016348959e-10
R605_659	605	659	9.8391319121949812e+02
C605_659	605	659	8.9989522409246220e-10
R606_607	606	607	9.4562684377429032e+03
C606_607	606	607	9.3632999901527629e-11
R606_631	606	631	3.6018413484131161e+03
C606_631	606	631	2.4582392616767927e-10
R606_632	606	632	7.3808359641306497e+03
C606_632	606	632	1.1996185608282774e-10
R606_657	606	657	8.4463008484372058e+03
C606_657	606	657	1.0482917878349389e-10
R606_660	606	660	1.3583088796516095e+04
C606_660	606	660	6.5185378301222593e-11
R606_661	606	661	8.5136603131427673e+03
C606_661	606	661	1.0399977790200944e-10
R607_632	607	632	6.3448741145018748e+03
C607_632	607	632	1.3954867594240883e-10
R607_661	607	661	2.0675145862549161e+04
C607_661	607	661	4.2825273765243048e-11
R608_634	608	634	6.3213165232728037e-06
C608_634	608	634	1.4006873068928098e-11
R608_636	608	636	1.5786843255676797e-05
C608_636	608	636	5.6085866399009952e-12
R608_654	608	654	1.8011821689201073e-05
C608_654	608	654	4.9157647514956810e-12
R608_662	608	662	1.4409457351360863e-05
C608_662	608	662	6.1447059393695983e-12
R609_611	609	611	4.9287899614109092e+03
C609_611	609	611	1.7964222225581332e-10
R609_612	609	612	4.5397047586445378e+03
C609_612	609	612	1.9503884696774155e-10
R609_614	609	614	4.9124729826730554e+03
C609_614	609	614	1.8023891120073124e-10
R609_616	609	616	3.5940145688993512e+03
C609_616	609	616	2.4635926336023593e-10
R609_634	609	634	1.5619749053192172e+03
C609_634	609	634	5.6685851909960674e-10
R609_635	609	635	3.6837261829437689e+03
C609_635	609	635	2.4035955381255754e-10
R609_665	609	665	7.1158530025974205e+03
C609_665	609	665	1.2442904334544370e-10
R610_614	610	614	1.3580330180060539e+03
C610_614	610	614	6.5198619618249444e-10
R610_613	610	613	2.9172867874598974e+03
C610_613	610	613	3.0350762410676140e-10
R610_615	610	615	3.0962680510594855e+03
C610_615	610	615	2.8596321994700242e-10
R610_630	610	630	2.9784969877641020e+03
C610_630	610	630	2.9727032974596567e-10
R610_640	610	640	2.2003978934333659e+03
C610_640	610	640	4.0239030601799335e-10
R610_645	610	645	1.3069701757240566e+03
C610_645	610	645	6.7745905617890741e-10
R610_646	610	646	1.2529213353462342e+03
C610_646	610	646	7.0668345786874329e-10
R610_664	610	664	2.3312754959957470e+03
C610_664	610	664	3.7980014941212048e-10
R610_665	610	665	3.7707008246165769e+03
C610_665	610	665	2.3481544224342800e-10
R611_612	611	612	1.6816173956741579e+03
C611_612	611	612	5.2652808182032206e-10
R611_613	611	613	1.4607839781241771e+03
C611_613	611	613	6.0612574820062351e-10
R611_614	611	614	3.2662123793242777e+03
C611_614	611	614	2.7108426485211524e-10
R611_617	611	617	1.8098241676583741e+03
C611_617	611	617	4.8922917348683191e-10
R611_635	611	635	4.7022882382641956e+03
C611_635	611	635	1.8829530152895176e-10
R611_665	611	665	2.9729502561728782e+03
C611_665	611	665	2.9782495682918436e-10
R611_666	611	666	2.7301226700081884e+03
C611_666	611	666	3.2431465128903693e-10
R612_617	612	617	5.3604627691629045e-06
C612_617	612	617	1.2663478784378498e-10
R612_618	612	618	7.1726432982520288e-07
C612_618	612	618	1.2344386091467509e-10
R612_634	612	634	7.0557386113668343e-06
C612_634	612	634	9.6208363561522578e-11
R612_635	612	635	3.9168562359604704e-06
C612_635	612	635	2.4865877127532871e-10
R612_636	612	636	6.1721801909403077e-06
C612_636	612	636	1.4345316473417961e-11
R612_666	612	666	8.6061971925195224e-06
C612_666	612	666	1.1316968890076128e-10
R613_614	613	614	2.5473049857071787e+03
C613_614	613	614	3.4759040894908451e-10
R613_617	613	617	1.9785040319735010e+03
C613_617	613	617	4.4751932136161486e-10
R613_639	613	639	3.2281902012928126e+03
C613_639	613	639	2.7427714183179517e-10
R613_640	613	640	1.1876244399788986e+03
C613_640	613	640	7.4553769010995757e-10
R613_642	613	642	9.2095658565715701e+02
C613_642	613	642	9.6141207467255490e-10
R613_663	613	663	2.1971154335567353e+03
C613_663	613	663	4.0299147153441373e-10
R613_664	613	664	9.3821620087629674e+02
C613_664	613	664	9.4372574346191863e-10
R613_665	613	665	1.4009893881043406e+03
C613_665	613	665	6.3199535215469978e-10
R613_666	613	666	1.8720995182871118e+03
C613_666	613	666	4.7295497544389039e-10
R614_615	614	615	3.7508233425897470e+03
C614_615	614	615	2.3605984628661957e-10
R614_616	614	616	2.1061167067425681e+03
C614_616	614	616	4.2040347472929732e-10
R614_645	614	645	2.8799770416473334e+03
C614_645	614	645	3.0743952777954950e-10
R614_655	614	655	4.8466808566159389e+03
C614_655	614	655	1.8268559616244657e-10
R614_665	614	665	1.1812759427453848e+03
C614_665	614	665	7.4954441181813314e-10
R614_667	614	667	5.1319542314879518e+03
C614_667	614	667	1.7253052965035562e-10
R615_645	615	645	1.1226081512876433e+03
C615_645	615	645	7.8871579605440736e-10
R615_655	615	655	2.1457601495376566e+03
C615_655	615	655	4.1263641786374859e-10
R615_656	615	656	1.9106575535604379e+03
C615_656	615	656	4.6341050495943437e-10
R615_659	615	659	2.9761495871423044e+03
C615_659	615	659	2.9750479798637349e-10
R615_668	615	668	5.0669527318993214e+03
C615_668	615	668	1.7474384083470718e-10
R616_634	616	634	3.0088873473030576e+03
C616_634	616	634	2.9426784040074590e-10
R616_635	616	635	1.7252216084438849e+03
C616_635	616	635	5.1322031753278926e-10
R616_654	616	654	5.2072590706406418e+03
C616_654	616	654	1.7003547733818975e-10
R616_655	616	655	1.3197245383662196e+03
C616_655	616	655	6.7091181224539667e-10
R616_658	616	658	3.0108488036456547e+03
C616_658	616	658	2.9407613581522256e-10
R616_665	616	665	1.2782571685836494e+03
C616_665	616	665	6.9267656263650969e-10
R616_667	616	667	1.1973093351288051e+03
C616_667	616	667	7.3950712294809554e-10
R616_669	616	669	7.6080290332954610e+02
C616_669	616	669	1.1637952192678154e-09
R616_670	616	670	2.1526274446222501e+03
C616_670	616	670	4.1132002842014124e-10
R617_618	617	618	3.4577649255037706e-06
C617_618	617	618	2.5606679481572945e-11
R617_619	617	619	9.3889133000217922e-07
C617_619	617	619	9.4304713805158376e-11
R617_637	617	637	3.3201238756105190e-06
C617_637	617	637	2.9335069876479936e-10
R617_642	617	642	3.5220677739772041e+03
C617_642	617	642	2.5139175010825068e-10
R617_648	617	648	3.3697508551937279e-06
C617_648	617	648	2.6275496906108716e-11
R617_663	617	663	2.4861582311068094e-06
C617_663	617	663	3.0271844907694945e-10
R617_666	617	666	2.6146031670163609e-06
C617_666	617	666	3.7250802384954995e-10
R617_671	617	671	2.2556433349903233e-06
C617_671	617	671	3.9253492250528987e-11
R618_619	618	619	3.0291170628645011e-06
C618_619	618	619	2.9230259621022996e-11
R618_636	618	636	5.1019179158897455e-06
C618_636	618	636	1.7354626167982713e-11
R618_635	618	635	1.6453798807632428e-06
C618_635	618	635	5.3812423018645429e-11
R618_666	618	666	3.1479031101087116e-06
C618_666	618	666	2.8127256485649031e-11
R618_671	618	671	2.2821122468701107e-06
C618_671	618	671	3.8798213493413436e-11
R618_672	618	672	2.6664096009168540e-06
C618_672	618	672	3.3206405399813510e-11
R618_673	618	673	4.3929261041357986e-06
C618_673	618	673	2.0155558293284440e-11
R619_648	619	648	2.9378687873492887e-06
C619_648	619	648	3.0138132292112164e-11
R619_663	619	663	2.8825922667026907e-06
C619_663	619	663	3.0716060399093609e-11
R619_671	619	671	1.2487229056931876e-06
C619_671	619	671	7.0905945399350918e-11
R619_672	619	672	2.5367448486662450e-06
C619_672	619	672	3.4903738236249119e-11
R619_674	619	674	2.6331451688913093e-06
C619_674	619	674	3.3625900772983483e-11
R620_622	620	622	1.5908354340567828e+03
C620_622	620	622	5.5657471712337789e-10
R620_629	620	629	3.7399613498932140e+03
C620_629	620	629	2.3674543634662989e-10
R620_644	620	644	1.8381185653787068e+03
C620_644	620	644	4.8169840530258590e-10
R620_646	620	646	4.4214325173390507e+03
C620_646	620	646	2.0025608854771602e-10
R620_675	620	675	4.1913576440544148e+03
C620_675	620	675	2.1124868285959733e-10
R621_622	621	622	1.7237890851053492e+03
C621_622	621	622	5.1364681987523302e-10
R621_623	621	623	2.9391997913475830e+03
C621_623	621	623	3.0124484368381364e-10
R621_625	621	625	3.3499465051130483e+03
C621_625	621	625	2.6430833458044150e-10
R621_632	621	632	4.2642562573774503e+03
C621_632	621	632	2.0763732952684686e-10
R621_633	621	633	3.0907881248458475e+03
C621_633	621	633	2.8647022893041575e-10
R621_676	621	676	4.8324470118802437e+03
C621_676	621	676	1.8322369174938870e-10
R622_625	622	625	2.6672446410047855e+03
C622_625	622	625	3.3196009398164975e-10
R622_629	622	629	2.0854907291573231e+03
C622_629	622	629	4.2456136070083052e-10
R622_633	622	633	1.8195916463004421e+03
C622_633	622	633	4.8660301529753464e-10
R622_644	622	644	4.7494224411825917e+03
C622_644	622	644	1.8642662190300627e-10
R622_675	622	675	1.4994486184283921e+03
C622_675	622	675	5.9049624696578728e-10
R622_676	622	676	1.9363239105580160e+03
C622_676	622	676	4.5726790691999331e-10
R623_625	623	625	2.1297439302250900e+03
C623_625	623	625	4.1573954931118004e-10
R623_627	623	627	6.0864662058187359e+03
C623_627	623	627	1.4547337515051490e-10
R623_676	623	676	9.9764613182480916e+03
C623_676	623	676	8.8750785820265523e-11
R624_626	624	626	2.6578367898236424e+03
C624_626	624	626	3.3313512142284363e-10
R624_627	624	627	9.1889349246236652e+03
C624_627	624	627	9.6357063028853968e-11
R624_647	624	647	4.1900867193456970e+03
C624_647	624	647	2.1131275818517247e-10
R624_651	624	651	9.4623418090874929e+03
C624_651	624	651	9.3572901884569092e-11
R624_677	624	677	4.6399684196448770e+03
C624_677	624	677	1.9082431206886664e-10
R625_626	625	626	3.3125794659076205e+03
C625_626	625	626	2.6728982378009229e-10
R625_627	625	627	2.7467433718447123e+03
C625_627	625	627	3.2235220471483396e-10
R625_628	625	628	4.1935128566476069e+03
C625_628	625	628	2.1114011378227294e-10
R625_629	625	629	1.3654160154068884e+03
C625_629	625	629	6.4846081465958857e-10
R625_676	625	676	1.5882546350257705e+03
C625_676	625	676	5.5747911082635301e-10
R625_678	625	678	2.1869262761512941e+03
C625_678	625	678	4.0486905816423865e-10
R626_627	626	627	2.9431706784708331e+03
C626_627	626	627	3.0083840810755569e-10
R626_628	626	628	2.5468199377423402e+03
C626_628	626	628	3.4765660837604812e-10
R626_647	626	647	1.0544866913357976e+03
C626_647	626	647	8.3966804794698100e-10
R626_677	626	677	5.4766286110917499e+03
C626_677	626	677	1.6167223388249698e-10
R626_678	626	678	2.7923808278684078e+03
C626_678	626	678	3.1708382068211434e-10
R627_676	627	676	1.1082130066504507e+04
C627_676	627	676	7.9896082827628844e-11
R627_677	627	677	1.0795984737929657e+04
C627_677	627	677	8.2013711874679494e-11
R627_678	627	678	7.9922434572062475e+03
C627_678	627	678	1.1078476105500237e-10
R628_629	628	629	4.5388328797156119e+03
C628_629	628	629	1.9507631260384216e-10
R628_630	628	630	4.6712636632600615e+03
C628_630	628	630	1.8954587998615965e-10
R628_638	628	638	2.0651458293397454e+03
C628_638	628	638	4.2874395072772169e-10
R628_647	628	647	5.4837601563115704e+03
C628_647	628	647	1.6146198164427767e-10
R628_678	628	678	4.6322296162093089e+03
C628_678	628	678	1.9114311142990455e-10
R628_679	628	679	8.0072323374147491e+03
C628_679	628	679	1.1057738109618412e-10
R629_630	629	630	1.2751139404321198e+03
C629_630	629	630	6.9438404963241405e-10
R629_646	629	646	1.4277756569317798e+03
C629_646	629	646	6.2013858928140134e-10
R629_675	629	675	9.5719990458579286e+02
C629_675	629	675	9.2500926656814215e-10
R629_676	629	676	3.4939877353651705e+03
C629_676	629	676	2.5341210352229858e-10
R629_678	629	678	1.4817341669549703e+03
C629_678	629	678	5.9755575692742178e-10
R629_679	629	679	1.1542266674696143e+03
C629_679	629	679	7.6710996778568995e-10
R630_638	630	638	3.1387781260270617e+03
C630_638	630	638	2.8209027403307652e-10
R630_640	630	640	9.2739662823560502e+02
C630_640	630	640	9.5473582148398719e-10
R630_646	630	646	7.7355743231988208e+02
C630_646	630	646	1.1446063921131858e-09
R630_679	630	679	1.0499642566015114e+03
C630_679	630	679	8.4328468910541163e-10
R631_632	631	632	2.5146638559404596e+03
C631_632	631	632	3.5210224205845685e-10
R631_633	631	633	3.8965375618203384e+03
C631_633	631	633	2.2723219464779408e-10
R631_644	631	644	1.7348374602012429e+03
C631_644	631	644	5.1037564152972037e-10
R631_657	631	657	5.1725306473427427e+03
C631_657	631	657	1.7117709725989960e-10
R631_659	631	659	2.5146638559404373e+03
C631_659	631	659	3.5210224205845995e-10
R631_660	631	660	2.2757062280400869e+03
C631_660	631	660	3.8907428858361565e-10
R631_661	631	661	3.0675610408567154e+03
C631_661	631	661	2.8863933591121573e-10
R631_682	631	682	2.0456720275911882e+03
C631_682	631	682	4.3282538440074147e-10
R631_683	631	683	5.1489187467415650e+03
C631_683	631	683	1.7196208082722751e-10
R631_684	631	684	2.3852280180660687e+03
C631_684	631	684	3.7120928271582751e-10
R632_633	632	633	6.7871286370233147e+03
C632_633	632	633	1.3045557687975770e-10
R632_661	632	661	9.0736553557770931e+03
C632_661	632	661	9.7581266532926446e-11
R632_684	632	684	1.6120066614456331e+04
C632_684	632	684	5.4926496451693591e-11
R633_644	633	644	9.9862784282688899e+03
C633_644	633	644	8.8663538480319168e-11
R633_675	633	675	7.5367366968525157e+03
C633_675	633	675	1.1748039202029809e-10
R633_676	633	676	1.0105522356390449e+04
C633_676	633	676	8.7617319567858470e-11
R633_680	633	680	5.3669275034102457e+03
C633_680	633	680	1.6497684776576331e-10
R633_683	633	683	8.1779928445386804e+03
C633_683	633	683	1.0826847107004850e-10
R633_684	633	684	9.5283611797932444e+03
C633_684	633	684	9.2924561211817203e-11
R634_635	634	635	5.5212120856906134e-06
C634_635	634	635	1.7640341355845830e-10
R634_636	634	636	9.6381735127335737e-07
C634_636	634	636	9.1865827122765510e-11
R634_654	634	654	6.9567364428667363e-06
C634_654	634	654	1.4000252372572119e-10
R634_662	634	662	8.6374609268532500e-06
C634_662	634	662	1.0250915045500191e-11
R634_669	634	669	1.4617143719964363e-05
C634_669	634	669	6.6631393763050039e-11
R634_685	634	685	5.4676108082088921e-06
C634_685	634	685	1.6193888203795731e-11
R635_636	635	636	4.1061439582485982e-06
C635_636	635	636	2.1563266916673311e-11
R635_665	635	665	2.8427951416319470e+03
C635_665	635	665	3.1146063560236452e-10
R635_666	635	666	3.2844556782303578e-06
C635_666	635	666	2.9653639881686654e-10
R635_669	635	669	6.6660726430065183e-06
C635_669	635	669	1.4610711749711232e-10
R635_670	635	670	9.2067834382640889e-07
C635_670	635	670	6.7319183835933053e-10
R635_671	635	671	3.2983492231276985e-06
C635_671	635	671	2.6844300642622412e-11
R635_672	635	672	3.6992531630609342e-06
C635_672	635	672	2.3935068584691385e-11
R635_673	635	673	1.3122314975848901e-06
C635_673	635	673	6.7474282040141399e-11
R635_685	635	685	2.9556301652556398e-06
C635_685	635	685	2.9957022096620065e-11
R636_662	636	662	1.1802258365426533e-05
C636_662	636	662	7.5021131912663477e-12
R636_673	636	673	8.5581888508470275e-06
C636_673	636	673	1.0345866364147453e-11
R636_685	636	685	6.9126926294852128e-06
C636_685	636	685	1.2808594699023050e-11
R636_686	636	686	1.7690289308270481e-05
C636_686	636	686	5.0051119361063996e-12
R637_639	637	639	3.7341818313180142e+03
C637_639	637	639	2.3711185520590553e-10
R637_641	637	641	4.0353901916015789e-06
C637_641	637	641	3.1449257489873170e-10
R637_642	637	642	1.2945279247292563e+03
C637_642	637	642	6.8397039939109931e-10
R637_648	637	648	6.2082885463100525e-07
C637_648	637	648	1.4261881919555043e-10
R637_663	637	663	6.1623399609224167e-06
C637_663	637	663	1.5805045892830795e-10
R637_687	637	687	7.7641139644175984e-06
C637_687	637	687	1.2544389010254542e-10
R638_639	638	639	2.4909056481584025e+03
C638_639	638	639	3.5546058613445086e-10
R638_640	638	640	1.9507488198985429e+03
C638_640	638	640	4.5388661659990130e-10
R638_643	638	643	1.5969584710316867e+03
C638_643	638	643	5.5444070572980567e-10
R638_647	638	647	1.3194073884013803e+03
C638_647	638	647	6.7107308135722245e-10
R638_650	638	650	4.8831133283718964e+03
C638_650	638	650	1.8132259527042595e-10
R638_678	638	678	4.0637158621277827e+03
C638_678	638	678	2.1788402824905925e-10
R638_679	638	679	1.8652920173439509e+03
C638_679	638	679	4.7468105447680847e-10
R638_688	638	688	3.4000362959817139e+03
C638_688	638	688	2.6041450873522147e-10
R638_689	638	689	2.9114371281751119e+03
C638_689	638	689	3.0411743160498201e-10
R638_690	638	690	1.1749655531451463e+03
C638_690	638	690	7.5356999133286266e-10
R638_691	638	691	1.1375990574595216e+03
C638_691	638	691	7.7832235873798194e-10
R639_640	639	640	1.7365323580516476e+03
C639_640	639	640	5.0987750248053033e-10
R639_641	639	641	4.5420646594798664e+03
C639_641	639	641	1.9493751147994306e-10
R639_642	639	642	1.0485117742672799e+03
C639_642	639	642	8.4445287447415425e-10
R639_643	639	643	2.3530320797277423e+03
C639_643	639	643	3.7628844473826615e-10
R639_691	639	691	2.0459827456755436e+03
C639_691	639	691	4.3275965233404360e-10
R640_642	640	642	1.7940049083134754e+03
C640_642	640	642	4.9354312109010491e-10
R640_646	640	646	1.9193816655209903e+03
C640_646	640	646	4.6130417811387451e-10
R640_664	640	664	1.7159198516315912e+03
C640_664	640	664	5.1600241168496015e-10
R640_679	640	679	1.8126824844477308e+03
C640_679	640	679	4.8845773559165844e-10
R640_688	640	688	1.0491476679017703e+03
C640_688	640	688	8.4394104737494409e-10
R640_691	640	691	2.9617899198470946e+03
C640_691	640	691	2.9894719263063430e-10
R641_642	641	642	6.7843595059722147e+03
C641_642	641	642	1.3050882414479558e-10
R641_643	641	643	4.6463437100426363e+03
C641_643	641	643	1.9056248029741113e-10
R641_648	641	648	5.0668817061681132e-06
C641_648	641	648	1.7474629033121991e-11
R641_649	641	649	1.4871412040214595e-06
C641_649	641	649	5.9538312791394030e-11
R641_687	641	687	5.8663705600684904e-06
C641_687	641	687	2.1633482561030878e-10
R641_652	641	652	1.7845694412566124e-05
C641_652	641	652	1.0419204738493959e-10
R641_689	641	689	7.1205611588202919e+03
C641_689	641	689	1.2434677014229773e-10
R641_691	641	691	5.0522406305278273e+03
C641_691	641	691	1.7525269409178893e-10
R642_663	642	663	2.0586874276700587e+03
C642_663	642	663	4.3008898281468698e-10
R642_664	642	664	6.4650633839254951e+03
C642_664	642	664	1.3695438530447729e-10
R642_687	642	687	4.2948409006076181e+03
C642_687	642	687	2.0615869183296973e-10
R642_688	642	688	4.8459467713862168e+03
C642_688	642	688	1.8271327017624670e-10
R642_691	642	691	4.0101623054072002e+03
C642_691	642	691	2.2079375203994214e-10
R643_650	643	650	8.1968623254448648e+03
C643_650	643	650	1.0801923303645902e-10
R643_689	643	689	5.1927225219692045e+03
C643_689	643	689	1.7051147600396490e-10
R643_652	643	652	1.7677529982596792e+04
C643_652	643	652	5.0087245365821974e-11
R643_691	643	691	5.4078527235345209e+03
C643_691	643	691	1.6372834597486945e-10
R644_645	644	645	2.3749204987831968e+03
C644_645	644	645	3.7282038794715412e-10
R644_646	644	646	3.2067089824928466e+03
C644_646	644	646	2.7611447952838214e-10
R644_659	644	659	2.0263556032437211e+03
C644_659	644	659	4.3695133286707031e-10
R644_668	644	668	6.2904365435822865e+03
C644_668	644	668	1.4075633313610547e-10
R644_675	644	675	1.7820368832483289e+03
C644_675	644	675	4.9685771940143180e-10
R644_681	644	681	3.3706220538381403e+03
C644_681	644	681	2.6268705525491071e-10
R644_682	644	682	3.7792394491200444e+03
C644_682	644	682	2.3428491198306067e-10
R644_683	644	683	1.5903968285470391e+03
C644_683	644	683	5.5672821135395786e-10
R644_692	644	692	2.4118241811548942e+03
C644_692	644	692	3.6711580745326978e-10
R645_646	645	646	1.9588040146612459e+03
C645_646	645	646	4.5202009750481525e-10
R645_655	645	655	2.4951589710990261e+03
C645_655	645	655	3.5485465734073267e-10
R645_659	645	659	4.8476279244310872e+03
C645_659	645	659	1.8264990537695032e-10
R645_664	645	664	2.4681621490954353e+03
C645_664	645	664	3.5873606684410911e-10
R645_665	645	665	4.7245863485971231e+03
C645_665	645	665	1.8740662491286848e-10
R645_667	645	667	1.8960484199853820e+03
C645_667	645	667	4.6698110257480988e-10
R645_668	645	668	9.0906770430973404e+02
C645_668	645	668	9.7398552110297314e-10
R645_681	645	681	4.1402562110720310e+03
C645_681	645	681	2.1385603609075672e-10
R645_692	645	692	3.4510091560364549e+03
C645_692	645	692	2.5656807665990637e-10
R645_693	645	693	1.9253372294410567e+03
C645_693	645	693	4.5987724548236427e-10
R645_694	645	694	4.6554009962084183e+03
C645_694	645	694	1.9019173266086583e-10
R646_664	646	664	6.5657994603219122e+03
C646_664	646	664	1.3485315642835508e-10
R646_675	646	675	3.6846433227587295e+03
C646_675	646	675	2.4029972622616788e-10
R646_679	646	679	1.7063335318572988e+03
C646_679	646	679	5.1890135496326168e-10
R646_681	646	681	2.9990157334078995e+03
C646_681	646	681	2.9523645769402617e-10
R646_688	646	688	6.2991540331469123e+03
C646_688	646	688	1.4056153842894128e-10
R646_694	646	694	7.9135046365115386e+03
C646_694	646	694	1.1188706172165885e-10
R647_650	647	650	7.9338883737609185e+03
C647_650	647	650	1.1159960160622766e-10
R647_651	647	651	8.2284440986395912e+03
C647_651	647	651	1.0760464203024559e-10
R647_677	647	677	2.4458326023309905e+03
C647_677	647	677	3.6201119441132453e-10
R647_678	647	678	2.7508941159882215e+03
C647_678	647	678	3.2186581684621669e-10
R647_689	647	689	1.3126353350118763e+04
C647_689	647	689	6.7453523311711622e-11
R647_690	647	690	5.3651559411643502e+03
C647_690	647	690	1.6503132274433868e-10
R647_695	647	695	8.2047673984370122e+03
C647_695	647	695	1.0791515940703816e-10
R648_649	648	649	4.0714749249406834e-06
C648_649	648	649	2.1746880381755011e-11
R648_663	648	663	2.2417931312713657e-06
C648_663	648	663	3.9496007430349355e-11
R648_674	648	674	5.5017647560420502e-06
C648_674	648	674	1.6093359512102573e-11
R648_687	648	687	3.4176763911645704e-06
C648_687	648	687	2.5907039765057876e-11
R648_698	648	698	4.6001552971568904e-06
C648_698	648	698	1.9247584581486415e-11
R649_652	649	652	9.7654746908889867e-06
C649_652	649	652	9.0668278780762193e-12
R649_653	649	653	7.8123797527111877e-06
C649_653	649	653	1.1333534847595276e-11
R649_687	649	687	3.8630108777066716e-06
C649_687	649	687	2.2920432008352017e-11
R649_698	649	698	8.1398384499033407e-06
C649_698	649	698	1.0877596492231544e-11
R650_651	650	651	5.4285884250303798e+03
C650_651	650	651	1.6310294912347222e-10
R650_689	650	689	2.3324098819635606e+03
C650_689	650	689	3.7961543060973581e-10
R650_652	650	652	1.1232888879189893e+04
C650_652	650	652	7.8823781773567752e-11
R650_695	650	695	6.9780301320525177e+03
C650_695	650	695	1.2688663776800903e-10
R650_700	650	700	1.1213554453529609e+04
C650_700	650	700	7.8959689844044343e-11
R651_677	651	677	1.6571245541437129e+04
C651_677	651	677	5.3431033864411183e-11
R651_695	651	695	6.5218655095513504e+03
C651_695	651	695	1.3576158238824361e-10
R651_700	651	700	4.1566379549849029e+04
C651_700	651	700	2.1301320713730907e-11
R652_653	652	653	2.3814760338166039e-06
C652_653	652	653	3.7179411807097168e-11
R652_687	652	687	7.0815937556074577e-06
C652_687	652	687	7.5018602745139208e-11
R652_689	652	689	2.3259201852765268e+03
C652_689	652	689	3.8067461957845878e-10
R652_696	652	696	8.5187719681172078e-06
C652_696	652	696	1.1433111046301443e-10
R652_699	652	699	4.8986241642476970e-06
C652_699	652	699	1.8074846161135896e-11
R652_700	652	700	1.4288856188610769e-05
C652_700	652	700	6.8162254979678153e-11
R652_701	652	701	1.7861070253624533e-05
C652_701	652	701	4.9572549076129561e-12
R653_687	653	687	8.0643781765606552e-06
C653_687	653	687	1.0979380707535452e-11
R653_698	653	698	1.3510799305843016e-05
C653_698	653	698	6.5534152469949197e-12
R653_699	653	699	5.2590264512042869e-06
C653_699	653	699	1.6836172814784837e-11
R653_701	653	701	2.5988865193095291e-05
C653_701	653	701	3.4069159046437995e-12
R654_658	654	658	4.9190958770957068e+03
C654_658	654	658	1.7999624398920274e-10
R654_662	654	662	2.0463588620914491e-06
C654_662	654	662	4.3268011202838178e-11
R654_669	654	669	1.3347626040393748e-05
C654_669	654	669	1.0613648032299863e-10
R654_685	654	685	6.0252110120132866e-06
C654_685	654	685	1.4695232746780485e-11
R654_702	654	702	1.2278153166409618e-05
C654_702	654	702	4.3268011202838185e-11
R655_656	655	656	4.8868657552827117e+03
C655_656	655	656	1.8118336497024919e-10
R655_658	655	658	3.2028732041594717e+03
C655_658	655	658	2.7644515572771792e-10
R655_659	655	659	8.2430403347402389e+03
C655_659	655	659	1.0741410277569653e-10
R655_667	655	667	2.1920569775542240e+03
C655_667	655	667	4.0392142666286953e-10
R655_668	655	668	2.1132409285839426e+03
C655_668	655	668	4.1898619779870943e-10
R655_669	655	669	7.3279872132781420e+03
C655_669	655	669	1.2082700964538279e-10
R655_702	655	702	8.1349936536985188e+03
C655_702	655	702	1.0884074645804432e-10
R655_703	655	703	5.4278882661687740e+03
C655_703	655	703	1.6312398824026733e-10
R656_657	656	657	3.2580123531316226e+03
C656_657	656	657	2.7176655142173717e-10
R656_658	656	658	3.9657703686094242e+03
C656_658	656	658	2.2326526737615101e-10
R656_659	656	659	5.1061150417969202e+03
C656_659	656	659	1.7340361007385520e-10
R656_703	656	703	6.2068034745680898e+03
C656_703	656	703	1.4265294290820339e-10
R657_659	657	659	2.3758161901701092e+03
C657_659	657	659	3.7267983329830056e-10
R657_660	657	660	5.6411433081140904e+03
C657_660	657	660	1.5695732821154074e-10
R657_703	657	703	1.0186029494970448e+04
C657_703	657	703	8.6924820131062166e-11
R658_669	658	669	4.1341473861951017e+03
C658_669	658	669	2.1417204056551623e-10
R658_702	658	702	3.3931351465441621e+03
C658_702	658	702	2.6094415443539896e-10
R658_703	658	703	6.4544273332685707e+03
C658_703	658	703	1.3718006818919709e-10
R659_660	659	660	1.1313984718763893e+03
C659_660	659	660	7.8258792433364402e-10
R659_668	659	668	6.9829105555961723e+02
C659_668	659	668	1.2679795547293912e-09
R659_682	659	682	1.2563467800809940e+03
C659_682	659	682	7.0475667684914099e-10
R659_692	659	692	2.1734067169228942e+03
C659_692	659	692	4.0738752429806354e-10
R659_703	659	703	1.0661252611663351e+03
C659_703	659	703	8.3050164361677055e-10
R659_704	659	704	9.3874701707078827e+02
C659_704	659	704	9.4319211203760664e-10
R660_661	660	661	6.3163349740546628e+03
C660_661	660	661	1.4017919969998372e-10
R660_682	660	682	2.3443085062576838e+03
C660_682	660	682	3.7768867848943257e-10
R660_703	660	703	8.0337930606155051e+03
C660_703	660	703	1.1021179846424427e-10
R660_704	660	704	5.1102606556065693e+03
C660_704	660	704	1.7326293928443541e-10
R660_705	660	705	6.0001048549775014e+03
C660_705	660	705	1.4756721809044457e-10
R660_706	660	706	9.4739650788735507e+03
C660_706	660	706	9.3458100629317066e-11
R661_682	661	682	4.8121309894094911e+03
C661_682	661	682	1.8399723192253587e-10
R661_684	661	684	4.2813479467212273e+03
C661_684	661	684	2.0680841471389353e-10
R661_706	661	706	6.6336354263051553e+03
C661_706	661	706	1.3347413971363906e-10
R662_685	662	685	1.9494289109120592e-06
C662_685	662	685	4.5419393174268054e-11
R662_686	662	686	2.4336846891354337e-06
C662_686	662	686	3.6381819947864536e-11
R662_702	662	702	4.0637442240590620e-06
C662_702	662	702	2.1788250757957442e-11
R662_707	662	707	9.7529861377417464e-06
C662_707	662	707	9.0784378158156002e-12
R663_664	663	664	1.3336737977584385e+03
C663_664	663	664	6.6389456191473557e-10
R663_666	663	666	2.8884575726857064e-06
C663_666	663	666	4.9045901244717467e-10
R663_671	663	671	1.1139142733657775e-06
C663_671	663	671	7.9487156495862040e-11
R663_674	663	674	5.2901402623692188e-07
C663_674	663	674	1.6737151337901584e-10
R663_687	663	687	3.3990860180032099e-06
C663_687	663	687	2.8653604343563860e-10
R663_688	663	688	3.3854036130504269e+03
C663_688	663	688	2.6154009474285138e-10
R663_697	663	697	1.9066829666832002e-06
C663_697	663	697	5.1081416046334526e-10
R663_698	663	698	3.2240756994926511e-06
C663_698	663	698	2.7462716890900906e-11
R663_708	663	708	3.2564417289976121e-06
C663_708	663	708	2.0845484796265806e-10
R664_665	664	665	1.4456255294921621e+03
C664_665	664	665	6.1248142318781641e-10
R664_666	664	666	4.0220116516466419e+03
C664_666	664	666	2.2014326620299647e-10
R664_667	664	667	3.6765305572239813e+03
C664_667	664	667	2.4082998030854085e-10
R664_688	664	688	1.7471936707356142e+03
C664_688	664	688	5.0676624837315012e-10
R664_693	664	693	3.2332010018527667e+03
C664_693	664	693	2.7385206833494613e-10
R664_694	664	694	1.3229437992525980e+03
C664_694	664	694	6.6927921065144328e-10
R664_697	664	697	3.0703486570728942e+03
C664_697	664	697	2.8837727587071854e-10
R664_708	664	708	1.4909693585247478e+03
C664_708	664	708	5.9385444552400819e-10
R665_666	665	666	9.3124576175808488e+02
C665_666	665	666	9.5078959610879853e-10
R665_667	665	667	9.5295810547792951e+02
C665_667	665	667	9.2912666003920804e-10
R665_670	665	670	8.7082817491481126e+02
C665_670	665	670	1.0167548630206138e-09
R665_708	665	708	2.0794555762611949e+03
C665_708	665	708	4.2579355472068287e-10
R666_670	666	670	2.6507191556472611e-06
C666_670	666	670	3.6743261043745492e-10
R666_671	666	671	2.7440413407815725e-07
C666_671	666	671	3.2266962182421433e-10
R666_708	666	708	7.4885001393703992e-06
C666_708	666	708	1.8917941139466981e-10
R667_668	667	668	2.6108212191622465e+03
C667_668	667	668	3.3913420620356026e-10
R667_669	667	669	1.9703802527634277e+03
C667_669	667	669	4.4936442113557219e-10
R667_670	667	670	3.6744133030301400e+03
C667_670	667	670	2.4096875029540932e-10
R667_693	667	693	2.6437815667358977e+03
C667_693	667	693	3.3490617864968625e-10
R667_702	667	702	9.6351365028811324e+03
C667_702	667	702	9.1894783372839519e-11
R667_708	667	708	1.8464690260319630e+03
C667_708	667	708	4.7951997527017994e-10
R667_709	667	709	3.1202302459476723e+03
C667_709	667	709	2.8376712995777075e-10
R668_692	668	692	6.3510374446726848e+02
C668_692	668	692	1.3941325167948715e-09
R668_693	668	693	1.4111896768230470e+03
C668_693	668	693	6.2742719582055530e-10
R668_702	668	702	5.0393400156088364e+03
C668_702	668	702	1.7570133766673943e-10
R668_703	668	703	1.6689155415934536e+03
C668_703	668	703	5.3053540435881882e-10
R668_704	668	704	1.1404569341900053e+03
C668_704	668	704	7.7637195684978409e-10
R668_709	668	709	1.5511553062399544e+03
C668_709	668	709	5.7081246354775450e-10
R669_670	669	670	1.4211025759177256e-06
C669_670	669	670	6.8535563540659349e-10
R669_685	669	685	9.1788788976521628e-08
C669_685	669	685	9.6462628124059740e-10
R669_702	669	702	5.1257829624046233e-06
C669_702	669	702	3.6275032546032023e-10
R669_708	669	708	4.4100876629202901e-06
C669_708	669	708	2.2084836704835433e-10
R669_709	669	709	3.1434702210666974e-06
C669_709	669	709	2.1594639610968007e-10
R669_710	669	710	2.2916633282495702e-06
C669_710	669	710	3.8636512213000550e-11
R670_671	670	671	6.5360034765587790e-07
C670_671	670	671	1.3546791779954423e-10
R670_672	670	672	1.2766410843250550e-06
C670_672	670	672	6.9355341338408402e-11
R670_673	670	673	9.1343501072243362e-07
C670_673	670	673	9.6932871119065649e-11
R670_685	670	685	1.4391126320768058e-06
C670_685	670	685	6.1525329009324204e-11
R670_708	670	708	1.4164354707767064e-06
C670_708	670	708	6.8761385816041825e-10
R670_710	670	710	9.3127339706022948e-07
C670_710	670	710	9.5076138166839101e-11
R671_672	671	672	2.8410891354242703e-07
C671_672	671	672	3.1164766027933070e-10
R671_674	671	674	1.8550645253670806e-06
C671_674	671	674	4.7729810450921827e-11
R671_708	671	708	2.7432497428698479e-06
C671_708	671	708	3.2276273204849383e-11
R671_710	671	710	3.1403194164102311e-06
C671_710	671	710	2.8195182218506358e-11
R672_673	672	673	1.7739971902155181e-06
C672_673	672	673	4.9910946115559124e-11
R672_674	672	674	4.2586348785914652e-06
C672_674	672	674	2.0791140986307104e-11
R672_710	672	710	3.4408304901127435e-06
C672_710	672	710	2.5732705643136408e-11
R673_685	673	685	3.2755930318114608e-06
C673_685	673	685	2.7030793297613893e-11
R673_686	673	686	1.0207425827271150e-05
C673_686	673	686	8.6742612357214394e-12
R673_710	673	710	6.6991035876931122e-06
C673_710	673	710	1.3216974034057306e-11
R674_698	674	698	6.7888154083478240e-06
C674_698	674	698	1.3042316345960013e-11
R674_697	674	697	4.2090826584419137e-06
C674_697	674	697	2.1035908618334374e-11
R674_708	674	708	4.7375322194480822e-06
C674_708	674	708	1.8689451399723685e-11
R674_710	674	710	6.6926005360609461e-06
C674_710	674	710	1.3229816674836679e-11
R674_711	674	711	3.4650533126886549e-06
C674_711	674	711	2.5552818435944148e-11
R675_676	675	676	1.4805071674931205e+03
C675_676	675	676	5.9805099302507383e-10
R675_678	675	678	1.8750451381186647e+03
C675_678	675	678	4.7221198236773595e-10
R675_679	675	679	1.5173368521112398e+03
C675_679	675	679	5.8353475068375123e-10
R675_680	675	680	1.4606237292153837e+03
C675_680	675	680	6.0619224786634711e-10
R675_681	675	681	6.4049693210470434e+02
C675_681	675	681	1.3823934781240410e-09
R675_683	675	683	1.1246179539131363e+03
C675_683	675	683	7.8730628354203600e-10
R675_712	675	712	2.5928092335958941e+03
C675_712	675	712	3.4149013750311192e-10
R676_678	676	678	1.1050704117915761e+03
C676_678	676	678	8.0123290991433787e-10
R676_677	676	677	6.9675845567579081e+03
C676_677	676	677	1.2707686207284367e-10
R676_680	676	680	3.8739717587450723e+03
C676_680	676	680	2.2855581734721296e-10
R676_712	676	712	4.4038592154267944e+03
C676_712	676	712	2.0105519690510609e-10
R677_678	677	678	1.0783267776859420e+03
C677_678	677	678	8.2110432572219260e-10
R677_690	677	690	3.6543633863321925e+03
C677_690	677	690	2.4229084195939154e-10
R677_695	677	695	2.3025670838319115e+03
C677_695	677	695	3.8453549862551416e-10
R677_712	677	712	3.9253265287171748e+03
C677_712	677	712	2.2556563771762479e-10
R678_679	678	679	1.8195725177302481e+03
C678_679	678	679	4.8660813079573201e-10
R678_681	678	681	6.1509532188577878e+03
C678_681	678	681	1.4394822236421096e-10
R678_690	678	690	2.4067094411121666e+03
C678_690	678	690	3.6789600214093079e-10
R678_712	678	712	2.8276920597924122e+03
C678_712	678	712	3.1312418855290801e-10
R678_713	678	713	5.3140474691192530e+03
C678_713	678	713	1.6661853076121449e-10
R679_681	679	681	9.3183361087553931e+02
C679_681	679	681	9.5018978856973369e-10
R679_688	679	688	7.1842142122351345e+02
C679_688	679	688	1.2324504191315458e-09
R679_690	679	690	1.4520740060768032e+03
C679_690	679	690	6.0976147083041190e-10
R679_713	679	713	1.6853309399022025e+03
C679_713	679	713	5.2536790296591820e-10
R680_683	680	683	1.5321804382537359e+03
C680_683	680	683	5.7788153378927992e-10
R680_684	680	684	6.6289301397097033e+03
C680_684	680	684	1.3356888110737803e-10
R680_712	680	712	5.9696965865006559e+03
C680_712	680	712	1.4831889173433165e-10
R680_716	680	716	6.4330293794350991e+03
C680_716	680	716	1.3763636530721875e-10
R681_683	681	683	6.8626726441756944e+02
C681_683	681	683	1.2901952746521417e-09
R681_688	681	688	1.3358921987886367e+03
C681_688	681	688	6.6279208943871530e-10
R681_692	681	692	9.2498146086849476e+02
C681_692	681	692	9.5722867879822354e-10
R681_693	681	693	1.4310472839358229e+03
C681_693	681	693	6.1872084286748687e-10
R681_694	681	694	4.4251046626074918e+02
C681_694	681	694	2.0008990729233222e-09
R681_712	681	712	1.6881125332491790e+03
C681_712	681	712	5.2450222616130831e-10
R681_713	681	713	3.3760641244623866e+02
C681_713	681	713	2.6226361498420780e-09
R681_714	681	714	4.2485638177871652e+02
C681_714	681	714	2.0840425604367270e-09
R681_716	681	716	1.7232033489539581e+03
C681_716	681	716	5.1382141419205039e-10
R681_717	681	717	1.9403852084929470e+03
C681_717	681	717	4.5631082829562725e-10
R682_683	682	683	1.0913801202300126e+03
C682_683	682	683	8.1128358972984993e-10
R682_684	682	684	1.1576344427163444e+03
C682_684	682	684	7.6485179520263685e-10
R682_692	682	692	1.5016721512463857e+03
C682_692	682	692	5.8962189647394315e-10
R682_704	682	704	1.1576344427163560e+03
C682_704	682	704	7.6485179520262909e-10
R682_705	682	705	1.6170394983261742e+03
C682_705	682	705	5.4755544475970589e-10
R682_706	682	706	1.7991091594437819e+03
C682_706	682	706	4.9214289030340930e-10
R682_717	682	717	1.1098258045687389e+03
C682_717	682	717	7.9779977907799691e-10
R682_718	682	718	1.3208320017670947e+03
C682_718	682	718	6.7034928023808426e-10
R683_684	683	684	8.1287933836303273e+02
C683_684	683	684	1.0892376517811932e-09
R683_692	683	692	1.2233843024378355e+03
C683_692	683	692	7.2374541665740510e-10
R683_712	683	712	3.3511258955201415e+03
C683_712	683	712	2.6421531428695269e-10
R683_716	683	716	6.5083645133236337e+02
C683_716	683	716	1.3604320715095322e-09
R683_717	683	717	7.5178741887274930e+02
C683_717	683	717	1.1777515285206836e-09
R683_718	683	718	2.0892891436512764e+03
C683_718	683	718	4.2378949050231860e-10
R684_706	684	706	1.1910478243908708e+04
C684_706	684	706	7.4339481888800194e-11
R684_716	684	716	1.2508768637981309e+04
C684_716	684	716	7.0783848300746157e-11
R684_718	684	718	6.1482918679871500e+03
C684_718	684	718	1.4401053182107173e-10
R685_686	685	686	2.2159083128607218e-07
C685_686	685	686	3.9957374434726974e-10
R685_702	685	702	2.4190819203410569e-06
C685_702	685	702	3.6601438514953986e-11
R685_709	685	709	3.8782289251574814e-06
C685_709	685	709	2.2830492959206791e-11
R685_710	685	710	2.0092647315725994e-06
C685_710	685	710	4.4066805522784732e-11
R685_720	685	720	3.9259909642452576e-06
C685_720	685	720	2.2552746294214028e-11
R686_702	686	702	3.6132089943869914e-06
C686_702	686	702	2.4505053072641817e-11
R686_707	686	707	5.3379793859345506e-06
C686_707	686	707	1.6587152510050107e-11
R686_710	686	710	7.0395576717545469e-06
C686_710	686	710	1.2577761600741561e-11
R686_720	686	720	4.7094716646940682e-06
C686_720	686	720	1.8800809193477068e-11
R687_688	687	688	3.2886312304314674e+03
C687_688	687	688	2.6923626264530528e-10
R687_689	687	689	2.2287325356034648e+03
C687_689	687	689	3.9727457985902231e-10
R687_691	687	691	1.6127167006341567e+03
C687_691	687	691	5.4902313676781136e-10
R687_696	687	696	6.4674267769296032e-06
C687_696	687	696	1.5059477169039171e-10
R687_697	687	697	6.7809504433228355e-06
C687_697	687	697	1.4363187978391633e-10
R687_698	687	698	6.2167585379854887e-07
C687_698	687	698	1.4242450889638634e-10
R687_699	687	699	3.5330292873572619e-06
C687_699	687	699	2.5061178656752697e-11
R687_721	687	721	5.8250719606615186e-06
C687_721	687	721	2.1786859641365564e-10
R688_690	688	690	1.1859039728181201e+03
C688_690	688	690	7.4661928958374017e-10
R688_691	688	691	1.0383467065043651e+03
C688_691	688	691	8.5271978632339189e-10
R688_694	688	694	8.8297900029780578e+02
C688_694	688	694	1.0027631250588871e-09
R688_697	688	697	1.6464904358013164e+03
C688_697	688	697	5.3776126629553303e-10
R688_713	688	713	1.4172491310362091e+03
C688_713	688	713	6.2474462838628374e-10
R688_721	688	721	2.1457809247861219e+03
C688_721	688	721	4.1263242275688191e-10
R689_690	689	690	1.0580821950267693e+03
C689_690	689	690	8.3681474450819881e-10
R689_691	689	691	7.6290419236892387e+02
C689_691	689	691	1.1605897445007498e-09
R689_695	689	695	2.1662312688157076e+03
C689_695	689	695	4.0873695918167790e-10
R689_696	689	696	7.1699217531126931e+02
C689_696	689	696	1.2349071749850150e-09
R689_700	689	700	4.4871788832155544e+03
C689_700	689	700	1.9732192648078711e-10
R689_715	689	715	1.6250325818670217e+03
C689_715	689	715	5.4486217173733868e-10
R689_721	689	721	3.0739454438706457e+03
C689_721	689	721	2.8803984906937706e-10
R690_691	690	691	9.7913226182360756e+02
C690_691	690	691	9.0428925306876455e-10
R690_695	690	695	1.8677488699976477e+03
C690_695	690	695	4.7405665500475722e-10
R690_712	690	712	2.0189599616719245e+03
C690_712	690	712	4.3855192698659273e-10
R690_713	690	713	8.0116745120114194e+02
C690_713	690	713	1.1051607006407274e-09
R690_715	690	715	7.9407645039654244e+02
C690_715	690	715	1.1150296438810691e-09
R690_721	690	721	2.0802180998783488e+03
C690_721	690	721	4.2563747606646604e-10
R691_721	691	721	6.8520442190908479e+03
C691_721	691	721	1.2921965378347784e-10
R692_693	692	693	7.8952441428720329e+02
C692_693	692	693	1.1214583940375954e-09
R692_704	692	704	1.5908167022077996e+03
C692_704	692	704	5.5658127078448458e-10
R692_709	692	709	4.8812715098672070e+03
C692_709	692	709	1.8139101254871346e-10
R692_714	692	714	3.0864598778332688e+03
C692_714	692	714	2.8687195581546798e-10
R692_717	692	717	6.5255915915180651e+02
C692_717	692	717	1.3568406316614472e-09
R692_719	692	719	3.4913001969600700e+03
C692_719	692	719	2.5360717547890846e-10
R692_722	692	722	4.1668866244888741e+03
C692_722	692	722	2.1248929032442995e-10
R693_694	693	694	6.4573944432718417e+02
C693_694	693	694	1.3711703528077724e-09
R693_708	693	708	1.4828026667230779e+03
C693_708	693	708	5.9712516140582120e-10
R693_709	693	709	1.4349769403288931e+03
C693_709	693	709	6.1702648789398965e-10
R693_714	693	714	1.6357245187635383e+03
C693_714	693	714	5.4130067229737283e-10
R693_719	693	719	4.7639652612583468e+03
C693_719	693	719	1.8585752270286847e-10
R693_722	693	722	1.0127907967745285e+03
C693_722	693	722	8.7423659902896557e-10
R694_697	694	697	8.9669722327080717e+02
C694_697	694	697	9.8742224099940038e-10
R694_708	694	708	2.0169061456012448e+03
C694_708	694	708	4.3899850453182807e-10
R694_713	694	713	1.2907333672640514e+03
C694_713	694	713	6.8598116710719987e-10
R694_714	694	714	5.8250585262611651e+02
C694_714	694	714	1.5200169710025374e-09
R694_721	694	721	1.8664643758695902e+03
C694_721	694	721	4.7438289910434606e-10
R694_722	694	722	1.1523432493719085e+03
C694_722	694	722	7.6836375115019131e-10
R695_696	695	696	5.6104873844516706e+03
C695_696	695	696	1.5781494922415452e-10
R695_700	695	700	5.5156219781330474e+03
C695_700	695	700	1.6052927216736134e-10
R695_712	695	712	6.3036681090359716e+03
C695_712	695	712	1.4046088188412071e-10
R695_715	695	715	1.8932331597516074e+03
C695_715	695	715	4.6767550903036538e-10
R695_723	695	723	5.2308923816027218e+03
C695_723	695	723	1.6926725252732342e-10
R696_699	696	699	8.5770017303659569e-07
C696_699	696	699	1.0323173639632945e-10
R696_700	696	700	7.7755465234814330e-06
C696_700	696	700	1.8219555941396303e-10
R696_715	696	715	1.5756893422622888e+03
C696_715	696	715	5.6192471317268924e-10
R696_721	696	721	5.2438199553684781e-06
C696_721	696	721	2.7015993315038346e-10
R696_723	696	723	4.5010946412604537e-06
C696_723	696	723	3.1473900495419953e-10
R697_698	697	698	1.7097423588078537e-06
C697_698	697	698	5.1786678685165933e-11
R697_708	697	708	2.1874542975647702e-06
C697_708	697	708	4.4524846072456085e-10
R697_711	697	711	5.3013984941455692e-07
C697_711	697	711	1.6701607748932364e-10
R697_721	697	721	2.1252119305808328e-06
C697_721	697	721	4.5828872164756316e-10
R697_722	697	722	2.8738297501985518e-06
C697_722	697	722	2.3620782179965711e-10
R697_724	697	724	2.1119950564188266e-06
C697_724	697	724	4.1923335900290766e-11
R698_699	698	699	5.4941844682334345e-06
C698_699	698	699	1.6115563407442195e-11
R698_711	698	711	8.7258671639079365e-06
C698_711	698	711	1.0147057765929358e-11
R698_721	698	721	6.4817746037765545e-06
C698_721	698	721	1.3660129144017410e-11
R698_724	698	724	7.2488818712481385e-06
C698_724	698	724	1.2214556636823014e-11
R699_700	699	700	2.8404547956841042e-06
C699_700	699	700	3.1171725846344721e-11
R699_701	699	701	3.6969067358687819e-06
C699_701	699	701	2.3950260175874425e-11
R699_721	699	721	1.7877446566013773e-06
C699_721	699	721	4.9527139036915964e-11
R699_723	699	723	2.3555058024548794e-06
C699_723	699	723	3.7589327132084642e-11
R699_724	699	724	4.4595251847191184e-06
C699_724	699	724	1.9854552783645010e-11
R699_725	699	725	1.5776173597513366e-06
C699_725	699	725	5.6123798095094452e-11
R700_701	700	701	1.8057208524601180e-06
C700_701	700	701	4.9034089654206716e-11
R700_723	700	723	7.2228834062290310e-06
C700_723	700	723	7.3551134481310086e-11
R700_725	700	725	9.0286042623005923e-06
C700_725	700	725	9.8068179308413431e-12
R701_725	701	725	2.0875707191165212e-05
C701_725	701	725	4.2413834108322672e-12
R702_703	702	703	7.4868270176678425e+03
C702_703	702	703	1.1826355539009225e-10
R702_707	702	707	2.4094728962562223e-06
C702_707	702	707	3.6747405753172877e-11
R702_709	702	709	8.0086346660998093e-06
C702_709	702	709	1.5846649335247002e-10
R702_720	702	720	5.6858584466260059e-06
C702_720	702	720	1.5572297305878384e-11
R702_726	702	726	1.4456837370308935e-05
C702_726	702	726	3.6747405753172825e-11
R703_704	703	704	2.1234006692750331e+03
C703_704	703	704	4.1698149318295994e-10
R703_705	703	705	1.3897799975575284e+04
C703_705	703	705	6.3709276522620906e-11
R703_709	703	709	1.1569213711864662e+04
C703_709	703	709	7.6532321361819936e-11
R703_726	703	726	1.1619944149442255e+04
C703_726	703	726	7.6198195990683773e-11
R704_705	704	705	7.7848395869756757e+02
C704_705	704	705	1.1373629113454546e-09
R704_709	704	709	2.1004097778116698e+03
C704_709	704	709	4.2154573410074350e-10
R704_717	704	717	1.8762273832808387e+03
C704_717	704	717	4.7191443296799390e-10
R704_719	704	719	1.7988618141988045e+03
C704_719	704	719	4.9221056042837669e-10
R704_726	704	726	2.2977687969934645e+03
C704_726	704	726	3.8533850005210873e-10
R705_706	705	706	1.6297923624926179e+03
C705_706	705	706	5.4327091111522532e-10
R705_717	705	717	2.5985704974632408e+03
C705_717	705	717	3.4073302323887602e-10
R705_718	705	718	1.5744809574865374e+03
C705_718	705	718	5.6235597991192025e-10
R705_719	705	719	1.7255173904614032e+03
C705_719	705	719	5.1313234314215696e-10
R705_726	705	726	1.8112968217590130e+03
C705_726	705	726	4.8883141132006149e-10
R705_727	705	727	2.5915023384977112e+03
C705_727	705	727	3.4166235104124028e-10
R706_718	706	718	4.9907069299174273e+03
C706_718	706	718	1.7741349955699555e-10
R706_727	706	727	2.6940786902453172e+04
C706_727	706	727	3.2865364508687589e-11
R707_720	707	720	4.1967845353940030e-06
C707_720	707	720	2.1097551571512241e-11
R707_726	707	726	1.0731674229684850e-05
C707_726	707	726	8.2505186306424206e-12
R707_728	707	728	1.7170678767495745e-05
C707_728	707	728	5.1565741441515177e-12
R708_709	708	709	7.1425816385012789e-06
C708_709	708	709	1.3635975172422457e-10
R708_710	708	710	9.8308291744652563e-07
C708_710	708	710	9.0065524076015914e-11
R708_711	708	711	4.0734851200261855e-06
C708_711	708	711	2.1736148669037202e-11
R708_722	708	722	8.5592124867976805e-06
C708_722	708	722	1.1379091947984045e-10
R708_729	708	729	8.1162880844815747e-06
C708_729	708	729	1.0909159119092012e-11
R709_710	709	710	5.2383965738868891e-06
C709_710	709	710	1.6902477107475263e-11
R709_719	709	719	4.8913503320531997e-06
C709_719	709	719	2.5945805675815236e-10
R709_720	709	720	1.0569410383367487e-06
C709_720	709	720	8.3771823553500757e-11
R709_722	709	722	1.2502655324388923e-05
C709_722	709	722	7.7900304665372561e-11
R709_726	709	726	1.0480554013142348e-05
C709_726	709	726	1.3517129407648939e-10
R709_729	709	729	5.5068959836220001e-06
C709_729	709	729	1.6078364006389705e-11
R710_711	710	711	5.5293138662180685e-06
C710_711	710	711	1.6013176374550926e-11
R710_720	710	720	4.3832933025736578e-06
C710_720	710	720	2.0199852498579667e-11
R710_729	710	729	6.0273607148322366e-06
C710_729	710	729	1.4689991583233868e-11
R711_722	711	722	4.1874718482940260e-06
C711_722	711	722	2.1144471265179235e-11
R711_724	711	724	3.3310257515497916e-06
C711_724	711	724	2.6580964776031845e-11
R711_729	711	729	4.9702337845698508e-06
C711_729	711	729	1.7814429261834587e-11
R712_713	712	713	2.0032868360549492e+03
C712_713	712	713	4.4198302797398980e-10
R712_715	712	715	3.5090476715865384e+03
C712_715	712	715	2.5232452350801992e-10
R712_716	712	716	6.7904650969971663e+03
C712_716	712	716	1.3039147820545371e-10
R712_723	712	723	1.4810614748994527e+04
C712_723	712	723	5.9782716430464859e-11
R712_730	712	730	9.1065570032492997e+03
C712_730	712	730	9.7228709092149220e-11
R713_714	713	714	2.5537968799889677e+03
C713_714	713	714	3.4670681471888444e-10
R713_715	713	715	4.7015286075363883e+03
C713_715	713	715	1.8832572459108390e-10
R713_716	713	716	1.0291620443155105e+04
C713_716	713	716	8.6032980577794899e-11
R713_721	713	721	3.3628067950740619e+03
C713_721	713	721	2.6329754745261837e-10
R713_730	713	730	7.3015176212435290e+03
C713_730	713	730	1.2126503387787531e-10
R714_716	714	716	3.2839937252695913e+03
C714_716	714	716	2.6961646573405488e-10
R714_717	714	717	3.3705988088505524e+03
C714_717	714	717	2.6268886684913626e-10
R714_721	714	721	5.0291012562088663e+03
C714_721	714	721	1.7605904844466456e-10
R714_722	714	722	1.0757549606468958e+03
C714_722	714	722	8.2306734720289963e-10
R714_730	714	730	4.9908708437524374e+03
C714_730	714	730	1.7740767281292515e-10
R715_721	715	721	1.1174404291712647e+03
C715_721	715	721	7.9236329614157567e-10
R715_723	715	723	1.1386496936094270e+03
C715_723	715	723	7.7760419791032875e-10
R715_730	715	730	4.7181607118274660e+03
C715_730	715	730	1.8766185295054406e-10
R716_717	716	717	1.8642252336278380e+03
C716_717	716	717	4.7495268582806856e-10
R716_718	716	718	4.5103319239835719e+03
C716_718	716	718	1.9630900710251696e-10
R716_722	716	722	7.2289145820871054e+03
C716_722	716	722	1.2248294977700031e-10
R716_730	716	730	4.6257370731383489e+03
C716_730	716	730	1.9141139405471751e-10
R716_731	716	731	5.0642900028454278e+03
C716_731	716	731	1.7483571857111611e-10
R717_718	717	718	1.1422300004896042e+03
C717_718	717	718	7.7516680644045010e-10
R717_719	717	719	1.2673743947330615e+03
C717_719	717	719	6.9862448332522131e-10
R717_722	717	722	2.0659156296854549e+03
C717_722	717	722	4.2858419239260471e-10
R717_731	717	731	2.5365444236387220e+03
C717_731	717	731	3.4906496154711530e-10
R718_719	718	719	8.6386669058134721e+03
C718_719	718	719	1.0249483992769178e-10
R718_727	718	727	1.0113570166232765e+04
C718_727	718	727	8.7547598636952227e-11
R718_731	718	731	6.3755791723537923e+03
C718_731	718	731	1.3887660364087573e-10
R719_722	719	722	1.0373329122529047e-05
C719_722	719	722	1.2234261894974524e-10
R719_726	719	726	7.1136840738416402e-06
C719_726	719	726	1.3691367915500729e-10
R719_720	719	720	8.5287629200367398e-06
C719_720	719	720	1.0381561663765722e-11
R719_727	719	727	1.3655506437257199e-05
C719_727	719	727	7.1323657117448212e-11
R719_729	719	729	6.9446217483690617e-06
C719_729	719	729	1.2749704934007959e-11
R719_731	719	731	1.3240894252025152e-05
C719_731	719	731	1.0699202196092761e-10
R719_732	719	732	2.9696787423124115e-06
C719_732	719	732	2.9815305241083002e-11
R719_733	719	733	2.0938960593696255e-06
C719_733	719	733	4.2285708392161476e-11
R720_726	720	726	5.1477403513219464e-06
C720_726	720	726	1.7200144554156134e-11
R720_728	720	728	1.1610707512059231e-05
C720_728	720	728	7.6258813752768941e-12
R720_729	720	729	9.7000841030992411e-06
C720_729	720	729	9.1279495341396347e-12
R720_733	720	733	7.3960169180528749e-06
C720_733	720	733	1.1971562416775831e-11
R721_722	721	722	1.2787354519119691e-05
C721_722	721	722	7.6165922938929293e-11
R721_723	721	723	6.9529926787425862e-06
C721_723	721	723	7.6406130899371017e-11
R721_724	721	724	1.6319280094314189e-06
C721_724	721	724	5.4255995153149528e-11
R721_725	721	725	9.3601728819700585e-06
C721_725	721	725	9.4594276501615632e-12
R721_730	721	730	1.5002530035690761e-05
C721_730	721	730	1.2393772473228246e-10
R721_734	721	734	7.9267561860791097e-06
C721_734	721	734	1.1170001459802230e-11
R722_724	722	724	4.1607645649242009e-06
C722_724	722	724	2.1280194249975072e-11
R722_729	722	729	6.8901524009756570e-07
C722_729	722	729	1.2850496334081423e-10
R722_730	722	730	6.0514012795816095e-06
C722_730	722	730	1.6094795467990821e-10
R722_731	722	731	9.9171758855622471e-06
C722_731	722	731	1.4285014856471691e-10
R722_732	722	732	2.3890092286470395e-06
C722_732	722	732	3.7062175025645954e-11
R722_734	722	734	4.5589836095196480e-06
C722_734	722	734	1.9421407435007014e-11
R723_725	723	725	2.2722482451631364e-06
C723_725	723	725	3.8966639476332002e-11
R723_730	723	730	2.7266978887423681e-05
C723_730	723	730	6.8191619083581014e-11
R723_734	723	734	1.7041861838723524e-05
C723_734	723	734	5.1955519301775996e-12
R724_725	724	725	1.0440635110085889e-05
C724_725	724	725	8.4805069075219891e-12
R724_729	724	729	1.3757001359790334e-05
C724_729	724	729	6.4361321086145069e-12
R724_734	724	734	6.3609487774461151e-06
C724_734	724	734	1.3919602447348909e-11
R725_734	725	734	1.7059558542040422e-05
C725_734	725	734	5.1901623334392499e-12
R726_727	726	727	1.1585282792757788e-05
C726_727	726	727	4.5855701432378599e-11
R726_728	726	728	1.9308804664250738e-06
C726_728	726	728	4.5855701432378528e-11
R726_733	726	733	3.5037510564383228e-06
C726_733	726	733	2.5270596210681049e-11
R726_735	726	735	1.4481603498188041e-05
C726_735	726	735	6.1140935243171437e-12
R727_731	727	731	9.9540141066450377e-06
C727_731	727	731	5.3370556145758843e-11
R727_732	727	732	6.0880793755771026e-06
C727_732	727	732	1.4543482879870783e-11
R727_733	727	733	5.4033830703846669e-06
C727_733	727	733	1.6386378129525567e-11
R727_735	727	735	1.6590023519370074e-06
C727_735	727	735	5.3370556145758830e-11
R728_733	728	733	7.9276008053866582e-06
C728_733	728	733	1.1168811389927387e-11
R728_735	728	735	3.1329560044006095e-05
C728_735	728	735	2.8261449584875245e-12
R729_732	729	732	3.1293196155813805e-06
C729_732	729	732	2.8294290467849911e-11
R729_733	729	733	6.7429130915585568e-06
C729_733	729	733	1.3131101790537012e-11
R729_734	729	734	1.0186743049995589e-05
C729_734	729	734	8.6918731272051044e-12
R729_736	729	736	1.3762120935871905e-05
C729_736	729	736	6.4337378360925138e-12
R730_731	730	731	1.6503379592871697e-05
C730_731	730	731	3.2190453219887009e-11
R730_732	730	732	9.1106993303131724e-06
C730_732	730	732	9.7184502484241743e-12
R730_734	730	734	2.0629224501404233e-06
C730_734	730	734	4.2920604293182683e-11
R730_736	730	736	2.0629224501404238e-05
C730_736	730	736	4.2920604293182681e-12
R731_732	731	732	4.9714521214060564e-07
C731_732	731	732	1.7810063540340008e-10
R731_735	731	735	1.1390496551934203e-05
C731_735	731	735	7.7733115291593523e-12
R731_736	731	736	2.2780993103868405e-06
C731_736	731	736	3.8866557645796765e-11
R732_733	732	733	1.1418828830740331e-06
C732_733	732	733	7.7540244697984032e-11
R732_734	732	734	4.5607314203007986e-06
C732_734	732	734	1.9413964561886065e-11
R732_735	732	735	5.0528653632274633e-06
C732_735	732	735	1.7523102597264703e-11
R732_736	732	736	4.5071943960104471e-07
C732_736	732	736	1.9644566084918158e-10
R733_735	733	735	3.3483024240432212e-06
C733_735	733	735	2.6443811507050740e-11
R733_736	733	736	4.6536854148394739e-06
C733_736	733	736	1.9026184685295109e-11
R734_736	734	736	6.9578230024161675e-06
C734_736	734	736	1.2725514595478075e-11
R735_736	735	736	8.2948177218853849e-06
C735_736	735	736	1.0674360924940823e-11
.control
quit 13

.endc
.end
.END
