Simul15-Jul-2025_11-06-44.cir
********************************************************************************
*
*                        Spice Netlist Generated by
*
*                              BIOCAD Program
*                               Release 1.0
*
*   Authors: Vincent Senez
*
*   Release 1.0 : January 2019
*
********************************************************************************
.CONTROL
  DESTROY ALL
  AC DEC 9.000000 1000.000000 10000000000.000000
  WRITE Simul15-Jul-2025_11-06-44.spi vdb(692,30)-vdb(30)-66 vp(692,30)-vp(30)
  DESTROY ALL
  AC DEC 1 1000.000000 1000.000000
  WRITE Simul15-Jul-2025_11-06-44_1000Hz.spi_cou all
  DESTROY ALL
  AC DEC 1 50000000.000000 50000000.000000
  WRITE Simul15-Jul-2025_11-06-44_50000000Hz.spi_cou all
  DESTROY ALL
  AC DEC 1 10000000000.000000 10000000000.000000
  WRITE Simul15-Jul-2025_11-06-44_10000000000Hz.spi_cou all
.ENDC
Vin	692	0	DC 0 AC 0.025000
Rg	30	0	50e-5
R1_9	1	9	2.1096615305983564e+00
C1_9	1	9	4.1969707882423766e-17
R1_7	1	7	7.6645048698259473e+00
C1_7	1	7	1.1552198044596024e-17
R1_3	1	3	1.6877292244786823e+01
C1_3	1	3	5.2462134853029784e-18
R1_8	1	8	1.6877292244786862e+01
C1_8	1	8	5.2462134853029661e-18
R2_3	2	3	1.8909465597858606e+01
C2_3	2	3	4.6824103892194027e-18
R2_13	2	13	7.8789439991077499e+00
C2_13	2	13	1.1237784934126569e-17
R2_5	2	5	6.9515434922628456e+00
C2_5	2	5	1.2737009883998889e-17
R2_14	2	14	1.5757887998215481e+00
C2_14	2	14	5.6188924670632900e-17
R2_4	2	4	5.9347091872720910e+00
C2_4	2	4	1.4919328879651236e-17
R2_10	2	10	1.8909465597858599e+01
C2_10	2	10	4.6824103892194042e-18
R2_21	2	21	6.1671833011701578e+00
C2_21	2	21	1.4356939602103302e-17
R3_9	3	9	5.4270437317500990e+00
C3_9	3	9	1.6314937293023663e-17
R3_7	3	7	2.7745512189216606e+00
C3_7	3	7	3.1912144049159819e-17
R3_13	3	13	1.0854087463500210e+00
C3_13	3	13	8.1574686465118221e-17
R3_5	3	5	4.7532070605820893e+00
C3_5	3	5	1.8627818447942169e-17
R3_22	3	22	3.0590443735732560e+00
C3_22	3	22	2.8944293497310274e-17
R4_14	4	14	4.2158651267698399e+00
C4_14	4	14	2.1002066125829799e-17
R4_10	4	10	4.7076996417456431e+00
C4_10	4	10	1.8807885996985174e-17
R4_5	4	5	6.7767751886262912e+00
C4_5	4	5	1.3065488481690094e-17
R4_21	4	21	2.7257919158989075e+00
C4_21	4	21	3.2482992430036903e-17
R4_6	4	6	2.5816630257815572e+00
C4_6	4	6	3.4296450499458724e-17
R4_24	4	24	6.2809342688191028e-01
C4_24	4	24	1.4096928001548254e-16
R4_16	4	16	6.9517734214970810e+00
C4_16	4	16	1.2736588608627623e-17
R4_25	4	25	2.7766650206330961e+00
C4_25	4	25	3.1887850177120737e-17
R4_29	4	29	4.2561542916513035e+00
C4_29	4	29	2.0803258552839614e-17
R5_13	5	13	4.4384210451836532e+00
C5_13	5	13	1.9948958710458777e-17
R5_21	5	21	4.7307150529528696e-01
C5_21	5	21	1.8716383713437349e-16
R5_6	5	6	3.5849918516592627e+00
C5_6	5	6	2.4697930102412828e-17
R5_7	5	7	5.1894094084781797e+00
C5_7	5	7	1.7062033692185667e-17
R5_22	5	22	2.1720547343557004e+00
C5_22	5	22	4.0764110024264328e-17
R5_17	5	17	3.4752311583156810e+00
C5_17	5	17	2.5477982366189721e-17
R5_23	5	23	3.9611003174108776e+00
C5_23	5	23	2.2352849227477850e-17
R5_34	5	34	3.3558750526640733e+00
C5_34	5	34	2.6384140285470615e-17
R5_27	5	27	7.6048150862872559e+00
C5_27	5	27	1.1642870624120199e-17
R6_21	6	21	3.6370199626316571e+00
C6_21	6	21	2.4344622542553574e-17
R6_25	6	25	6.9813607712655745e-01
C6_25	6	25	1.2682610320673804e-16
R6_29	6	29	3.2474752376959697e+00
C6_29	6	29	2.7264835507358328e-17
R6_30	6	30	1.3914139437423312e+00
C6_30	6	30	6.3634462316698353e-17
R6_32	6	32	2.8194452546371678e+00
C6_32	6	32	3.1404006878436237e-17
R6_34	6	34	2.0100909676424181e+00
C6_34	6	34	4.4048692121555281e-17
R6_27	6	27	5.1466561963507020e+00
C6_27	6	27	1.7203767804187440e-17
R7_9	7	9	2.9597479064906302e+00
C7_9	7	9	2.9915344471003954e-17
R7_8	7	8	2.0708147139635726e+00
C7_8	7	8	4.2757025808711502e-17
R7_22	7	22	6.4463627461957307e-01
C7_22	7	22	1.3735168443980645e-16
R7_17	7	17	3.1219253482079909e+00
C7_17	7	17	2.8361305378690021e-17
R7_44	7	44	2.3516530853503603e+00
C7_44	7	44	3.7650909788340917e-17
R8_9	8	9	8.9923877618500878e+00
C8_9	8	9	9.8463145178899028e-18
R8_44	8	44	1.1989850349133446e+00
C8_44	8	44	7.3847358884174309e-17
R8_18	8	18	1.4387820418960132e+01
C8_18	8	18	6.1539465736811937e-18
R8_17	8	17	5.7884549020546219e+00
C8_17	8	17	1.5296288848786216e-17
R9_13	9	13	1.8856861628552071e+01
C9_13	9	13	5.1650199173192179e-17
R9_22	9	22	6.2658880463017352e+00
C9_22	9	22	1.5543856699943638e-16
R9_42	9	42	5.2193327220425377e+09
C9_42	9	42	1.6964214179346274e-16
R9_44	9	44	9.4284308189902699e+00
C9_44	9	44	5.6345671825300440e-17
R9_45	9	45	5.0872418660283785e+09
C9_45	9	45	1.7404692071211635e-16
R9_43	9	43	1.5274057934401245e+10
C9_43	9	43	5.7968798174177481e-17
R10_14	10	14	7.2539160969215573e+00
C10_14	10	14	1.2206079721210964e-17
R10_24	10	24	3.5326423132672748e+00
C10_24	10	24	2.5063923918215562e-17
R10_16	10	16	4.4444198797375947e+00
C10_16	10	16	1.9922032698500949e-17
R10_41	10	41	1.4507832193843102e+00
C10_41	10	41	6.1030398606054879e-17
R10_46	10	46	4.4550161274089968e+00
C10_46	10	46	1.9874648180341219e-17
R10_11	10	11	8.7046993163058541e+00
C10_11	10	11	1.0171733101009153e-17
R11_16	11	16	6.7613937238922830e+00
C11_16	11	16	1.3095211103758909e-17
R11_46	11	46	2.7347218583006128e+00
C11_46	11	46	3.2376922684569078e-17
R11_41	11	41	9.9381211138039927e+00
C11_41	11	41	8.9093176824959253e-18
R11_15	11	15	2.6613387865450098e+00
C11_15	11	15	3.3269675630041233e-17
R11_47	11	47	1.3250828151738665e+00
C11_47	11	47	6.6819882618719403e-17
R11_48	11	48	2.3947989401412717e+00
C11_48	11	48	3.6972572805956237e-17
R11_12	11	12	7.9504968910432110e+00
C11_12	11	12	1.1136647103119885e-17
R11_50	11	50	9.9381211138040104e+00
C11_50	11	50	8.9093176824959099e-18
R12_15	12	15	8.9591144109099172e+00
C12_15	12	15	9.8828828508070578e-18
R12_48	12	48	4.7366262234055929e+00
C12_48	12	48	1.8693026216102643e-17
R12_49	12	49	8.6538567816338468e+00
C12_49	12	49	1.0231493356570584e-17
R12_50	12	50	2.1634641954084608e+00
C12_50	12	50	4.0925973426282353e-17
R13_14	13	14	1.6609974464903107e+01
C13_14	13	14	1.1194354583627517e-16
R13_21	13	21	6.0840210683796281e+00
C13_21	13	21	1.1157441072081044e-16
R13_22	13	22	3.8172194396400982e+00
C13_22	13	22	2.5514924522858132e-16
R13_42	13	42	3.2848746868628764e+09
C13_42	13	42	2.6954415802862593e-16
R13_56	13	56	2.1152972824373538e+09
C13_56	13	56	4.1857888678407189e-16
R13_58	13	58	8.4346714232050362e+09
C13_58	13	58	1.0497371353009451e-16
R14_21	14	21	5.9511644042483622e+00
C14_21	14	21	1.6365883930223088e-16
R14_24	14	24	4.9902703467431699e+00
C14_24	14	24	1.9517192280608222e-16
R14_41	14	41	1.6929632691080151e+01
C14_41	14	41	1.0982987473974596e-16
R14_56	14	56	5.7648352384127493e+09
C14_56	14	56	1.5358960752255345e-16
R14_57	14	57	5.1144713362019567e+09
C14_57	14	57	1.7312029406298681e-16
R14_58	14	58	5.6980995218538027e+09
C14_58	14	58	1.5538843754907610e-16
R14_59	14	59	5.3371495483950129e+09
C14_59	14	59	1.6589731534996299e-16
R14_61	14	61	3.4374969307484531e+09
C14_61	14	61	2.5757660284142162e-16
R15_16	15	16	3.2819935158986144e+00
C15_16	15	16	2.6978078335952204e-17
R15_46	15	46	3.2299479495008767e+00
C15_46	15	46	2.7412787931670039e-17
R15_48	15	48	8.4532354912001872e-01
C15_48	15	48	1.0474318178190121e-16
R15_49	15	49	3.7657366108620476e+00
C15_49	15	49	2.3512498966233090e-17
R15_28	15	28	6.8754267675443268e+00
C15_28	15	28	1.2878019236269781e-17
R15_64	15	64	3.1463574537120849e+00
C15_64	15	64	2.8141074074574062e-17
R16_24	16	24	3.8424406753705820e+00
C16_24	16	24	2.3043134728803753e-17
R16_29	16	29	6.1218664297512468e+00
C16_29	16	29	1.4463216273341290e-17
R16_46	16	46	7.6343952931293668e-01
C16_46	16	46	1.1597759189871129e-16
R16_28	16	28	6.5100297227765438e+00
C16_28	16	28	1.3600840847196110e-17
R16_64	16	64	5.8513776536673205e+00
C16_64	16	64	1.5131800305951340e-17
R16_65	16	65	4.4805933851711721e+00
C16_65	16	65	1.9761194680828517e-17
R17_22	17	22	4.1668347414550491e+00
C17_22	17	22	2.1249193611907298e-17
R17_23	17	23	7.7332880701211659e-01
C17_23	17	23	1.1449447811480885e-16
R17_27	17	27	4.5883396725449339e+00
C17_27	17	27	1.9297149838274728e-17
R17_34	17	34	4.7140306748781686e+00
C17_34	17	34	1.8782626647266847e-17
R17_44	17	44	3.2251523708216063e+00
C17_44	17	44	2.7453548852776839e-17
R17_18	17	18	4.1270121107980797e+00
C17_18	17	18	2.1454232697387896e-17
R17_66	17	66	3.4286726121581275e+00
C17_66	17	66	2.5823952352881142e-17
R17_26	17	26	4.9662097299733761e+00
C17_26	17	26	1.7828864060172237e-17
R17_67	17	67	3.3936316685130925e+00
C17_67	17	67	2.6090597571773110e-17
R18_44	18	44	9.5899506272795172e+00
C18_44	18	44	9.2327772697947248e-18
R18_67	18	67	1.2786600836372688e+00
C18_67	18	67	6.9245829523460445e-17
R18_26	18	26	5.6633528430090720e+00
C18_26	18	26	1.5634180073964036e-17
R18_19	18	19	1.5343921003647234e+01
C18_19	18	19	5.7704857936217022e-18
R19_67	19	67	8.5834483708378571e+00
C19_67	19	67	1.0315420370071749e-17
R19_26	19	26	3.6935645579573753e+00
C19_26	19	26	2.3971931932053639e-17
R19_68	19	68	1.1444597827783809e+00
C19_68	19	68	7.7365652775538126e-17
R19_36	19	36	3.5981361187153440e+00
C19_36	19	36	2.4607706670533750e-17
R19_20	19	20	1.3733517393340582e+01
C19_20	19	20	6.4471377312948382e-18
R20_40	20	40	1.7242627332036611e+00
C20_40	20	40	5.1350572314168265e-17
R20_38	20	38	1.3794101865629266e+01
C20_38	20	38	6.4188215392710439e-18
R20_36	20	36	4.2248801685702757e+00
C20_36	20	36	2.0957251954429543e-17
R20_68	20	68	8.6213136660183061e+00
C20_68	20	68	1.0270114462833652e-17
R21_22	21	22	7.2731992954335274e+00
C21_22	21	22	1.9477948988479537e-16
R21_23	21	23	9.4052877125751042e+00
C21_23	21	23	1.0355458425730345e-16
R21_24	21	24	1.0287159810356851e+01
C21_24	21	24	1.3771245656830644e-16
R21_25	21	25	5.2018201495549521e+00
C21_25	21	25	1.3049683495411315e-16
R21_34	21	34	6.5230826407400260e+00
C21_34	21	34	1.4930987579601575e-16
R21_56	21	56	3.2696891124514241e+09
C21_56	21	56	2.7079601492637449e-16
R21_61	21	61	1.9018629940252144e+09
C21_61	21	61	4.6555339920992309e-16
R21_69	21	69	3.0254115126512084e+09
C21_69	21	69	2.9266061096068743e-16
R21_70	21	70	1.9134654106093662e+09
C21_70	21	70	4.6273048720437964e-16
R22_23	22	23	3.1890600133493727e+00
C22_23	22	23	3.0540681417692062e-16
R22_42	22	42	3.2896285171816063e+09
C22_42	22	42	2.6915464073693763e-16
R22_44	22	44	2.6242792334047107e+00
C22_44	22	44	3.7113453724679818e-16
R22_45	22	45	3.6141350456296916e+09
C22_45	22	45	2.4498774133265224e-16
R22_56	22	56	2.6656792348017955e+09
C22_56	22	56	3.3215503581241453e-16
R22_60	22	60	2.3149408010147920e+09
C22_60	22	60	3.8248009681796707e-16
R22_70	22	70	3.7487998067626033e+09
C22_70	22	70	2.3618726721623263e-16
R23_34	23	34	4.4143980660734394e+00
C23_34	23	34	2.2063272145331625e-16
R23_44	23	44	6.9382402337263409e+00
C23_44	23	44	2.0418290530048990e-16
R23_60	23	60	4.8012863885532703e+09
C23_60	23	60	1.8441282399044634e-16
R23_66	23	66	6.5710798611476839e+00
C23_66	23	66	2.1559166507338158e-16
R23_67	23	67	6.5769157153850060e+00
C23_67	23	67	2.1540036544501531e-16
R23_70	23	70	1.4666834536104858e+09
C23_70	23	70	6.0368771429199258e-16
R23_71	23	71	3.3500324963627968e+09
C23_71	23	71	2.6430155010774331e-16
R23_72	23	72	2.0402969179708846e+09
C23_72	23	72	4.3396565171532304e-16
R23_73	23	73	2.0398587612002828e+09
C23_73	23	73	4.3405886649672089e-16
R24_25	24	25	4.8770224183619755e+00
C24_25	24	25	1.9970395363143719e-16
R24_29	24	29	6.1683234515961054e+00
C24_29	24	29	1.4354285871161482e-17
R24_41	24	41	7.7183346629098084e+00
C24_41	24	41	1.2618792802239761e-16
R24_46	24	46	5.9015379173774676e+00
C24_46	24	46	1.6503505908657263e-16
R24_57	24	57	1.6055693037085254e+09
C24_57	24	57	5.5146718341890954e-16
R24_61	24	61	6.5327035186402206e+09
C24_61	24	61	1.3553634864548384e-16
R24_65	24	65	6.9788548334055029e+00
C24_65	24	65	9.7268259868102956e-17
R24_69	24	69	4.7844687007592669e+09
C24_69	24	69	1.8506104587108893e-16
R24_76	24	76	2.9581588531218762e+09
C24_76	24	76	2.9931414290533391e-16
R25_29	25	29	2.6037719797744510e+00
C25_29	25	29	3.4005235042766625e-17
R25_30	25	30	1.0937638288951714e+00
C25_30	25	30	8.0951550810962181e-17
R25_34	25	34	3.1284396629110955e+00
C25_34	25	34	3.1132473815708616e-16
R25_62	25	62	3.8764672027458995e+00
C25_62	25	62	2.5124955480240718e-16
R25_65	25	65	3.5624040345234440e+00
C25_65	25	65	2.7339983041152437e-16
R25_69	25	69	1.6222188740711796e+09
C25_69	25	69	5.4580722481542873e-16
R25_75	25	75	1.6291568849936123e+09
C25_75	25	75	5.4348282222277918e-16
R25_76	25	76	2.8206414281619067e+09
C25_76	25	76	3.1390689112759371e-16
R26_36	26	36	7.8856745679906233e+00
C26_36	26	36	1.1228193277136677e-17
R26_39	26	39	5.8149464905218053e+00
C26_39	26	39	1.5226602396826985e-17
R26_35	26	35	1.2243093938841833e+01
C26_35	26	35	7.2319855268851946e-18
R26_66	26	66	1.4303461081468507e+00
C26_66	26	66	6.1902414853083631e-17
R26_27	26	27	8.4146061216550994e+00
C26_27	26	27	1.0522403174895651e-17
R26_67	26	67	6.6361835603903563e+00
C26_67	26	67	1.3342288887016825e-17
R26_68	26	68	7.0971850092038844e+00
C26_68	26	68	1.2475633375088248e-17
R26_77	26	77	1.1230537935748359e+01
C26_77	26	77	7.8840282341381822e-18
R27_34	27	34	1.6292320918783989e+00
C27_34	27	34	5.4345773454484897e-17
R27_32	27	32	9.6714950099280284e+00
C27_32	27	32	9.1549318982338897e-18
R27_66	27	66	8.8135749649370183e+00
C27_66	27	66	1.0046079884978062e-17
R27_77	27	77	1.1245352536347042e+01
C27_77	27	77	7.8736418341547233e-18
R27_35	27	35	2.5103060769429714e+01
C27_35	27	35	3.5271347579186650e-18
R28_64	28	64	1.4038808155876812e+00
C28_64	28	64	6.3069369697836725e-17
R28_49	28	49	2.2659770164687174e+01
C28_49	28	49	3.9074482012171086e-18
R28_52	28	52	1.3147678255005978e+01
C28_52	28	52	6.7344116925197567e-18
R28_29	28	29	2.2353388199518335e+01
C28_29	28	29	3.9610048096381143e-18
R28_65	28	65	1.0027373744019053e+01
C28_65	28	65	8.8300167551660150e-18
R28_78	28	78	7.9538738885339155e+00
C28_78	28	78	1.1131918787100654e-17
R28_31	28	31	1.9102776397947050e+01
C28_31	28	31	4.6350266749452968e-18
R28_79	28	79	9.5401297887982306e+00
C28_79	28	79	9.2809930399441265e-18
R28_80	28	80	7.6660601951388001e+00
C28_80	28	80	1.1549854281883433e-17
R29_30	29	30	1.1023774644283986e+00
C29_30	29	30	8.0319020505295320e-17
R29_32	29	32	7.2470812230098760e+00
C29_32	29	32	1.2217591530349450e-17
R29_33	29	33	3.9110526757621211e+00
C29_33	29	33	2.2638886640090171e-17
R29_65	29	65	5.4265995566450220e-01
C29_65	29	65	1.6316272694486554e-16
R29_80	29	80	3.8991033637221073e+00
C29_80	29	80	2.2708266468082909e-17
R29_81	29	81	3.6605780464160174e+00
C29_81	29	81	2.4187949839421999e-17
R30_32	30	32	6.9796806573989567e-01
C30_32	30	32	1.2685663215284689e-16
R30_33	30	33	2.3806156858764438e+00
C30_33	30	33	3.7192848343936942e-17
R30_34	30	34	4.5690790664644814e+00
C30_34	30	34	1.9378495509055187e-17
R30_62	30	62	4.6044079394156728e-01
C30_62	30	62	1.9229807466024936e-16
R30_65	30	65	2.0829793911638030e+00
C30_65	30	65	4.2507323186010904e-17
R30_81	30	81	2.4096727753694367e+00
C30_81	30	81	3.6744357605328922e-17
R31_78	31	78	1.6805612617162460e-01
C31_78	31	78	5.2685897376676431e-16
R31_53	31	53	5.6635486264904822e+00
C31_53	31	53	1.5633639615250647e-17
R31_52	31	52	6.5286134549996717e+00
C31_52	31	52	1.3562125982844615e-17
R31_80	31	80	4.6124167203206259e+00
C31_80	31	80	1.9196417743417842e-17
R31_82	31	82	7.3253670677543861e+00
C31_82	31	82	1.2087022718595697e-17
R31_85	31	85	4.3856720476162003e+00
C31_85	31	85	2.0188896298829796e-17
R32_33	32	33	3.5566341998668776e+00
C32_33	32	33	2.4894850916440626e-17
R32_34	32	34	5.0684347567812464e+00
C32_34	32	34	1.7469274523369679e-17
R32_62	32	62	1.3213277060503121e+00
C32_62	32	62	6.7009779454839201e-17
R32_77	32	77	6.0635569342006823e+00
C32_77	32	77	1.4602300123643829e-17
R32_35	32	35	1.6454586570128104e+01
C32_35	32	35	5.3809846751628646e-18
R32_83	32	83	7.5881247652868566e+00
C32_83	32	83	1.1668479487191567e-17
R32_88	32	88	6.9294759020629790e+00
C32_88	32	88	1.2777572131196843e-17
R33_62	33	62	2.7648653812351522e+00
C33_62	33	62	3.2023938225319867e-17
R33_81	33	81	6.1099485797765185e-01
C33_81	33	81	1.4491427712348856e-16
R33_80	33	80	2.8924965758285999e+00
C33_80	33	80	3.0610884351569482e-17
R33_82	33	82	3.2997147077698759e+00
C33_82	33	82	2.6833191960962393e-17
R33_88	33	88	2.3710522327186414e+00
C33_88	33	88	3.7342862779736458e-17
R33_83	33	83	4.6177615990221712e+00
C33_83	33	83	1.9174198639606923e-17
R34_62	34	62	6.2131344736571856e+00
C34_62	34	62	1.5675834202937262e-16
R34_66	34	66	6.5586982375754603e+00
C34_66	34	66	1.4849908070417357e-16
R34_69	34	69	4.9378733277020226e+09
C34_69	34	69	1.7931176499257310e-16
R34_70	34	70	5.0674794146270103e+09
C34_70	34	70	1.7472567903172646e-16
R34_71	34	71	9.5671849551968968e+08
C34_71	34	71	9.2547471993738394e-16
R34_75	34	75	4.6803633816199617e+09
C34_75	34	75	1.8917735857371402e-16
R34_77	34	77	1.1111154498315576e+01
C34_77	34	77	8.7656117016795085e-17
R34_89	34	89	6.4930464044202051e+09
C34_89	34	89	1.3636415428930900e-16
R34_90	34	90	4.4265491645181684e+09
C34_90	34	90	2.0002461258021027e-16
R35_36	35	36	4.4045518835422177e+00
C35_36	35	36	2.0102357858659866e-17
R35_39	35	39	4.2739629879197736e+00
C35_39	35	39	2.0716575791662429e-17
R35_77	35	77	6.1561057194302982e-01
C35_77	35	77	1.4382774144137650e-16
R35_83	35	83	5.8594667284928521e+00
C35_83	35	83	1.5110910646432559e-17
R35_92	35	92	5.1974952429186674e+00
C35_92	35	92	1.7035489987342265e-17
R35_37	35	37	5.5097745599000660e+00
C35_37	35	37	1.6069963880991520e-17
R35_93	35	93	3.5940695679235417e+00
C35_93	35	93	2.4635549339451073e-17
R35_38	35	38	8.6518800577833908e+00
C35_38	35	38	1.0233830979932055e-17
R36_39	36	39	7.3607525261677165e-01
C36_39	36	39	1.2028916589062153e-16
R36_40	36	40	3.4009030374544049e+00
C36_40	36	40	2.6034814046411068e-17
R36_38	36	38	2.9272699845777601e+00
C36_38	36	38	3.0247253801829154e-17
R36_68	36	68	2.2520322315943697e+00
C36_68	36	68	3.9316434697435510e-17
R36_93	36	93	3.1047110014422548e+00
C36_93	36	93	2.8518557163249325e-17
R37_92	37	92	1.6590012896677016e+00
C37_92	37	92	5.3370590319272726e-17
R37_83	37	83	9.3752526181094087e+00
C37_83	37	83	9.4442125216947105e-18
R37_84	37	84	1.9908015476012441e+01
C37_84	37	84	4.4475491932727225e-18
R37_38	37	38	1.9908015476012448e+01
C37_38	37	38	4.4475491932727210e-18
R37_93	37	93	1.2442509672507775e+01
C37_93	37	93	7.1160787092363563e-18
R38_40	38	40	1.0512345684268874e+01
C38_40	38	40	8.4226566390884445e-18
R38_93	38	93	1.4016460912358515e+00
C38_93	38	93	6.3169924793163259e-17
R39_40	39	40	8.6314906342574123e+00
C39_40	39	40	1.6412808732855384e-16
R39_68	39	68	2.8654956022735285e+00
C39_68	39	68	2.3689482021150747e-16
R39_66	39	66	6.3553078163344097e+00
C39_66	39	66	2.2291131909517749e-16
R39_74	39	74	6.7522059629169631e+08
C39_74	39	74	1.3113029824070975e-15
R39_77	39	77	4.6967293485625010e+00
C39_77	39	77	2.0736997740654008e-16
R39_89	39	89	3.9091417120609078e+09
C39_89	39	89	2.2649953542697369e-16
R39_93	39	93	3.8978686540261891e+00
C39_93	39	93	2.4987005600868956e-16
R39_94	39	94	2.1602384479331479e+09
C39_94	39	94	4.0987085594515854e-16
R39_96	39	96	4.2221990095887341e+09
C39_96	39	96	2.0970560120193028e-16
R40_68	40	68	7.9412430751152217e+00
C40_68	40	68	1.2264586912697016e-16
R40_74	40	74	4.4335062908393087e+09
C40_74	40	74	1.9971073087896333e-16
R40_93	40	93	7.9412430790858295e+00
C40_93	40	93	6.6897746796529281e-17
R40_96	40	96	3.0019071883016796e+09
C40_96	40	96	2.9495208417849969e-16
R40_97	40	97	4.2623017456150327e+09
C40_97	40	97	2.0773254324635756e-16
R40_98	40	98	1.2864813794551483e+10
C40_98	40	98	6.8824842383260412e-17
R41_46	41	46	3.0637385013434062e+00
C41_46	41	46	3.1789940899622189e-16
R41_47	41	47	1.1881268380900027e+01
C41_47	41	47	8.1974468354047934e-17
R41_57	41	57	2.6415217722536688e+09
C41_57	41	57	3.3519268741237238e-16
R41_59	41	59	5.9642676450787973e+09
C41_59	41	59	1.4845389817986652e-16
R41_99	41	99	3.7658788594321799e+09
C41_99	41	99	2.3511610828434978e-16
R42_45	42	45	2.5726243897859530e+09
C42_45	42	45	3.4416947348216222e-16
R42_43	42	43	2.5022299401264901e+09
C42_43	42	43	3.5385188527287850e-16
R42_56	42	56	1.4645346401240320e+09
C42_56	42	56	6.0457346480040502e-16
R42_55	42	55	2.4074314468298945e+09
C42_55	42	55	3.6778566752790388e-16
R42_58	42	58	7.0943972836250687e+09
C42_58	42	58	1.2480535643861945e-16
R42_60	42	60	3.4806078040875740e+09
C42_60	42	60	2.5438625422266126e-16
R42_100	42	100	5.5362692739249535e+09
C42_100	42	100	1.5993058463940649e-16
R43_45	43	45	4.3789897672178535e+09
C43_45	43	45	2.0219704287241160e-16
R43_55	43	55	7.5357618331452179e+09
C43_55	43	55	1.1749558986930600e-16
R43_100	43	100	4.5580321789159594e+09
C43_100	43	100	1.9425461404060991e-16
R43_101	43	101	1.6949659819550634e+10
C43_101	43	101	5.2238144666402748e-17
R44_45	44	45	4.6419568638266182e+09
C44_45	44	45	1.9074256992773970e-16
R44_60	44	60	6.2110912407366076e+09
C44_60	44	60	1.4255446384249113e-16
R44_67	44	67	1.1562417229761531e+01
C44_67	44	67	8.4235038361102859e-17
R44_72	44	72	7.8524769435140343e+09
C44_72	44	72	1.1275662291900591e-16
R44_102	44	102	8.1495276681740952e+09
C44_102	44	102	1.0864663790979905e-16
R45_60	45	60	3.1069678924117546e+09
C45_60	45	60	2.8497841379773712e-16
R45_100	45	100	3.1480960065461287e+09
C45_100	45	100	2.8125533016110902e-16
R45_102	45	102	9.2421578754015141e+09
C45_102	45	102	9.5802170189776616e-17
R46_47	46	47	7.1766537945231876e+00
C46_47	46	47	1.9739980346775496e-16
R46_48	46	48	4.3082859418246722e+00
C46_48	46	48	1.5756174838059943e-16
R46_57	46	57	5.0302435303593330e+09
C46_57	46	57	1.7601906873020735e-16
R46_64	46	64	6.2242547736563756e+00
C46_64	46	64	1.5647827640639722e-16
R46_65	46	65	9.6349987293105706e+00
C46_65	46	65	1.0108570704147158e-16
R46_76	46	76	3.1958243899185424e+09
C46_76	46	76	2.7705489215650185e-16
R46_63	46	63	6.4188292466148262e+09
C46_63	46	63	1.3794085302502070e-16
R46_99	46	99	4.5266438394430208e+09
C46_99	46	99	1.9560160090018172e-16
R46_107	46	107	3.2309874436620102e+09
C46_107	46	107	2.7403968512377254e-16
R47_48	47	48	4.7560554700025852e+00
C47_48	47	48	2.9786659502401151e-16
R47_50	47	50	1.8909465578949131e+01
C47_50	47	50	5.1506514281413440e-17
R47_51	47	51	3.5805607882975407e+09
C47_51	47	51	2.4728494614414650e-16
R47_99	47	99	6.0486300922473326e+09
C47_99	47	99	1.4638335758618494e-16
R47_107	47	107	6.2219985666895533e+09
C47_107	47	107	1.4230456214506839e-16
R48_49	48	49	2.3064827393120422e+00
C48_49	48	49	3.8388268275707769e-17
R48_50	48	50	2.9053540084982585e+00
C48_50	48	50	2.5904105375081585e-16
R48_51	48	51	2.8493330573631606e+09
C48_51	48	51	3.1074597594406431e-16
R48_64	48	64	3.7627977935179548e+00
C48_64	48	64	2.5883948921567048e-16
R48_107	48	107	2.2602380710329828e+09
C48_107	48	107	3.9173695596382127e-16
R48_108	48	108	7.9210939041549599e+08
C48_108	48	108	1.1177986177332894e-15
R48_109	48	109	4.0464225875883573e+00
C48_109	48	109	2.4069672354130314e-16
R49_50	49	50	6.5168961098223335e+00
C49_50	49	50	1.3586510614546822e-17
R49_64	49	64	2.6497415821743524e+00
C49_64	49	64	3.3415288028707848e-17
R49_52	49	52	5.2135168878578613e+00
C49_52	49	52	1.6983138268183542e-17
R49_109	49	109	8.6891948130964602e-01
C49_109	49	109	1.0189882960910097e-16
R50_51	50	51	3.7088721501459236e+09
C50_51	50	51	2.3872992809017795e-16
R50_108	50	108	5.2588858324815454e+09
C50_108	50	108	1.6836623001610050e-16
R50_109	50	109	1.7857383193713577e+01
C50_109	50	109	1.0412384713264185e-16
R50_110	50	110	4.6800533405943089e+09
C50_110	50	110	1.8918989106811394e-16
R50_104	50	104	1.4464480415836945e+10
C50_104	50	104	6.1213314010959435e-17
R51_105	51	105	3.1646266572014832e+09
C51_105	51	105	2.7978617309726706e-16
R51_99	51	99	6.3983228844976654e+09
C51_99	51	99	1.3838294779484461e-16
R51_107	51	107	1.9090855367045534e+09
C51_107	51	107	4.6379209557493288e-16
R51_108	51	108	3.4365445190192890e+09
C51_108	51	108	2.5764798820434844e-16
R51_110	51	110	2.3762930483581777e+09
C51_110	51	110	3.7260504646586050e-16
R51_104	51	104	3.6799164002957406e+09
C51_104	51	104	2.4060839578552449e-16
R52_64	52	64	4.1210239086252400e+00
C52_64	52	64	2.1485407542694237e-17
R52_78	52	78	2.9779184713106424e+00
C52_78	52	78	2.9732808007678915e-17
R52_53	52	53	8.2593395925568256e+00
C52_53	52	53	1.0720212818200673e-17
R52_109	52	109	1.0324174490696025e+01
C52_109	52	109	8.5761702545605437e-18
R52_111	52	111	1.3765565987594701e+00
C52_111	52	111	6.4321276909204079e-17
R53_78	53	78	3.6064582682579984e+00
C53_78	53	78	2.4550922701447964e-17
R53_85	53	85	3.8182350630856825e+00
C53_85	53	85	2.3189216144918390e-17
R53_111	53	111	1.3968565230866401e+01
C53_111	53	111	6.3386523029830298e-18
R53_112	53	112	1.8624753641155101e+00
C53_112	53	112	4.7539892272372989e-17
R53_54	53	54	2.2349704369386249e+01
C53_54	53	54	3.9616576893643927e-18
R54_103	54	103	2.1602209238086374e+00
C54_103	54	103	4.0987418089578442e-17
R54_85	54	85	5.3501150248728235e+00
C54_85	54	85	1.6549527955635817e-17
R54_86	54	86	1.7281767390469113e+01
C54_86	54	86	5.1234272611973014e-18
R54_112	54	112	1.0801104619043180e+01
C54_112	54	112	8.1974836179156934e-18
R55_56	55	56	3.8385761943046575e+09
C55_56	55	56	2.3066333371569044e-16
R55_58	55	58	5.5053200672585373e+09
C55_58	55	58	1.6082966492099134e-16
R55_60	55	60	4.0999818300730863e+09
C55_60	55	60	2.1595675746792679e-16
R55_100	55	100	3.1556967105293980e+09
C55_100	55	100	2.8057790811952353e-16
R55_101	55	101	3.3935228491340027e+09
C55_101	55	101	2.6091434213444333e-16
R55_117	55	117	6.5273003050598898e+09
C55_117	55	117	1.3564854385719521e-16
R55_119	55	119	1.9324735354025347e+09
C55_119	55	119	4.5817899468184290e-16
R55_115	55	115	4.1099297455020003e+09
C55_115	55	115	2.1543404304392851e-16
R55_120	55	120	3.6911009524817586e+09
C55_120	55	120	2.3987931869072217e-16
R56_58	56	58	9.0043123994124985e+08
C56_58	56	58	9.8332747957275511e-16
R56_60	56	60	1.8024290851557019e+09
C56_60	56	60	4.9123640369102981e-16
R56_61	56	61	1.4046952341841142e+09
C56_61	56	61	6.3032803141407073e-16
R56_70	56	70	2.8045405331453691e+09
C56_70	56	70	3.1570903370292126e-16
R56_120	56	120	1.3492811038302124e+09
C56_120	56	120	6.5621520911139751e-16
R57_59	57	59	1.7018680540118959e+09
C57_59	57	59	5.2026288384270434e-16
R57_61	57	61	2.9224225973519750e+09
C57_61	57	61	3.0297424558045904e-16
R57_69	57	69	4.4713925991905699e+09
C57_69	57	69	1.9801857297439780e-16
R57_76	57	76	2.5780559437819858e+09
C57_76	57	76	3.4344436312002536e-16
R57_63	57	63	2.4873806875022769e+09
C57_63	57	63	3.5596432269042839e-16
R57_99	57	99	5.8749474107397852e+09
C57_99	57	99	1.5071092893212919e-16
R57_122	57	122	1.6328373528414767e+09
C57_122	57	122	5.4225779448221661e-16
R57_123	57	123	2.0601363191624134e+09
C57_123	57	123	4.2978650173013000e-16
R57_124	57	124	5.1075705331455107e+09
C57_124	57	124	1.7335419568933736e-16
R58_61	58	61	2.8141367093059468e+09
C58_61	58	61	3.1463246926563557e-16
R58_59	58	59	6.4598400665249519e+09
C58_59	58	59	1.3706512430365911e-16
R58_120	58	120	3.3238200637364216e+09
C58_120	58	120	2.6638589476010027e-16
R58_115	58	115	7.2457510704862328e+09
C58_115	58	115	1.2219834397934723e-16
R58_124	58	124	3.7736352307452011e+09
C58_124	58	124	2.3463284805223513e-16
R58_126	58	126	9.8399245716725235e+09
C58_126	58	126	8.9982273263452738e-17
R59_61	59	61	5.8886124210082407e+09
C59_61	59	61	1.5036119180491077e-16
R59_99	59	99	6.2788225125613642e+09
C59_99	59	99	1.4101669221078284e-16
R59_123	59	123	2.1433155769492090e+09
C59_123	59	123	4.1310705302683583e-16
R59_124	59	124	3.8731505670302105e+09
C59_124	59	124	2.2860427612523896e-16
R59_125	59	125	6.5907150339296980e+09
C59_125	59	125	1.3434335685001864e-16
R59_126	59	126	4.3947215285230732e+09
C59_126	59	126	2.0147323919237299e-16
R60_70	60	70	1.0914830387726014e+09
C60_70	60	70	8.1120709186253102e-16
R60_72	60	72	1.3490115855752184e+09
C60_72	60	72	6.5634631397361759e-16
R60_100	60	100	2.0857073150747204e+09
C60_100	60	100	4.2451727301358197e-16
R60_102	60	102	2.5599588023200989e+09
C60_102	60	102	3.4587227767007114e-16
R60_118	60	118	1.8193108908249350e+09
C60_118	60	118	4.8667810771941367e-16
R60_119	60	119	2.6331411277519512e+09
C60_119	60	119	3.3625952379389858e-16
R60_120	60	120	9.4175064638608396e+08
C60_120	60	120	9.4018388529675637e-16
R60_128	60	128	2.8364092217855434e+09
C60_128	60	128	3.1216186116565419e-16
R61_69	61	69	1.1913685481178982e+09
C61_69	61	69	7.4319469243901760e-16
R61_70	61	70	1.9294190692534139e+09
C61_70	61	70	4.5890433851812807e-16
R61_120	61	120	1.3708596745261123e+09
C61_120	61	120	6.4588578842402482e-16
R61_122	61	122	3.2850706731885600e+09
C61_122	61	122	2.6952807710544433e-16
R61_124	61	124	1.9624186271853926e+09
C61_124	61	124	4.5118751393524830e-16
R61_128	61	128	2.0384230449992988e+09
C61_128	61	128	4.3436458583615783e-16
R62_65	62	65	8.1404770495630689e+00
C62_65	62	65	1.7402789049949270e-16
R62_75	62	75	1.7522078500639124e+09
C62_75	62	75	5.0531606833498907e-16
R62_77	62	77	1.1483110989872538e+01
C62_77	62	77	1.2336988206805795e-16
R62_81	62	81	3.2824194344422217e+00
C62_81	62	81	2.9672035471041000e-16
R62_88	62	88	5.2016917954133133e+00
C62_88	62	88	1.3050005502363974e-16
R62_90	62	90	3.2283990815694842e+09
C62_90	62	90	2.7425939585807167e-16
R62_91	62	91	2.2990150898321834e+09
C62_91	62	91	3.8512960859453571e-16
R62_130	62	130	5.0029733614033251e+09
C62_130	62	130	1.7697851212456620e-16
R63_76	63	76	2.3923347837488098e+09
C63_76	63	76	3.7010655352865829e-16
R63_99	63	99	2.5719622712741179e+09
C63_99	63	99	3.4425807547378010e-16
R63_107	63	107	3.4618509587495003e+09
C63_107	63	107	2.5576455839676979e-16
R63_106	63	106	1.1488786044155979e+09
C63_106	63	106	7.7068088682040310e-16
R63_122	63	122	4.1404043833783431e+09
C63_122	63	122	2.1384838284263114e-16
R63_121	63	121	1.9983365350496514e+09
C63_121	63	121	4.4307791313939047e-16
R63_123	63	123	1.5220166548426731e+09
C63_123	63	123	5.8174053410179239e-16
R63_125	63	125	4.8480782445359678e+09
C63_125	63	125	1.8263293970098610e-16
R63_127	63	127	1.7434226938652906e+09
C63_127	63	127	5.0786237027634665e-16
R63_116	63	116	1.9902474235087204e+09
C63_116	63	116	4.4487874785891936e-16
R63_132	63	132	2.4122819634267917e+09
C63_132	63	132	3.6704613935023147e-16
R64_65	64	65	5.7353697192477346e+00
C64_65	64	65	1.6981654306041605e-16
R64_76	64	76	5.4383681287490854e+09
C64_76	64	76	1.6280964449967477e-16
R64_78	64	78	3.3524480779274684e+00
C64_78	64	78	2.6411110958872138e-17
R64_79	64	79	4.3525364394654229e+00
C64_79	64	79	2.2376852496050800e-16
R64_107	64	107	3.7793505111889749e+09
C64_107	64	107	2.3427802715801809e-16
R64_108	64	108	2.1609385007419662e+09
C64_108	64	108	4.0973807509838356e-16
R64_109	64	109	4.9424836588665846e+00
C64_109	64	109	1.3734411934770475e-16
R64_111	64	111	4.8299962092628510e+00
C64_111	64	111	2.6275388159601788e-16
R64_114	64	114	7.4823753144408149e+00
C64_114	64	114	1.3016730890474278e-16
R64_131	64	131	3.3592967495728507e+09
C64_131	64	131	2.6357266050181037e-16
R64_133	64	133	1.6730489812188120e+09
C64_133	64	133	5.2922466206277769e-16
R64_134	64	134	3.4870582929819779e+09
C64_134	64	134	2.5391568115795076e-16
R65_75	65	75	2.8996646147563972e+09
C65_75	65	75	3.0535213527595664e-16
R65_76	65	76	5.6211311465291095e+08
C65_76	65	76	1.5751612239944297e-15
R65_79	65	79	2.2594331532877407e+00
C65_79	65	79	3.0043865848816474e-16
R65_80	65	80	2.3291352422645160e+00
C65_80	65	80	3.8014914962136171e-17
R65_81	65	81	1.7227578708928633e+00
C65_81	65	81	4.3686113794417820e-16
R65_130	65	130	2.3625609437270350e+09
C65_130	65	130	3.7477076900425542e-16
R65_134	65	134	1.4347954304189348e+09
C65_134	65	134	6.1710454530892511e-16
R66_67	66	67	2.8547483761129300e+00
C66_67	66	67	3.4117215620320259e-16
R66_68	66	68	5.6339125783335513e+00
C66_68	66	68	2.5145403463360624e-16
R66_71	66	71	2.4736562916914477e+09
C66_71	66	71	3.5793929200024975e-16
R66_73	66	73	1.1852822717782791e+09
C66_73	66	73	7.4701090430687537e-16
R66_74	66	74	2.7150729455442066e+09
C66_74	66	74	3.2611233637500942e-16
R66_77	66	77	4.8648150056686967e+00
C66_77	66	77	1.3953687133559251e-16
R66_89	66	89	8.9754340724283206e+08
C66_89	66	89	9.8649132126090969e-16
R66_135	66	135	3.2548289471058593e+09
C66_135	66	135	2.7203235441521433e-16
R67_68	67	68	8.4145195740727345e+00
C67_68	67	68	6.3135068387183286e-17
R67_72	67	72	3.4749045569829426e+09
C67_72	67	72	2.5480377005484085e-16
R67_73	67	73	3.8237308711174469e+09
C67_73	67	73	2.3155886529253705e-16
R67_102	67	102	8.8384213294015064e+09
C67_102	67	102	1.0017838578871598e-16
R67_135	67	135	4.2845075877456799e+09
C67_135	67	135	2.0665590235676740e-16
R68_74	68	74	1.1746569254250307e+09
C68_74	68	74	7.5376798325998513e-16
R68_97	68	97	3.6822391178326569e+09
C68_97	68	97	2.4045662255121333e-16
R68_135	68	135	4.2015997445676866e+09
C68_135	68	135	2.1073372894330824e-16
R69_70	69	70	1.1065338800751426e+09
C69_70	69	70	8.0017322347136156e-16
R69_71	69	71	2.2516116254390168e+09
C69_71	69	71	3.9323779096555427e-16
R69_75	69	75	6.2032239325887668e+08
C69_75	69	75	1.4273526013601312e-15
R69_76	69	76	2.1242710497142718e+09
C69_76	69	76	4.1681064279395728e-16
R69_122	69	122	6.4950203965143824e+08
C69_122	69	122	1.3632270996025951e-15
R69_128	69	128	9.8872047051905000e+08
C69_128	69	128	8.9551982395507646e-16
R69_129	69	129	1.8047396440376740e+09
C69_129	69	129	4.9060748713819305e-16
R69_136	69	136	2.2116059134301143e+09
C69_136	69	136	4.0035106450169973e-16
R70_71	70	71	1.4829396878081496e+09
C70_71	70	71	5.9706998806451011e-16
R70_72	70	72	1.6927695925150020e+09
C70_72	70	72	5.2305924303880314e-16
R70_73	70	73	2.9965886199207196e+09
C70_73	70	73	2.9547558707722294e-16
R70_120	70	120	2.4135599150467696e+09
C70_120	70	120	3.6685179273158526e-16
R70_128	70	128	1.0967315709944932e+09
C70_128	70	128	8.0732496913271209e-16
R70_136	70	136	2.4601845632565570e+09
C70_136	70	136	3.5989933231999783e-16
R71_73	71	73	1.5774996499107695e+09
C71_73	71	73	5.6127985939653516e-16
R71_75	71	75	4.8326637110788050e+09
C71_75	71	75	1.8321547590207689e-16
R71_89	71	89	2.5839287846331253e+09
C71_89	71	89	3.4266377114016122e-16
R71_90	71	90	3.5860709659374442e+09
C71_90	71	90	2.4690498043965523e-16
R71_136	71	136	1.5729418954816806e+09
C71_136	71	136	5.6290622320086337e-16
R72_73	72	73	6.6964751291439176e+08
C72_73	72	73	1.3222161878068420e-15
R72_102	72	102	1.8807992012492895e+09
C72_102	72	102	4.7076731057301342e-16
R72_118	72	118	2.0117246806254532e+09
C72_118	72	118	4.4012920367647906e-16
R72_128	72	128	5.6154282758271542e+09
C72_128	72	128	1.5767609133420505e-16
R72_135	72	135	4.9888062603596601e+09
C72_135	72	135	1.7748109176646339e-16
R72_136	72	136	3.2787643548474393e+09
C72_136	72	136	2.7004648272175034e-16
R72_137	72	137	4.5507551022488089e+09
C72_137	72	137	1.9456524506503546e-16
R73_89	73	89	8.9490354812550545e+08
C73_89	73	89	9.8940135342476568e-16
R73_135	73	135	1.9025251614517386e+09
C73_135	73	135	4.6539136492911001e-16
R73_136	73	136	1.3051377831424682e+09
C73_136	73	136	6.7841019786287806e-16
R73_137	73	137	1.9160857026909840e+09
C73_137	73	137	4.6209769242393623e-16
R74_89	74	89	2.2360182452470460e+09
C74_89	74	89	3.9598012385725181e-16
R74_94	74	94	2.5692835007080560e+09
C74_94	74	94	3.4461700371173208e-16
R74_96	74	96	2.5738310083022118e+09
C74_96	74	96	3.4400812595853097e-16
R74_97	74	97	1.1512125399527137e+09
C74_97	74	97	7.6911843032596625e-16
R74_135	74	135	3.0230255989082284e+09
C74_135	74	135	2.9289159245617061e-16
R74_138	74	138	1.7400733212886553e+09
C74_138	74	138	5.0883992695450368e-16
R75_76	75	76	1.3387844981912255e+09
C75_76	75	76	6.6136019866995145e-16
R75_90	75	90	8.3017557311167634e+08
C75_90	75	90	1.0665440063253854e-15
R75_91	75	91	2.2659811909056230e+09
C75_91	75	91	3.9074410028360976e-16
R75_122	75	122	1.9620974951935160e+09
C75_122	75	122	4.5126135875968476e-16
R75_121	75	121	2.5665680182757859e+09
C75_121	75	121	3.4498161568101454e-16
R75_129	75	129	1.6933791978944089e+09
C75_129	75	129	5.2287094514976483e-16
R75_130	75	130	1.0677876446349946e+09
C75_130	75	130	8.2920867847526544e-16
R75_136	75	136	2.2012871164364843e+09
C75_136	75	136	4.0222775806426608e-16
R75_139	75	139	1.1722994580764010e+09
C75_139	75	139	7.5528379340280794e-16
R76_107	76	107	4.7492275180266142e+09
C76_107	76	107	1.8643427343483155e-16
R76_122	76	122	1.7784751659282057e+09
C76_122	76	122	4.9785276660744953e-16
R76_121	76	121	1.8409465223841879e+09
C76_121	76	121	4.8095844769749459e-16
R76_130	76	130	2.4367411611284590e+09
C76_130	76	130	3.6336185222478094e-16
R76_132	76	132	2.7269031663754764e+09
C76_132	76	132	3.2469755164679139e-16
R76_133	76	133	5.4408863930172949e+09
C76_133	76	133	1.6273428955185054e-16
R76_134	76	134	1.4812552070967305e+09
C76_134	76	134	5.9774897496254310e-16
R76_140	76	140	4.0023215716348438e+09
C76_140	76	140	2.2122629725085522e-16
R77_83	77	83	5.2955950594283836e+00
C77_83	77	83	1.6719911015922235e-17
R77_88	77	88	5.8135595294726308e+00
C77_88	77	88	1.6753258549403566e-16
R77_89	77	89	2.5533309168412433e+09
C77_89	77	89	3.4677008603152872e-16
R77_90	77	90	2.8020281136629205e+09
C77_90	77	90	3.1599211206433840e-16
R77_91	77	91	5.9639959306780968e+09
C77_91	77	91	1.4846066160868914e-16
R77_92	77	92	5.8631864570342023e+00
C77_92	77	92	1.6611456347726344e-16
R77_93	77	93	9.7231853345859971e+00
C77_93	77	93	1.0016888760019809e-16
R77_94	77	94	1.5962564578491108e+09
C77_94	77	94	5.5468454166385343e-16
R77_95	77	95	3.5341152916931133e+09
C77_95	77	95	2.5053477564276527e-16
R77_141	77	141	2.6558634386883731e+09
C77_141	77	141	3.3338264641245025e-16
R78_79	78	79	1.8026917891035934e+00
C78_79	78	79	4.9116481644390433e-17
R78_80	78	80	1.8465473647337598e+00
C78_80	78	80	4.7949963191313104e-17
R78_82	78	82	3.6359366779915074e+00
C78_82	78	82	2.4351875736986311e-17
R78_85	78	85	1.5842264402846178e+00
C78_85	78	85	5.5889660668769547e-17
R78_111	78	111	2.7485052184570851e+00
C78_111	78	111	3.2214557052834821e-17
R78_112	78	112	2.4601875096812713e+00
C78_112	78	112	3.5989890128932081e-17
R78_87	78	87	2.6310213808149183e+00
C78_87	78	87	3.3653043953058075e-17
R78_114	78	114	1.6389490058971065e-01
C78_114	78	114	5.4023571112595464e-16
R78_144	78	144	2.3372049232744136e+00
C78_144	78	144	3.7883660644507463e-17
R79_80	79	80	4.5712535794209752e-01
C79_80	79	80	1.9369277295969939e-16
R79_81	79	81	1.6880367051088347e+00
C79_81	79	81	8.3924125838463717e-16
R79_114	79	114	2.5135780336420130e+00
C79_114	79	114	5.6360694978796085e-16
R79_131	79	131	1.9029021917646887e+09
C79_131	79	131	4.6529915490763705e-16
R79_113	79	113	2.0609666641971505e+09
C79_113	79	113	4.2961334459279802e-16
R79_134	79	134	1.1922691156198440e+09
C79_134	79	134	7.4263332841569356e-16
R79_142	79	142	1.2117561526258829e+09
C79_142	79	142	7.3069055996232592e-16
R79_144	79	144	2.2199021346660515e+00
C79_144	79	144	4.3874035872421755e-16
R80_81	80	81	9.8260580961544663e-01
C80_81	80	81	9.0109255719393540e-17
R80_82	80	82	1.6892078401717381e+00
C80_82	80	82	5.2416213129225201e-17
R80_144	80	144	2.3477832361210482e+00
C80_144	80	144	3.7712969752815331e-17
R81_82	81	82	3.0649290167062109e+00
C81_82	81	82	2.8888720648138654e-17
R81_88	81	88	2.8283283743162007e+00
C81_88	81	88	3.4435911605614473e-16
R81_91	81	91	2.9209713591775498e+09
C81_91	81	91	3.0312477351688407e-16
R81_130	81	130	2.0089909489756887e+09
C81_130	81	130	4.4072810888045206e-16
R81_134	81	134	3.2114767808061175e+09
C81_134	81	134	2.7570455654290912e-16
R81_142	81	142	2.1991639502042518e+09
C81_142	81	142	4.0261608581650539e-16
R81_144	81	144	3.1852158399956783e+00
C81_144	81	144	3.0577540355863640e-16
R81_145	81	145	2.2326195717360740e+09
C81_145	81	145	3.9658291672660683e-16
R82_85	82	85	4.0442461350909671e+00
C82_85	82	85	2.1893296108202485e-17
R82_88	82	88	4.1371405293255092e+00
C82_88	82	88	2.1401709113428466e-17
R82_83	82	83	5.6898811392562818e+00
C82_83	82	83	1.5561287837653005e-17
R82_144	82	144	6.2366724020258735e-01
C82_144	82	144	1.4196974357870511e-16
R82_86	82	86	5.6471561291570600e+00
C82_86	82	86	1.5679020757518257e-17
R82_84	82	84	8.9234039660756821e+00
C82_84	82	84	9.9224330206961123e-18
R82_146	82	146	4.4388376367252222e+00
C82_146	82	146	1.9947086470890221e-17
R83_88	83	88	4.9393454507350437e-01
C83_88	83	88	1.7925832289544304e-16
R83_92	83	92	2.3357805213890455e+00
C83_92	83	92	3.7906762796936840e-17
R83_84	83	84	3.4021478160916074e+00
C83_84	83	84	2.6025288422569795e-17
R83_146	83	146	3.2865292625132501e+00
C83_146	83	146	2.6940845827823521e-17
R84_92	84	92	7.1658179869357985e+00
C84_92	84	92	1.2356143894726763e-17
R84_146	84	146	9.5544239825810562e-01
C84_146	84	146	9.2671079210450814e-17
R84_86	84	86	1.1465308779097265e+01
C84_86	84	86	7.7225899342042345e-18
R85_103	85	103	1.0253802709512863e+01
C85_103	85	103	8.6350284551365680e-18
R85_86	85	86	6.7562991292574530e+00
C85_86	85	86	1.3105085561795004e-17
R85_87	85	87	2.1911052411068286e+00
C85_87	85	87	4.0409687544388970e-17
R85_112	85	112	6.6331135194117365e+00
C85_112	85	112	1.3348464173104098e-17
R85_144	85	144	7.7841030542106431e+00
C85_144	85	144	1.1374705287606023e-17
R85_147	85	147	9.4747114378066382e+00
C85_147	85	147	9.3450738580485077e-18
R86_103	86	103	2.5951333648869547e+01
C86_103	86	103	3.4118430816697912e-18
R86_144	86	144	1.2247673028537315e+01
C86_144	86	144	7.2292816736449202e-18
R86_146	86	146	1.7300889099246358e+01
C86_146	86	146	5.1177646225046885e-18
R86_147	86	147	3.4601778198492710e+00
C86_147	86	147	2.5588823112523446e-17
R87_112	87	112	8.9217119153774256e+00
C87_112	87	112	1.0916746338976995e-16
R87_103	87	103	2.1614380230838751e+01
C87_103	87	103	6.5542941017283162e-17
R87_114	87	114	1.6957295959303725e+01
C87_114	87	114	5.7436083042572015e-17
R87_113	87	113	5.6355599196039734e+09
C87_113	87	113	1.5711283250133925e-16
R87_144	87	144	1.1056488859640552e+01
C87_144	87	144	8.8089507551649886e-17
R87_147	87	147	1.4082224014979500e+01
C87_147	87	147	1.0059988018143011e-16
R87_148	87	148	9.0558796562291775e+09
C87_148	87	148	9.7772807867533423e-17
R87_149	87	149	1.0710724071867428e+10
C87_149	87	149	8.2666566308586281e-17
R87_150	87	150	1.1964739365746170e+10
C87_150	87	150	7.4002345946194508e-17
R88_91	88	91	2.0664128278858910e+09
C88_91	88	91	4.2848107103838285e-16
R88_92	88	92	8.2710117238019993e+00
C88_92	88	92	1.7128134935634982e-16
R88_141	88	141	2.5175562871586576e+09
C88_141	88	141	3.5169771028209818e-16
R88_144	88	144	8.0289083803581089e+00
C88_144	88	144	1.2130673470863527e-16
R88_145	88	145	1.9076401450003340e+09
C88_145	88	145	4.6414350422461111e-16
R88_146	88	146	4.9055003447032677e+00
C88_146	88	146	1.9854461124392281e-16
R88_151	88	151	5.8440868848475504e+09
C88_151	88	151	1.5150677927046208e-16
R89_90	89	90	1.5990093510348349e+09
C89_90	89	90	5.5372958333669605e-16
R89_94	89	94	1.8575009571700299e+09
C89_94	89	94	4.7667204599935586e-16
R89_95	89	95	1.3211326435407345e+09
C89_95	89	95	6.7019673310547463e-16
R89_135	89	135	2.9293200938043914e+09
C89_135	89	135	3.0226085007667481e-16
R89_136	89	136	2.0837169971417961e+09
C89_136	89	136	4.2492276202311337e-16
R89_137	89	137	2.1482243760848451e+09
C89_137	89	137	4.1216308294279868e-16
R89_138	89	138	1.5206018873652365e+09
C89_138	89	138	5.8228178529633071e-16
R89_153	89	153	2.0223460234405906e+09
C89_153	89	153	4.3781764912497454e-16
R90_91	90	91	1.2228049063992517e+09
C90_91	90	91	7.2408834562764377e-16
R90_95	90	95	2.9930054293853545e+09
C90_95	90	95	2.9582932693905278e-16
R90_136	90	136	2.6819546385037079e+09
C90_136	90	136	3.3013935768652108e-16
R90_139	90	139	2.5374682798466096e+09
C90_139	90	139	3.4893787194593959e-16
R90_141	90	141	2.2765202285770111e+09
C90_141	90	141	3.8893516981988358e-16
R90_153	90	153	2.1593335937610593e+09
C90_153	90	153	4.1004260956168687e-16
R90_154	90	154	3.5884716891839237e+09
C90_154	90	154	2.4673979855233535e-16
R91_130	91	130	1.3192356627509291e+09
C91_130	91	130	6.7116043531880084e-16
R91_139	91	139	3.3386085410580983e+09
C91_139	91	139	2.6520592959945708e-16
R91_141	91	141	1.0505300830487223e+09
C91_141	91	141	8.4283048718647280e-16
R91_145	91	145	1.3783795456982019e+09
C91_145	91	145	6.4236210154402844e-16
R91_154	91	154	1.2851705225595243e+09
C91_154	91	154	6.8895042810086786e-16
R92_93	92	93	8.3743128563479807e+00
C92_93	92	93	1.1630335235896377e-16
R92_94	92	94	5.3394595842337160e+09
C92_94	92	94	1.6582554240403888e-16
R92_141	92	141	3.9761702451026306e+09
C92_141	92	141	2.2268130565851714e-16
R92_146	92	146	8.3743128605351327e+00
C92_146	92	146	6.3438192195798441e-17
R92_151	92	151	4.6730220071671505e+09
C92_151	92	151	1.8947455850668095e-16
R92_156	92	156	5.7809036041469793e+09
C92_156	92	156	1.5316269606447640e-16
R93_94	93	94	2.4230588594614334e+09
C93_94	93	94	3.6541364987592578e-16
R93_96	93	96	3.5326701526344180e+09
C93_96	93	96	2.5063726400827914e-16
R93_156	93	156	8.4603344601491966e+09
C93_156	93	156	1.0465529298759968e-16
R94_95	94	95	5.4331556465378845e+08
C94_95	94	95	1.6296584145609863e-15
R94_96	94	96	1.4835260430483239e+09
C94_96	94	96	5.9683399954385493e-16
R94_138	94	138	1.7783227489833648e+09
C94_138	94	138	4.9789543670077770e-16
R94_141	94	141	3.0116816278183856e+09
C94_141	94	141	2.9399481456523794e-16
R94_156	94	156	1.0052070035314813e+09
C94_156	94	156	8.8083228488197688e-16
R94_157	94	157	1.3137111931432745e+09
C94_157	94	157	6.7398282538910785e-16
R95_138	95	138	5.1228165371592121e+09
C95_138	95	138	1.7283827661550357e-16
R95_141	95	141	2.8259755214598842e+09
C95_141	95	141	3.1331438470585108e-16
R95_153	95	153	2.3497250654206595e+09
C95_153	95	153	3.7681803489698407e-16
R95_155	95	155	3.5560798132625203e+09
C95_155	95	155	2.4898731980024767e-16
R95_156	95	156	6.1269844136107550e+09
C95_156	95	156	1.4451134880204553e-16
R95_157	95	157	2.6540526423773904e+09
C95_157	95	157	3.3361010537714083e-16
R96_97	96	97	2.0290890805432119e+09
C96_97	96	97	4.3636269604435640e-16
R96_98	96	98	2.9105984593032455e+09
C96_98	96	98	3.0420506094542368e-16
R96_138	96	138	2.6844846675859408e+09
C96_138	96	138	3.2982821335918638e-16
R96_156	96	156	3.6796881842645326e+09
C96_156	96	156	2.4062331843396960e-16
R96_157	96	157	2.2993689761522603e+09
C96_157	96	157	3.8507033489755542e-16
R96_158	96	158	2.1874833552876444e+09
C96_158	96	158	4.0476595150300994e-16
R97_98	97	98	2.4649553088110986e+09
C97_98	97	98	3.5920277277848776e-16
R97_135	97	135	4.6683852524310741e+09
C97_135	97	135	1.8966274928550850e-16
R97_138	97	138	2.4194350497627130e+09
C97_138	97	138	3.6596096340211230e-16
R97_152	97	152	3.6047907953788033e+09
C97_152	97	152	2.4562279254459690e-16
R97_158	97	158	5.8990321367824640e+09
C97_158	97	158	1.5009560232417007e-16
R98_152	98	152	1.4621077803846582e+10
C98_152	98	152	6.0557695785399606e-17
R98_158	98	158	9.1471628970528755e+09
C98_158	98	158	9.6797093444708755e-17
R98_159	98	159	3.2155942628371796e+10
C98_159	98	159	2.7535152426810786e-17
R99_105	99	105	4.2633859766749082e+09
C99_105	99	105	2.0767971432662873e-16
R99_107	99	107	1.9274369390263093e+09
C99_107	99	107	4.5937626480651063e-16
R99_106	99	106	1.8764248100151627e+09
C99_106	99	106	4.7186478081839336e-16
R99_123	99	123	4.8871033182244101e+09
C99_123	99	123	1.8117455761538758e-16
R99_125	99	125	3.7575114904437218e+09
C99_125	99	125	2.3563967374466812e-16
R99_160	99	160	6.6344803072051115e+09
C99_160	99	160	1.3345714218767468e-16
R100_101	100	101	2.8408752166774712e+09
C100_101	100	101	3.1167112744062593e-16
R100_102	100	102	3.4637876750861630e+09
C100_102	100	102	2.5562155211432661e-16
R100_118	100	118	2.7270532727252183e+09
C100_118	100	118	3.2467967918176274e-16
R100_119	100	119	1.4498840354227839e+09
C100_119	100	119	6.1068248223163134e-16
R100_163	100	163	1.8478928730782430e+09
C100_163	100	163	4.7915049329946183e-16
R100_164	100	164	3.6723651983927002e+09
C100_164	100	164	2.4110314031064370e-16
R101_119	101	119	4.1805047652852898e+09
C101_119	101	119	2.1179709901361078e-16
R101_117	101	117	3.5407389257602658e+09
C101_117	101	117	2.5006610209474376e-16
R101_164	101	164	2.6817998661087890e+09
C101_164	101	164	3.3015841073357799e-16
R101_165	101	165	1.1459492083214312e+10
C101_165	101	165	7.7265098249594137e-17
R102_118	102	118	1.3852819564099834e+09
C102_118	102	118	6.3916141952400799e-16
R102_135	102	135	6.0525151991930838e+09
C102_135	102	135	1.4628939417088011e-16
R102_163	102	163	7.2876550544435263e+09
C102_163	102	163	1.2149570404819459e-16
R102_166	102	166	7.9363944833040400e+09
C102_166	102	166	1.1156436131831327e-16
R103_112	103	112	8.8877985216640063e+00
C103_112	103	112	5.9773099880634071e-17
R103_147	103	147	8.8877985216640099e+00
C103_147	103	147	5.9773099880634047e-17
R103_148	103	148	5.2894010241830797e+09
C103_148	103	148	1.6739490495273010e-16
R103_149	103	149	4.9787790528538542e+09
C103_149	103	149	1.7783853677790233e-16
R103_168	103	168	1.4398233612294807e+10
C103_168	103	168	6.1494958724932154e-17
R104_110	104	110	2.3598954920588393e+09
C104_110	104	110	3.7519406460136753e-16
R104_105	104	105	4.5276320786451950e+09
C104_105	104	105	1.9555890724339604e-16
R104_170	104	170	5.9499267194803114e+09
C104_170	104	170	1.4881171205035210e-16
R104_172	104	172	1.4571363872513006e+10
C104_172	104	172	6.0764303839136724e-17
R105_107	105	107	3.0050883485040164e+09
C105_107	105	107	2.9463985048585230e-16
R105_106	105	106	3.0216638379942422e+09
C105_106	105	106	2.9302358871519420e-16
R105_110	105	110	6.5351402438198767e+09
C105_110	105	110	1.3548581188250995e-16
R105_160	105	160	4.3968504941766853e+09
C105_160	105	160	2.0137568536220959e-16
R105_169	105	169	4.4317102639988136e+09
C105_169	105	169	1.9979166708905522e-16
R105_170	105	170	3.4078623055831809e+09
C105_170	105	170	2.5981647798662452e-16
R105_171	105	171	4.4977534304886255e+09
C105_171	105	171	1.9685800819984263e-16
R105_172	105	172	3.9059590027066560e+09
C105_172	105	172	2.2668409501647203e-16
R105_173	105	173	2.4953693767374349e+09
C105_173	105	173	3.5482473655168393e-16
R106_107	106	107	1.7841468765289271e+09
C106_107	106	107	4.9627011842354022e-16
R106_125	106	125	4.7739253128695230e+09
C106_125	106	125	1.8546975992965217e-16
R106_127	106	127	1.1447093822683291e+09
C106_127	106	127	7.7348783491708181e-16
R106_116	106	116	5.2673130406073093e+08
C106_116	106	116	1.6809685979816253e-15
R106_132	106	132	2.3275916196170487e+09
C106_132	106	132	3.8040125863903705e-16
R106_160	106	160	1.7941775640893278e+09
C106_160	106	160	4.9349562686645943e-16
R106_169	106	169	1.3081055146359298e+09
C106_169	106	169	6.7687107178538934e-16
R106_173	106	173	1.8565071309698639e+09
C106_173	106	173	4.7692721828514907e-16
R107_108	107	108	1.2856778375512631e+09
C107_108	107	108	6.8867857548699188e-16
R107_110	107	110	3.4957573763159566e+09
C107_110	107	110	2.5328381989516354e-16
R107_132	107	132	2.6378634083662658e+09
C107_132	107	132	3.3565755485738949e-16
R107_133	107	133	1.6573074415251329e+09
C107_133	107	133	5.3425137636816229e-16
R107_170	107	170	5.4202411714981060e+09
C107_170	107	170	1.6335413013647846e-16
R107_173	107	173	2.3001879464843655e+09
C107_173	107	173	3.8493323254444682e-16
R107_175	107	175	5.0027605709458017e+09
C107_175	107	175	1.7698603983612316e-16
R108_109	108	109	1.3131675119573710e+09
C108_109	108	109	6.7426186959211286e-16
R108_110	108	110	1.3817979245414827e+09
C108_110	108	110	6.4077298566923657e-16
R108_111	108	111	7.8229354676832552e+09
C108_111	108	111	1.1318242178497924e-16
R108_133	108	133	3.2567488096320672e+09
C108_133	108	133	2.7187199058192968e-16
R108_175	108	175	3.0233071757019305e+09
C108_175	108	175	2.9286431389308956e-16
R109_110	109	110	5.3423074574739742e+09
C109_110	109	110	1.6573714424864951e-16
R109_111	109	111	1.7222367698401062e+01
C109_111	109	111	1.0796305539475088e-16
R109_175	109	175	9.3154792376089382e+09
C109_175	109	175	9.5048119277142623e-17
R110_170	110	170	2.8697509217920537e+09
C110_170	110	170	3.0853506308731792e-16
R110_175	110	175	4.4902690044081755e+09
C110_175	110	175	1.9718613313161614e-16
R111_112	111	112	9.0655975946464817e+00
C111_112	111	112	5.8600799694450909e-17
R111_114	111	114	6.9007265872414338e+00
C111_114	111	114	2.0529288194293025e-16
R111_131	111	131	4.7852986164036322e+09
C111_131	111	131	1.8502895068342300e-16
R111_133	111	133	7.6840689310596991e+09
C111_133	111	133	1.1522785514339383e-16
R111_175	111	175	5.4058447147767601e+09
C111_175	111	175	1.6378916310335866e-16
R111_176	111	176	6.3154781322472391e+09
C111_176	111	176	1.4019821827566698e-16
R112_114	112	114	7.7417728180777940e+00
C112_114	112	114	1.8299039275434852e-16
R112_113	112	113	5.1052274926348238e+09
C112_113	112	113	1.7343375647360874e-16
R112_148	112	148	4.2937652449878750e+09
C112_148	112	148	2.0621033782262596e-16
R112_176	112	176	7.4634510012831812e+09
C112_176	112	176	1.1863396457587398e-16
R113_114	113	114	1.1382081086136019e+09
C113_114	113	114	7.7790588118238516e-16
R113_131	113	131	1.6128506617304490e+09
C113_131	113	131	5.4897753568208360e-16
R113_142	113	142	2.3602978070439496e+09
C113_142	113	142	3.7513011241954390e-16
R113_144	113	144	2.7973893191641665e+09
C113_144	113	144	3.1651610865682244e-16
R113_148	113	148	4.5256536939431238e+09
C113_148	113	148	1.9564439561184141e-16
R113_150	113	150	1.1382081086136019e+09
C113_150	113	150	7.7790588118238506e-16
R113_176	113	176	3.3486694711136417e+09
C113_176	113	176	2.6440913005532996e-16
R114_131	114	131	3.1270042693355584e+09
C114_131	114	131	2.8315240576506737e-16
R114_144	114	144	9.9055298702813630e+00
C114_144	114	144	9.8324942900644086e-17
R114_176	114	176	6.8570518483708458e+09
C114_176	114	176	1.2912528609658465e-16
R115_117	115	117	3.3984284559193425e+09
C115_117	115	117	2.6053771417720684e-16
R115_119	115	119	4.3203594706837206e+09
C115_119	115	119	2.0494099801373186e-16
R115_120	115	120	4.1751650509971528e+09
C115_120	115	120	2.1206797117841744e-16
R115_124	115	124	3.9257623358025875e+09
C115_124	115	124	2.2554059720453861e-16
R115_126	115	126	3.3474215237079430e+09
C115_126	115	126	2.6450770404296756e-16
R115_161	115	161	8.3948022185818946e+08
C115_161	115	161	1.0547226231728552e-15
R115_162	115	162	3.1614891453076248e+09
C115_162	115	162	2.8006383732620577e-16
R115_178	115	178	4.7690516127586412e+09
C115_178	115	178	1.8565929949913727e-16
R116_127	116	127	8.0665628256863725e+08
C116_127	116	127	1.0976407186473020e-15
R116_121	116	121	3.2415574604807682e+09
C116_121	116	121	2.7314610106238257e-16
R116_132	116	132	8.8658280153746974e+08
C116_132	116	132	9.9868707148903530e-16
R116_169	116	169	1.7370454024650867e+09
C116_169	116	169	5.0972690779612267e-16
R116_173	116	173	2.4017931569310751e+09
C116_173	116	173	3.6864905670368230e-16
R116_180	116	180	8.3745119439681685e+08
C116_180	116	180	1.0572780690076300e-15
R117_119	117	119	3.3002393862925658e+09
C117_119	117	119	2.6828925967539128e-16
R117_161	117	161	5.1305274690002146e+09
C117_161	117	161	1.7257850913963463e-16
R117_164	117	164	5.2505080371985369e+09
C117_164	117	164	1.6863487788744050e-16
R117_165	117	165	4.6014184530013313e+09
C117_165	117	165	1.9242300841438902e-16
R117_178	117	178	3.4860019917258720e+09
C117_178	117	178	2.5399262071610050e-16
R117_179	117	179	6.6681047999463892e+09
C117_179	117	179	1.3278417305425655e-16
R117_182	117	182	1.7229706481844928e+09
C117_182	117	182	5.1389080982486421e-16
R118_119	118	119	2.2689386648235555e+09
C118_119	118	119	3.9023478044033201e-16
R118_120	118	120	5.9354343418859682e+09
C118_120	118	120	1.4917506128433738e-16
R118_128	118	128	4.4737773012042732e+09
C118_128	118	128	1.9791302116483511e-16
R118_135	118	135	6.6408951137593222e+09
C118_135	118	135	1.3332822857953200e-16
R118_136	118	136	4.8681078829282646e+09
C118_136	118	136	1.8188150365464021e-16
R118_137	118	137	2.3499685974971213e+09
C118_137	118	137	3.7677898446942317e-16
R118_163	118	163	1.3616764055458488e+09
C118_163	118	163	6.5024170066680892e-16
R118_166	118	166	1.2081714679460292e+09
C118_166	118	166	7.3285854300571290e-16
R118_183	118	183	2.4059222462909169e+09
C118_183	118	183	3.6801637420536066e-16
R118_184	118	184	1.2098178348061640e+09
C118_184	118	184	7.3186124078081659e-16
R119_120	119	120	9.6732579462156868e+08
C119_120	119	120	9.1532634260661701e-16
R119_161	119	161	1.7569314035350637e+09
C119_161	119	161	5.0395751360495812e-16
R119_163	119	163	2.2636089989124942e+09
C119_163	119	163	3.9115358797627236e-16
R119_164	119	164	1.4714594175514479e+09
C119_164	119	164	6.0172830534012490e-16
R119_182	119	182	1.6460688319516859e+09
C119_182	119	182	5.3789900186020186e-16
R119_183	119	183	8.3735042798512602e+08
C119_183	119	183	1.0574053014226535e-15
R119_184	119	184	1.6399434201724396e+09
C119_184	119	184	5.3990812781022564e-16
R119_185	119	185	3.8239432815598750e+09
C119_185	119	185	2.3154600277931352e-16
R120_124	120	124	1.1113802223697028e+09
C120_124	120	124	7.9668394657239418e-16
R120_128	120	128	5.5940557273117638e+08
C120_128	120	128	1.5827850576767312e-15
R120_161	120	161	3.0170206600905662e+09
C120_161	120	161	2.9347455037759703e-16
R120_184	120	184	4.4563717686471758e+09
C120_184	120	184	1.9868602254627133e-16
R120_185	120	185	3.5938692576026006e+09
C120_185	120	185	2.4636922443045282e-16
R121_122	121	122	1.3412262504517243e+09
C121_122	121	122	6.6015616783655366e-16
R121_123	121	123	3.3645996392139583e+09
C121_123	121	123	2.6315724800673538e-16
R121_127	121	127	2.8779849942099662e+09
C121_127	121	127	3.0765232740313706e-16
R121_129	121	129	2.7412181627543421e+09
C121_129	121	129	3.2300193896655861e-16
R121_130	121	130	4.1251878694067326e+09
C121_130	121	130	2.1463720192393014e-16
R121_132	121	132	2.1564020435913968e+09
C121_132	121	132	4.1060004757989021e-16
R121_139	121	139	2.5935738921624293e+09
C121_139	121	139	3.4138945660104923e-16
R121_140	121	140	1.0218697830534436e+09
C121_140	121	140	8.6646928638430316e-16
R121_180	121	180	3.6968898774586558e+09
C121_180	121	180	2.3950369392897940e-16
R121_181	121	181	1.8789467199140842e+09
C121_181	121	181	4.7123144702074699e-16
R121_186	121	186	2.1880473969580078e+09
C121_186	121	186	4.0466160967581298e-16
R121_187	121	187	3.7636541281047568e+09
C121_187	121	187	2.3525508762567022e-16
R121_188	121	188	1.3966797406053298e+09
C121_188	121	188	6.3394546076558241e-16
R122_123	122	123	1.3285339981533542e+09
C122_123	122	123	6.6646302084156020e-16
R122_124	122	124	1.1531198342208889e+09
C122_124	122	124	7.6784628572297319e-16
R122_128	122	128	2.6300826960218349e+09
C122_128	122	128	3.3665054830376693e-16
R122_129	122	129	1.0293168158268247e+09
C122_129	122	129	8.6020044371738462e-16
R122_188	122	188	3.4080835883686671e+09
C122_188	122	188	2.5979960841389454e-16
R123_124	123	124	1.0336641184663197e+09
C123_124	123	124	8.5658268085548328e-16
R123_125	123	125	9.9588089447126019e+08
C123_125	123	125	8.8908100016326981e-16
R123_126	123	126	1.8405939530052078e+09
C123_126	123	126	4.8105057623075603e-16
R123_127	123	127	1.9097737282601106e+09
C123_127	123	127	4.6362496697797615e-16
R123_188	123	188	1.1664765511836832e+09
C123_188	123	188	7.5905407682779430e-16
R124_126	124	126	1.1809327774049783e+09
C124_126	124	126	7.4976222071306140e-16
R124_128	124	128	2.3241534445189085e+09
C124_128	124	128	3.8096399520784597e-16
R124_129	124	129	3.0534355070169353e+09
C124_129	124	129	2.8997461373107992e-16
R124_161	124	161	1.5003207600181973e+09
C124_161	124	161	5.9015298947757074e-16
R124_185	124	185	3.0316848681451359e+09
C124_185	124	185	2.9205501897752402e-16
R124_188	124	188	1.6818199714005678e+09
C124_188	124	188	5.2646466135293336e-16
R124_190	124	190	3.6224945221575723e+09
C124_190	124	190	2.4442239354240376e-16
R125_126	125	126	1.7283416152996044e+09
C125_126	125	126	5.1229385085801717e-16
R125_127	125	127	1.5345662978380311e+09
C125_127	125	127	5.7698307524896065e-16
R125_160	125	160	3.6423628380006180e+09
C125_160	125	160	2.4308912128755080e-16
R125_188	125	188	2.7850274389692969e+09
C125_188	125	188	3.1792102631049193e-16
R125_189	125	189	2.3670671427997527e+09
C125_189	125	189	3.7405731577716555e-16
R125_190	125	190	4.2603394182285314e+09
C125_190	125	190	2.0782822558963181e-16
R125_191	125	191	2.8253335288350067e+09
C125_191	125	191	3.1338557825599164e-16
R126_161	126	161	4.2916228983995309e+09
C126_161	126	161	2.0631327650670288e-16
R126_162	126	162	3.1224093349021621e+09
C126_162	126	162	2.8356909256029496e-16
R126_188	126	188	5.6248407164361658e+09
C126_188	126	188	1.5741224086803852e-16
R126_190	126	190	1.4169160296065338e+09
C126_190	126	190	6.2489149900144311e-16
R126_191	126	191	5.1696625700534925e+09
C126_191	126	191	1.7127206460804622e-16
R127_160	127	160	1.8120276741609757e+09
C127_160	127	160	4.8863424898296664e-16
R127_169	127	169	8.0512930242606080e+08
C127_169	127	169	1.0997224657356361e-15
R127_180	127	180	1.4115504520325532e+09
C127_180	127	180	6.2726683302396093e-16
R127_188	127	188	1.2472792827266991e+09
C127_188	127	188	7.0988013186940026e-16
R127_189	127	189	1.7305333147569332e+09
C127_189	127	189	5.1164503690838454e-16
R127_192	127	192	2.0043167084582040e+09
C127_192	127	192	4.4175592508087091e-16
R128_129	128	129	1.2990935053020234e+09
C128_129	128	129	6.8156662941221537e-16
R128_136	128	136	1.2244191882791357e+09
C128_136	128	136	7.2313370304529054e-16
R128_184	128	184	5.2203042126727161e+09
C128_184	128	184	1.6961057165032137e-16
R128_185	128	185	5.2487847205049381e+09
C128_185	128	185	1.6869024523734363e-16
R128_194	128	194	4.6171445874909239e+09
C128_194	128	194	1.9176760981209811e-16
R129_136	129	136	1.4859155398365614e+09
C129_136	129	136	5.9587423239236652e-16
R129_139	129	139	1.3794810304011638e+09
C129_139	129	139	6.4184918979459503e-16
R129_185	129	185	1.7428804052045739e+09
C129_185	129	185	5.0802038915347854e-16
R129_187	129	187	1.0950598674192364e+09
C129_187	129	187	8.0855742050587198e-16
R129_188	129	188	2.5619207197556653e+09
C129_188	129	188	3.4560740887580782e-16
R129_194	129	194	1.0384650972431787e+09
C129_194	129	194	8.5262257157272592e-16
R130_134	130	134	1.4914753013930857e+09
C130_134	130	134	5.9365299638082543e-16
R130_139	130	139	1.8719618095356884e+09
C130_139	130	139	4.7298976784126523e-16
R130_140	130	140	1.3900764968933523e+09
C130_140	130	140	6.3695687516392132e-16
R130_142	130	142	2.5118087619640279e+09
C130_142	130	142	3.5250246559681376e-16
R130_143	130	143	1.5255288000189679e+09
C130_143	130	143	5.8040122329318929e-16
R130_145	130	145	3.0774575253645587e+09
C130_145	130	145	2.8771112985389215e-16
R130_154	130	154	4.1501956128989048e+09
C130_154	130	154	2.1334386720184894e-16
R130_196	130	196	5.7656743409920921e+09
C130_196	130	196	1.5356725498784365e-16
R131_133	131	133	1.6322910562004519e+09
C131_133	131	133	5.4243927780932925e-16
R131_134	131	134	2.5686310648366437e+09
C131_134	131	134	3.4470453691110748e-16
R131_142	131	142	2.3135883515760694e+09
C131_142	131	142	3.8270368239744667e-16
R131_150	131	150	3.2428826106489739e+09
C131_150	131	150	2.7303448444062174e-16
R131_175	131	175	4.5201788711213636e+09
C131_175	131	175	1.9588135933221287e-16
R131_174	131	174	4.3373341573422956e+09
C131_174	131	174	2.0413893640201822e-16
R131_176	131	176	2.1405258873638690e+09
C131_176	131	176	4.1364544429332919e-16
R131_177	131	177	1.9372088002432773e+09
C131_177	131	177	4.5705903338287967e-16
R131_196	131	196	1.7319068158783464e+09
C131_196	131	196	5.1123927314239195e-16
R132_133	132	133	2.0040561106295302e+09
C132_133	132	133	4.4181336889906992e-16
R132_134	132	134	5.0206653118816395e+09
C132_134	132	134	1.7635487065919634e-16
R132_140	132	140	3.6789923818667331e+09
C132_140	132	140	2.4066882716694720e-16
R132_173	132	173	3.0732948859071655e+09
C132_173	132	173	2.8810082161661644e-16
R132_174	132	174	3.6128040103399940e+09
C132_174	132	174	2.4507800012563512e-16
R132_180	132	180	2.7661872211147370e+09
C132_180	132	180	3.2008635385973189e-16
R132_181	132	181	2.6023378233099532e+09
C132_181	132	181	3.4023975433513184e-16
R132_196	132	196	4.1752856068079033e+09
C132_196	132	196	2.1206184799820723e-16
R133_134	133	134	4.0297703659101148e+09
C133_134	133	134	2.1971941358996769e-16
R133_173	133	173	7.9291518731125793e+09
C133_173	133	173	1.1166626593474868e-16
R133_174	133	174	3.9715873161709142e+09
C133_174	133	174	2.2293826402730324e-16
R133_175	133	175	3.4719764246587310e+09
C133_175	133	175	2.5501866182372773e-16
R133_196	133	196	7.2390202014986000e+09
C133_196	133	196	1.2231196447230570e-16
R134_140	134	140	3.7455735065389915e+09
C134_140	134	140	2.3639071030223899e-16
R134_142	134	142	2.1689189793392248e+09
C134_142	134	142	4.0823045495675854e-16
R134_196	134	196	2.8637853449198108e+09
C134_196	134	196	3.0917777523747773e-16
R135_137	135	137	1.2179320304495976e+09
C135_137	135	137	7.2698538141997068e-16
R135_138	135	138	1.6963193815600863e+09
C135_138	135	138	5.2196466734094035e-16
R135_152	135	152	3.8013369699661598e+09
C135_152	135	152	2.3292299227760443e-16
R135_166	135	166	3.3539566508551097e+09
C135_166	135	166	2.6399231530743177e-16
R135_193	135	193	6.6198452381799173e+09
C135_193	135	193	1.3375218752748969e-16
R135_197	135	197	3.1451997645322671e+09
C135_197	135	197	2.8151432277360400e-16
R136_137	136	137	1.1329078169220490e+09
C136_137	136	137	7.8154530181066100e-16
R136_139	136	139	2.9023779780505958e+09
C136_139	136	139	3.0506666891632713e-16
R136_153	136	153	1.4950481002867115e+09
C136_153	136	153	5.9223431107681394e-16
R136_184	136	184	2.9379157997613678e+09
C136_184	136	184	3.0137650022914823e-16
R136_194	136	194	1.0883222716822493e+09
C136_194	136	194	8.1356304537569007e-16
R136_198	136	198	3.9648111617385349e+09
C136_198	136	198	2.2331928194828619e-16
R137_138	137	138	5.2495270320127935e+09
C137_138	137	138	1.6866639152451600e-16
R137_153	137	153	3.7078917402752872e+09
C137_153	137	153	2.3879305107065062e-16
R137_166	137	166	3.9420549273630452e+09
C137_166	137	166	2.2460843342238316e-16
R137_184	137	184	5.7907516441337318e+09
C137_184	137	184	1.5290221997294005e-16
R137_197	137	197	2.5258257238489499e+09
C137_197	137	197	3.5054626823214282e-16
R137_198	137	198	2.4995505241410823e+09
C137_198	137	198	3.5423120002915548e-16
R138_152	138	152	1.8578070166017096e+09
C138_152	138	152	4.7659351794224733e-16
R138_153	138	153	2.3121968115065346e+09
C138_153	138	153	3.8293400340912005e-16
R138_157	138	157	8.3153924122798359e+08
C138_157	138	157	1.0647949462883424e-15
R138_158	138	158	2.1660605135851016e+09
C138_158	138	158	4.0876918079934939e-16
R138_197	138	197	2.4287260371392770e+09
C138_197	138	197	3.6456099541919020e-16
R138_199	138	199	1.5977424045816343e+09
C138_199	138	199	5.5416866896753927e-16
R138_200	138	200	2.5228612862774792e+09
C138_200	138	200	3.5095817059623174e-16
R139_140	139	140	2.9478457163739338e+09
C139_140	139	140	3.0036130343657538e-16
R139_143	139	143	4.5825136659105940e+09
C139_143	139	143	1.9321683387147261e-16
R139_153	139	153	4.0751023367860484e+09
C139_153	139	153	2.1727522612310938e-16
R139_154	139	154	1.4839596910533409e+09
C139_154	139	154	5.9665959057925227e-16
R139_186	139	186	1.9070714536544654e+09
C139_186	139	186	4.6428191245970249e-16
R139_187	139	187	3.4546966765497136e+09
C139_187	139	187	2.5629421758216085e-16
R139_194	139	194	3.1270325993954129e+09
C139_194	139	194	2.8314984048173621e-16
R139_201	139	201	2.7720033292387676e+09
C139_201	139	201	3.1941476128859810e-16
R139_204	139	204	2.9944161692436996e+09
C139_204	139	204	2.9568995478795812e-16
R140_143	140	143	2.4867397369523292e+09
C140_143	140	143	3.5605607154737535e-16
R140_181	140	181	1.7959039591105626e+09
C140_181	140	181	4.9302123156881473e-16
R140_186	140	186	2.4148616428301625e+09
C140_186	140	186	3.6665404178696935e-16
R140_196	140	196	1.9921551575633037e+09
C140_196	140	196	4.4445272163589720e-16
R140_204	140	204	3.0959827451558528e+09
C140_204	140	204	2.8598957248239698e-16
R140_205	140	205	3.7265701440699821e+09
C140_205	140	205	2.3759616684230394e-16
R140_207	140	207	5.4157275146699076e+09
C140_207	140	207	1.6349027518493369e-16
R141_145	141	145	5.2800343672082071e+09
C141_145	141	145	1.6769185958313393e-16
R141_151	141	151	3.4644677028045774e+09
C141_151	141	151	2.5557137709300346e-16
R141_153	141	153	9.1851411694334812e+09
C141_153	141	153	9.6396861557938445e-17
R141_154	141	154	2.4373012133777938e+09
C141_154	141	154	3.6327835757030650e-16
R141_155	141	155	2.7079640824088736e+09
C141_155	141	155	3.2696843634365140e-16
R141_156	141	156	6.6335392764894600e+09
C141_156	141	156	1.3347607435416788e-16
R141_208	141	208	6.5870738003662758e+09
C141_208	141	208	1.3441761980118793e-16
R142_144	142	144	3.3392762068377357e+09
C142_144	142	144	2.6515290346062260e-16
R142_145	142	145	1.5996241936317022e+09
C142_145	142	145	5.5351674801178906e-16
R142_143	142	143	2.9444277904765468e+09
C142_143	142	143	3.0070996631800495e-16
R142_150	142	150	2.1441794291214581e+09
C142_150	142	150	4.1294061946242329e-16
R142_196	142	196	2.3382345987764688e+09
C142_196	142	196	3.7866978025357864e-16
R142_210	142	210	4.1070599184928803e+09
C142_210	142	210	2.1558457857242848e-16
R143_145	143	145	2.7980761066637087e+09
C143_145	143	145	3.1643841980972089e-16
R143_154	143	154	2.6968870315776620e+09
C143_154	143	154	3.2831140916645500e-16
R143_196	143	196	3.1007881482651362e+09
C143_196	143	196	2.8554636413822216e-16
R143_204	143	204	1.1923105791317565e+09
C143_204	143	204	7.4260750277395365e-16
R143_207	143	207	1.6729792573000190e+09
C143_207	143	207	5.2924671829401894e-16
R143_209	143	209	9.6195733635721242e+08
C143_209	143	209	9.2043456423228472e-16
R143_210	143	210	2.3515154290529757e+09
C143_210	143	210	3.7653113849930559e-16
R144_145	144	145	2.4002146489327698e+09
C144_145	144	145	3.6889149980552453e-16
R144_146	144	146	6.3165887268688961e+00
C144_146	144	146	1.5419092504045730e-16
R144_147	144	147	5.6253668567148978e+00
C144_147	144	147	1.7313726974685043e-16
R144_150	144	150	4.0551683860706921e+09
C144_150	144	150	2.1834328378110532e-16
R144_211	144	211	6.2974977283888464e+09
C144_211	144	211	1.4059850751649669e-16
R145_146	145	146	4.0129034196687207e+09
C145_146	145	146	2.2064293333356485e-16
R145_150	145	150	4.5813088401165667e+09
C145_150	145	150	1.9326764743445489e-16
R145_151	145	151	4.7872525855431452e+09
C145_151	145	151	1.8495342910751043e-16
R145_154	145	154	2.0165605306288538e+09
C145_154	145	154	4.3907374375907616e-16
R145_208	145	208	9.2335127050575459e+08
C145_208	145	208	9.5891868022775603e-16
R145_209	145	209	2.6937083950964732e+09
C145_209	145	209	3.2869882401219953e-16
R145_210	145	210	2.0774885728924372e+09
C145_210	145	210	4.2619670368018088e-16
R145_211	145	211	3.1699802316690788e+09
C145_211	145	211	2.7931366033592067e-16
R146_147	146	147	1.6384730297424721e+01
C146_147	146	147	5.9443191387112570e-17
R146_151	146	151	4.5003096573146925e+09
C146_151	146	151	1.9674619062287470e-16
R146_208	146	208	8.6089176990370331e+09
C146_208	146	208	1.0284902384408208e-16
R146_211	146	211	3.5537300742639861e+09
C146_211	146	211	2.4915195110404649e-16
R147_149	147	149	4.0787956807843184e+09
C147_149	147	149	2.1707848369834040e-16
R147_150	147	150	1.0535052494392897e+10
C147_150	147	150	8.4045027983605126e-17
R147_211	147	211	7.0411571554038229e+09
C147_211	147	211	1.2574904410711447e-16
R148_149	148	149	2.6891443831655612e+09
C148_149	148	149	3.2925669117762951e-16
R148_150	148	150	2.7716539827571807e+09
C148_150	148	150	3.1945502115643052e-16
R148_168	148	168	2.4222129779531164e+09
C148_168	148	168	3.6554125907137226e-16
R148_176	148	176	4.2581964159857020e+09
C148_176	148	176	2.0793281831153868e-16
R148_203	148	203	3.2293492614956570e+09
C148_203	148	203	2.7417869979474533e-16
R148_212	148	212	5.7001484441703024e+09
C148_212	148	212	1.5533258306729574e-16
R149_150	149	150	2.4113278867908797e+09
C149_150	149	150	3.6719136644596331e-16
R149_168	149	168	2.9505365096176829e+09
C149_168	149	168	3.0008738370593106e-16
R149_211	149	211	4.8041643891221170e+09
C149_211	149	211	1.8430234895891978e-16
R149_212	149	212	2.1952105090809398e+09
C149_212	149	212	4.0334117299333404e-16
R150_176	150	176	4.6350939415886717e+09
C150_176	150	176	1.9102499169553487e-16
R150_177	150	177	3.3742176970634437e+09
C150_177	150	177	2.6240712994617191e-16
R150_196	150	196	3.6277960256011939e+09
C150_196	150	196	2.4406520527935952e-16
R150_203	150	203	3.2914030687857060e+09
C150_203	150	203	2.6900952669605927e-16
R150_206	150	206	2.3970561345065026e+09
C150_206	150	206	3.6937757483192475e-16
R150_210	150	210	1.0537738510145793e+09
C150_210	150	210	8.4023605335007488e-16
R150_211	150	211	3.5752888993845849e+09
C150_211	150	211	2.4764957647266138e-16
R150_212	150	212	2.7861209860957747e+09
C150_212	150	212	3.1779624291935293e-16
R150_213	150	213	1.8640845758214176e+09
C150_213	150	213	4.7498852422500009e-16
R151_156	151	156	3.7387428379301414e+09
C151_156	151	156	2.3682259520962115e-16
R151_155	151	155	2.0373752493966238e+09
C151_155	151	155	4.3458797389544223e-16
R151_208	151	208	1.0958058480041244e+09
C151_208	151	208	8.0800698710695995e-16
R151_211	151	211	7.9783043083847322e+09
C151_211	151	211	1.1097831662919608e-16
R151_214	151	214	3.3263464642683086e+09
C151_214	151	214	2.6618357143827000e-16
R151_215	151	215	4.1223521593019300e+09
C151_215	151	215	2.1478484794223279e-16
R151_216	151	216	3.3194969293746300e+09
C151_216	151	216	2.6673282142990469e-16
R152_158	152	158	1.8699318696183460e+09
C152_158	152	158	4.7350323083199514e-16
R152_159	152	159	2.0401272314601018e+09
C152_159	152	159	4.3400174658043912e-16
R152_193	152	193	4.2733886043959384e+09
C152_193	152	193	2.0719360293823729e-16
R152_197	152	197	2.0138323711677170e+09
C152_197	152	197	4.3966856148339270e-16
R152_200	152	200	9.5917750840225422e+08
C152_200	152	200	9.2310210982207278e-16
R152_217	152	217	2.6955843256618972e+09
C152_217	152	217	3.2847007354614535e-16
R153_154	153	154	2.9990523895069671e+09
C153_154	153	154	2.9523284914858030e-16
R153_155	153	155	3.2386943945432506e+09
C153_155	153	155	2.7338756728384357e-16
R153_157	153	157	3.5731569291092687e+09
C153_157	153	157	2.4779733979406292e-16
R153_194	153	194	2.7398666090024848e+09
C153_194	153	194	3.2316127317685669e-16
R153_197	153	197	4.2746744195095372e+09
C153_197	153	197	2.0713127943942688e-16
R153_198	153	198	3.5351169310132275e+09
C153_198	153	198	2.5046378916983181e-16
R153_199	153	199	2.3692605602542081e+09
C153_199	153	199	3.7371102045652576e-16
R153_201	153	201	2.6568890241367388e+09
C153_201	153	201	3.3325395741272449e-16
R153_202	153	202	1.7705385963373468e+09
C153_202	153	202	5.0008442828167411e-16
R153_219	153	219	2.3204803467118249e+09
C153_219	153	219	3.8156702466998221e-16
R154_155	154	155	2.3214348503194184e+09
C154_155	154	155	3.8141013588133689e-16
R154_201	154	201	2.5539993601155968e+09
C154_201	154	201	3.4667932793057761e-16
R154_204	154	204	1.6687116824885833e+09
C154_204	154	204	5.3060021751604045e-16
R154_208	154	208	1.8851219130270498e+09
C154_208	154	208	4.6968780935670715e-16
R154_209	154	209	1.3960116052230980e+09
C154_209	154	209	6.3424886898307734e-16
R154_215	154	215	1.4733292319417884e+09
C154_215	154	215	6.0096464693981119e-16
R154_219	154	219	4.1399802161831765e+09
C154_219	154	219	2.1387029296393724e-16
R155_156	155	156	9.9122805058361709e+08
C155_156	155	156	8.9325436379517478e-16
R155_157	155	157	1.3680433518236072e+09
C155_157	155	157	6.4721544132335679e-16
R155_208	155	208	4.3732856664473639e+09
C155_208	155	208	2.0246076959780893e-16
R155_214	155	214	1.1565876249871423e+09
C155_214	155	214	7.6554405612790767e-16
R155_215	155	215	2.1537897848260527e+09
C155_215	155	215	4.1109805048662608e-16
R155_219	155	219	1.2401511175463459e+09
C155_219	155	219	7.1396039496526192e-16
R155_220	155	220	2.2896407091484122e+09
C155_220	155	220	3.8670642872580414e-16
R156_157	156	157	1.0601572036764588e+09
C156_157	156	157	8.3517687624958493e-16
R156_158	156	158	6.7972662849077539e+09
C156_158	156	158	1.3026101149898029e-16
R156_214	156	214	7.1264573528493147e+09
C156_214	156	214	1.2424388975624616e-16
R156_220	156	220	4.6809952235694046e+09
C156_220	156	220	1.8915182336478457e-16
R157_158	157	158	1.0452145216546575e+09
C157_158	157	158	8.4711680076766622e-16
R157_199	157	199	1.0340858171137778e+09
C157_199	157	199	8.5623336772114305e-16
R157_219	157	219	3.3513177772620182e+09
C157_219	157	219	2.6420018647810095e-16
R157_220	157	220	1.9176157986978524e+09
C157_220	157	220	4.6172897735888452e-16
R158_159	158	159	2.4132705772833691e+09
C158_159	158	159	3.6689577622776150e-16
R158_199	158	199	2.3670442926858277e+09
C158_199	158	199	3.7406092671605098e-16
R158_200	158	200	8.7393582122234297e+08
C158_200	158	200	1.0131393635537176e-15
R158_220	158	220	2.0871264315310609e+09
C158_220	158	220	4.2422862761144765e-16
R158_221	158	221	4.3062832219067450e+09
C158_221	158	221	2.0561090296981268e-16
R159_200	159	200	2.0181061563063080e+09
C159_200	159	200	4.3873746627905889e-16
R159_217	159	217	3.2338912451157317e+09
C159_217	159	217	2.7379361722113619e-16
R159_218	159	218	1.2899992732912470e+10
C159_218	159	218	6.8637153526527316e-17
R159_221	159	221	3.5084277874482079e+09
C159_221	159	221	2.5236910529202986e-16
R160_169	160	169	5.9343155300265563e+08
C160_169	160	169	1.4920318564456882e-15
R160_171	160	171	4.4228207934036398e+09
C160_171	160	171	2.0019323030689979e-16
R160_189	160	189	2.4027188833896203e+09
C160_189	160	189	3.6850702253228274e-16
R160_222	160	222	5.2512283639602232e+09
C160_222	160	222	1.6861174573490836e-16
R161_162	161	162	1.3248185405138156e+09
C161_162	161	162	6.6833211841721407e-16
R161_178	161	178	1.8637264245263522e+09
C161_178	161	178	4.7507980251179865e-16
R161_182	161	182	2.0268008424313869e+09
C161_182	161	182	4.3685534521380784e-16
R161_185	161	185	1.1160610015785129e+09
C161_185	161	185	7.9334264027476835e-16
R161_188	161	188	3.7017050371121535e+09
C161_188	161	188	2.3919214870527618e-16
R161_190	161	190	1.2220500143069816e+09
C161_190	161	190	7.2453563383992653e-16
R161_223	161	223	9.1245030830367172e+08
C161_223	161	223	9.7037479591198154e-16
R162_178	162	178	1.9790499075615919e+09
C162_178	162	178	4.4739588340696964e-16
R162_190	162	190	6.2782774613215280e+08
C162_190	162	190	1.4102893463291226e-15
R162_191	162	191	2.0762208439284551e+09
C162_191	162	191	4.2645693703020689e-16
R162_223	162	223	2.5442112190851598e+09
C162_223	162	223	3.4801307967597775e-16
R162_224	162	224	2.1114946772063563e+09
C162_224	162	224	4.1933270836915685e-16
R163_164	163	164	2.1725384487706933e+09
C163_164	163	164	4.0755033919008634e-16
R163_166	163	166	2.3991448542399383e+09
C163_166	163	166	3.6905599098579876e-16
R163_183	163	183	8.7582868861133766e+08
C163_183	163	183	1.0109497361908388e-15
R163_225	163	225	5.4501421635763388e+09
C163_225	163	225	1.6245792405513977e-16
R164_165	164	165	3.6192514124839091e+09
C164_165	164	165	2.4464141359340737e-16
R164_182	164	182	1.9877775442498648e+09
C164_182	164	182	4.4543152439833711e-16
R164_183	164	183	1.1763429402841399e+09
C164_183	164	183	7.5268763162393056e-16
R164_225	164	225	3.0198062731639991e+09
C164_225	164	225	2.9320383548057984e-16
R164_226	164	226	5.4877982630008307e+09
C164_226	164	226	1.6134317248313654e-16
R165_179	165	179	6.9812368573438139e+09
C165_179	165	179	1.2682835431498022e-16
R165_182	165	182	9.1806191080245419e+09
C165_182	165	182	9.6444343380511088e-17
R165_226	165	226	6.0397874329847603e+09
C165_226	165	226	1.4659767276982482e-16
R165_167	165	167	2.7254848521315720e+10
C165_167	165	167	3.2486652090820607e-17
R166_183	166	183	2.2536352159046474e+09
C166_183	166	183	3.9288469378331836e-16
R166_184	166	184	2.3419171576483297e+09
C166_184	166	184	3.7807433914063224e-16
R166_195	166	195	3.4392574250315118e+09
C166_195	166	195	2.5744475399130307e-16
R166_193	166	193	4.2316777948760910e+09
C166_193	166	193	2.0923586922711972e-16
R166_197	166	197	2.6754271085850797e+09
C166_197	166	197	3.3094483451214655e-16
R166_198	166	198	2.7938799737225485e+09
C166_198	166	198	3.1691367919441202e-16
R166_225	166	225	3.7855563466910691e+09
C166_225	166	225	2.3389396448264176e-16
R166_227	166	227	3.4064498109767985e+09
C166_227	166	227	2.5992421166660501e-16
R167_226	167	226	7.5943483416363440e+09
C167_226	167	226	1.1658917156139033e-16
R167_179	167	179	7.0268225942621279e+09
C167_179	167	179	1.2600556934837144e-16
R167_229	167	229	7.2859611236158409e+09
C167_229	167	229	1.2152395088001633e-16
R167_230	167	230	4.3600264079784975e+09
C167_230	167	230	2.0307647221580007e-16
R167_231	167	231	4.3739679247943277e+09
C167_231	167	231	2.0242918945081975e-16
R167_232	167	232	2.3901858825827526e+10
C167_232	167	232	3.7043929852988962e-17
R168_212	168	212	4.0291725090390892e+09
C168_212	168	212	2.1975201600667184e-16
R168_203	168	203	6.1098840092034655e+09
C168_203	168	203	1.4491580860884960e-16
R168_233	168	233	1.2710499681839645e+10
C168_233	168	233	6.9660422789283249e-17
R169_171	169	171	2.1509578241327882e+09
C169_171	169	171	4.1163930401888684e-16
R169_173	169	173	1.8176943716203842e+09
C169_173	169	173	4.8711092223424398e-16
R169_180	169	180	1.8071043817204278e+09
C169_180	169	180	4.8996548879874320e-16
R169_189	169	189	3.6485966903371053e+09
C169_189	169	189	2.4267378854038084e-16
R169_192	169	192	2.1869755747224135e+09
C169_192	169	192	4.0485993164893189e-16
R169_222	169	222	2.6304053322695560e+09
C169_222	169	222	3.3660925593396910e-16
R169_235	169	235	2.0002390752444878e+09
C169_235	169	235	4.4265647674729877e-16
R170_172	170	172	7.2833237172741318e+09
C170_172	170	172	1.2156795661848989e-16
R170_173	170	173	3.8194312647098293e+09
C170_173	170	173	2.3181953551067958e-16
R170_175	170	175	1.0163665719450623e+10
C170_175	170	175	8.7116086473164696e-17
R170_234	170	234	7.8003350738466949e+09
C170_234	170	234	1.1351035222431291e-16
R170_237	170	237	1.1983061038540007e+10
C170_237	170	237	7.3889198999513549e-17
R171_173	171	173	3.5752767873459072e+09
C171_173	171	173	2.4765041544022305e-16
R171_172	171	172	3.9920015878382611e+09
C171_172	171	172	2.2179820378765677e-16
R171_222	171	222	3.9986818609650264e+09
C171_222	171	222	2.2142766353668268e-16
R171_235	171	235	1.2885823373664153e+09
C171_235	171	235	6.8712627515103537e-16
R171_236	171	236	5.9249878688099184e+09
C171_236	171	236	1.4943807503150949e-16
R171_237	171	237	3.5780645440684605e+09
C171_237	171	237	2.4745746500515308e-16
R171_238	171	238	3.7890869573668923e+09
C171_238	171	238	2.3367602582425138e-16
R172_173	172	173	4.8695656550672789e+09
C172_173	172	173	1.8182705489936903e-16
R172_237	172	237	2.6744242511307387e+09
C172_237	172	237	3.3106893243495218e-16
R172_238	172	238	1.2742515943794821e+10
C172_238	172	238	6.9485397201419203e-17
R173_174	173	174	2.3217035308950248e+09
C173_174	173	174	3.8136599695770280e-16
R173_175	173	175	5.2888458716378756e+09
C173_175	173	175	1.6741247583866519e-16
R173_180	173	180	2.1733706780856299e+09
C173_180	173	180	4.0739427959886878e-16
R173_234	173	234	2.2782937554923739e+09
C173_234	173	234	3.8863240509064527e-16
R173_235	173	235	3.3829694641000638e+09
C173_235	173	235	2.6172828075926445e-16
R173_237	173	237	2.5968983142203078e+09
C173_237	173	237	3.4095242653574525e-16
R173_241	173	241	4.2495286545329418e+09
C173_241	173	241	2.0835693877614641e-16
R174_175	174	175	7.4114004382469873e+09
C174_175	174	175	1.1946713567529587e-16
R174_177	174	177	5.8463962032641182e+09
C174_177	174	177	1.5144693430213631e-16
R174_180	174	180	1.0796582089747524e+10
C174_180	174	180	8.2009174231240936e-17
R174_181	174	181	1.4764670494898720e+10
C174_181	174	181	5.9968746475305178e-17
R174_196	174	196	5.0085239452207842e+09
C174_196	174	196	1.7678237967592857e-16
R174_234	174	234	8.7263775615345650e+09
C174_234	174	234	1.0146464274052061e-16
R174_240	174	240	7.9905590536353064e+09
C174_240	174	240	1.1080811439559771e-16
R174_241	174	241	5.5909853107434111e+09
C174_241	174	241	1.5836542800400768e-16
R174_242	174	242	5.4216070989414339e+09
C174_242	174	242	1.6331297446339807e-16
R174_243	174	243	4.1517292456922073e+09
C174_243	174	243	2.1326505879898157e-16
R175_176	175	176	1.0275239729532473e+10
C175_176	175	176	8.6170133739574270e-17
R175_177	175	177	8.9422323367222137e+09
C175_177	175	177	9.9015407826514995e-17
R175_234	175	234	7.6095695342950563e+09
C175_234	175	234	1.1635596175441538e-16
R175_243	175	243	8.0331096259550743e+09
C175_243	175	243	1.1022117497801864e-16
R176_177	176	177	2.7238340833344870e+09
C176_177	176	177	3.2506340496924846e-16
R176_203	176	203	1.3708799896202703e+10
C176_203	176	203	6.4587621703141095e-17
R176_243	176	243	2.3410064818415264e+10
C176_243	176	243	3.7822141398066333e-17
R176_245	176	245	2.3509012109739399e+10
C176_245	176	245	3.7662951448869502e-17
R177_196	177	196	3.4652808030646329e+09
C177_196	177	196	2.5551140932560244e-16
R177_203	177	203	6.4324993795941858e+09
C177_203	177	203	1.3764770572832288e-16
R177_206	177	206	2.5920911815586209e+09
C177_206	177	206	3.4158473590716771e-16
R177_242	177	242	3.1818373286861787e+09
C177_242	177	242	2.7827279971776576e-16
R177_243	177	243	3.0187741885911613e+09
C177_243	177	243	2.9330407853832161e-16
R177_245	177	245	2.6806794460201812e+09
C177_245	177	245	3.3029640415026858e-16
R178_182	178	182	3.1639238855914321e+09
C178_182	178	182	2.7984831927601473e-16
R178_179	178	179	4.9726753061936350e+09
C178_179	178	179	1.7805682599006235e-16
R178_223	178	223	3.5428569915315704e+09
C178_223	178	223	2.4991660228352468e-16
R178_224	178	224	4.9661855054195662e+09
C178_224	178	224	1.7828951027579383e-16
R178_228	178	228	3.8648366188202386e+09
C178_228	178	228	2.2909604441966781e-16
R178_247	178	247	1.2284243623586348e+10
C178_247	178	247	7.2077598656538588e-17
R179_182	179	182	2.6174949398886123e+09
C179_182	179	182	3.3826952946762110e-16
R179_226	179	226	5.2171980463194418e+09
C179_226	179	226	1.6971155279885021e-16
R179_228	179	228	3.1999469528447132e+09
C179_228	179	228	2.7669795616857764e-16
R179_229	179	229	4.2015304197051587e+09
C179_229	179	229	2.1073720603030501e-16
R179_230	179	230	4.2456478306450315e+09
C179_230	179	230	2.0854739182771088e-16
R179_247	179	247	1.0421579156591608e+10
C179_247	179	247	8.4960135925271575e-17
R180_181	180	181	1.4697765960017116e+09
C180_181	180	181	6.0241725450564250e-16
R180_188	180	188	7.2824816353983383e+09
C180_188	180	188	1.2158201366361143e-16
R180_192	180	192	2.4753653449666958e+09
C180_192	180	192	3.5769216188647611e-16
R180_235	180	235	5.0899966654048195e+09
C180_235	180	235	1.7395272333239942e-16
R180_239	180	239	5.1859979544372292e+09
C180_239	180	239	1.7073257442040072e-16
R180_240	180	240	2.9589024508322616e+09
C180_240	180	240	2.9923892267923709e-16
R180_241	180	241	5.1095763585395098e+09
C180_241	180	241	1.7328614342365616e-16
R180_252	180	252	4.4576208062860327e+09
C180_252	180	252	1.9863035017500891e-16
R181_186	181	186	5.6990248654067478e+09
C181_186	181	186	1.5536320732245245e-16
R181_188	181	188	1.2922428390715797e+10
C181_188	181	188	6.8517987094138985e-17
R181_196	181	196	6.1048681121101189e+09
C181_196	181	196	1.4503487470001367e-16
R181_205	181	205	4.0199924732278614e+09
C181_205	181	205	2.2025384067175907e-16
R181_240	181	240	3.5434705532542973e+09
C181_240	181	240	2.4987332853290908e-16
R181_252	181	252	4.8342886874165325e+09
C181_252	181	252	1.8315389066538605e-16
R182_183	182	183	3.5389195968880196e+09
C182_183	182	183	2.5019465897970701e-16
R182_184	182	184	7.6365659172503443e+09
C182_184	182	184	1.1594462632738040e-16
R182_185	182	185	6.1817950624336777e+09
C182_185	182	185	1.4323004447051733e-16
R182_223	182	223	4.1047027238932147e+09
C182_223	182	223	2.1570838164382367e-16
R182_225	182	225	6.3533756430715723e+09
C182_225	182	225	1.3936194417617338e-16
R182_226	182	226	4.3023264369425735e+09
C182_226	182	226	2.0580000022713722e-16
R182_228	182	228	3.0010803607576637e+09
C182_228	182	228	2.9503334641677646e-16
R182_229	182	229	4.5372111964300108e+09
C182_229	182	229	1.9514603648969869e-16
R182_254	182	254	1.7948343673643200e+09
C182_254	182	254	4.9331503664052343e-16
R183_184	183	184	8.1170582874705410e+08
C183_184	183	184	1.0908123982141767e-15
R183_195	183	195	2.5284000720090752e+09
C183_195	183	195	3.5018935155955888e-16
R183_225	183	225	1.1228954274665070e+09
C183_225	183	225	7.8851401478915516e-16
R183_254	183	254	3.3937602695490932e+09
C183_254	183	254	2.6089608910933470e-16
R184_185	184	185	5.7386176829629679e+09
C184_185	184	185	1.5429129985931388e-16
R184_194	184	194	5.6695303889404116e+09
C184_194	184	194	1.5617145000707504e-16
R184_195	184	195	3.1957476219303823e+09
C184_195	184	195	2.7706154754647537e-16
R184_198	184	198	5.1005864383465166e+09
C184_198	184	198	1.7359156489210110e-16
R184_254	184	254	8.8834181324963131e+09
C184_254	184	254	9.9670956437484554e-17
R184_255	184	255	1.3584337812163225e+10
C184_255	184	255	6.5179384813826453e-17
R185_187	185	187	3.7388484532321968e+09
C185_187	185	187	2.3681590542525585e-16
R185_188	185	188	5.4782625812582035e+09
C185_188	185	188	1.6162401282646150e-16
R185_194	185	194	4.6686586104065275e+09
C185_194	185	194	1.8965164420597919e-16
R185_223	185	223	2.7389415034848266e+09
C185_223	185	223	3.2327042420345914e-16
R185_254	185	254	1.0387187364025814e+10
C185_254	185	254	8.5241437423810353e-17
R185_255	185	255	3.6156628239653416e+09
C185_255	185	255	2.4488422311706335e-16
R185_257	185	257	5.2440707757712622e+09
C185_257	185	257	1.6884188249152276e-16
R186_187	186	187	1.2852388832550600e+09
C186_187	186	187	6.8891378344976969e-16
R186_188	186	188	6.1196952376459494e+09
C186_188	186	188	1.4468347643412916e-16
R186_201	186	201	3.7822379426767654e+09
C186_201	186	201	2.3409917491160582e-16
R186_204	186	204	2.1304077517757704e+09
C186_204	186	204	4.1561000750301070e-16
R186_205	186	205	2.7630173908333116e+09
C186_205	186	205	3.2045356813080450e-16
R186_252	186	252	2.9752512185751691e+09
C186_252	186	252	2.9759462870635245e-16
R186_253	186	253	2.3245902717127070e+09
C186_253	186	253	3.8089240606158217e-16
R186_257	186	257	4.4950258737390280e+09
C186_257	186	257	1.9697746054651644e-16
R187_188	187	188	2.1849429510213647e+09
C187_188	187	188	4.0523656752049557e-16
R187_194	187	194	2.2563024719577503e+09
C187_194	187	194	3.9242025069969421e-16
R187_201	187	201	5.7006984970551729e+09
C187_201	187	201	1.5531759523107276e-16
R187_252	187	252	8.9704835112382488e+09
C187_252	187	252	9.8703573847579657e-17
R187_257	187	257	1.3508391376673086e+09
C187_257	187	257	6.5545834215980917e-16
R188_189	188	189	4.3376499186172419e+09
C188_189	188	189	2.0412407601170692e-16
R188_190	188	190	1.1770127107839229e+09
C188_190	188	190	7.5225932021608058e-16
R188_191	188	191	4.3119315654319067e+09
C188_191	188	191	2.0534156636396236e-16
R188_192	188	192	3.3318643650236669e+09
C188_192	188	192	2.6574274481119542e-16
R188_223	188	223	3.6642856035385242e+09
C188_223	188	223	2.4163476254279134e-16
R188_252	188	252	3.4244768055996375e+09
C188_252	188	252	2.5855592896765446e-16
R188_257	188	257	4.5371209335360022e+09
C188_257	188	257	1.9514991878560079e-16
R188_258	188	258	1.7310405263919935e+09
C188_258	188	258	5.1149511995855918e-16
R189_191	189	191	2.0470000809019568e+09
C189_191	189	191	4.3254457582134707e-16
R189_192	189	192	2.4362435181698346e+09
C189_192	189	192	3.6343607488185251e-16
R189_222	189	222	3.6041333038401680e+09
C189_222	189	222	2.4566760079506366e-16
R189_246	189	246	2.8874402413820171e+09
C189_246	189	246	3.0664488532452248e-16
R189_258	189	258	5.4374536853568983e+09
C189_258	189	258	1.6283702500022008e-16
R190_191	190	191	8.0586745455862653e+08
C190_191	190	191	1.0987151506012161e-15
R190_223	190	223	2.2744238059608345e+09
C190_223	190	223	3.8929366610544823e-16
R190_224	190	224	3.7215198165304160e+09
C190_224	190	224	2.3791859921505903e-16
R190_258	190	258	4.1767411635875912e+09
C190_258	190	258	2.1198794634893629e-16
R191_224	191	224	2.2991141141840091e+09
C191_224	191	224	3.8511302080986478e-16
R191_246	191	246	3.6182305738927116e+09
C191_246	191	246	2.4471043611447148e-16
R191_258	191	258	2.6550164955347829e+09
C191_258	191	258	3.3348899458406402e-16
R192_222	192	222	2.1106536862030210e+09
C192_222	192	222	4.1949979169383869e-16
R192_235	192	235	2.6292129325870852e+09
C192_235	192	235	3.3676191483995494e-16
R192_239	192	239	2.8569897493913474e+09
C192_239	192	239	3.0991318113361433e-16
R192_246	192	246	2.6791569994100728e+09
C192_246	192	246	3.3048409701072450e-16
R192_248	192	248	2.0401285802628641e+09
C192_248	192	248	4.3400145964619380e-16
R192_252	192	252	2.0195073814297962e+09
C192_252	192	252	4.3843305047646326e-16
R192_258	192	258	1.4767541804086902e+09
C192_258	192	258	5.9957086524377492e-16
R192_259	192	259	1.4869735381972797e+09
C192_259	192	259	5.9545026118852821e-16
R193_197	193	197	1.3339257495191031e+09
C193_197	193	197	6.6376916557702285e-16
R193_217	193	217	1.1378760114087156e+10
C193_217	193	217	7.7813291854516919e-17
R193_227	193	227	1.3080546752494165e+10
C193_227	193	227	6.7689737933253485e-17
R193_261	193	261	9.2919603652873478e+09
C193_261	193	261	9.5288695484294509e-17
R194_198	194	198	1.1434149635435927e+09
C194_198	194	198	7.7436347251917306e-16
R194_195	194	195	3.5700171840220962e+09
C194_195	194	195	2.4801527165268682e-16
R194_201	194	201	1.1846571054477274e+09
C194_201	194	201	7.4740511632297727e-16
R194_202	194	202	2.0994416798998868e+09
C194_202	194	202	4.2174011794517768e-16
R194_255	194	255	2.6503848360805559e+09
C194_255	194	255	3.3407178068879079e-16
R194_257	194	257	2.5500875713150220e+09
C194_257	194	257	3.4721112782939062e-16
R194_263	194	263	2.0192611130219097e+09
C194_263	194	263	4.3848652162420612e-16
R195_198	195	198	1.2886382349577098e+09
C195_198	195	198	6.8709646949832855e-16
R195_225	195	225	1.6968970038054588e+09
C195_225	195	225	5.2178699102795350e-16
R195_227	195	227	1.8825410556425178e+09
C195_227	195	227	4.7033172479619766e-16
R195_254	195	254	8.8406638024224031e+08
C195_254	195	254	1.0015297510322576e-15
R195_255	195	255	1.8292341783016303e+09
C195_255	195	255	4.8403796091437316e-16
R195_262	195	262	8.7004904157713997e+08
C195_262	195	262	1.0176653721668369e-15
R195_263	195	263	1.6869692727326572e+09
C195_263	195	263	5.2485768176781543e-16
R195_264	195	264	2.1140396725951233e+09
C195_264	195	264	4.1882789295675335e-16
R196_205	196	205	4.8116422178714819e+09
C196_205	196	205	1.8401592254955341e-16
R196_206	196	206	2.8722988248620219e+09
C196_206	196	206	3.0826137379439734e-16
R196_207	196	207	2.4358982432602639e+09
C196_207	196	207	3.6348758990643819e-16
R196_210	196	210	5.2792079167593203e+09
C196_210	196	210	1.6771811144038457e-16
R196_240	196	240	5.0326999797761173e+09
C196_240	196	240	1.7593315422299193e-16
R196_242	196	242	4.8860307535626974e+09
C196_242	196	242	1.8121432843098423e-16
R196_265	196	265	7.1637884900030642e+09
C196_265	196	265	1.2359644382795299e-16
R197_198	197	198	1.2654981694149399e+09
C197_198	197	198	6.9966026273221971e-16
R197_199	197	199	3.6042226470483837e+09
C197_199	197	199	2.4566151106816293e-16
R197_200	197	200	3.9164631737315936e+09
C197_200	197	200	2.2607611572570359e-16
R197_202	197	202	5.4871844484257088e+09
C197_202	197	202	1.6136122086328439e-16
R197_217	197	217	5.0659160010256071e+09
C197_217	197	217	1.7477960185694847e-16
R197_227	197	227	6.7683712040371618e+09
C197_227	197	227	1.3081711315890448e-16
R197_261	197	261	4.8457944570593042e+09
C197_261	197	261	1.8271901326935792e-16
R197_264	197	264	7.0155287091952477e+09
C197_264	197	264	1.2620841826781814e-16
R197_270	197	270	3.1288713793781719e+09
C197_270	197	270	2.8298343854452943e-16
R198_202	198	202	8.9567038063741171e+08
C198_202	198	202	9.8855427268889263e-16
R198_227	198	227	2.8346418801097980e+09
C198_227	198	227	3.1235648774994604e-16
R198_263	198	263	1.2968493438881936e+09
C198_263	198	263	6.8274606134691888e-16
R198_264	198	264	1.4410231189556847e+09
C198_264	198	264	6.1443759649162802e-16
R198_270	198	270	2.3108416024283557e+09
C198_270	198	270	3.8315857771019653e-16
R199_200	199	200	1.3003695126761215e+09
C199_200	199	200	6.8089783178462472e-16
R199_202	199	202	3.3671200385990176e+09
C199_202	199	202	2.6296026620672628e-16
R199_219	199	219	1.9559467276271389e+09
C199_219	199	219	4.5268041771983632e-16
R199_220	199	220	2.8779156852709002e+09
C199_220	199	220	3.0765973660435953e-16
R199_270	199	270	2.9172650011088061e+09
C199_270	199	270	3.0350989072417712e-16
R200_217	200	217	1.5844367662233045e+09
C200_217	200	217	5.5882241599991535e-16
R200_220	200	220	3.3210107423268161e+09
C200_220	200	220	2.6661123687894034e-16
R200_221	200	221	1.3293753918556309e+09
C200_221	200	221	6.6604120034452677e-16
R200_270	200	270	2.5322047017288799e+09
C200_270	200	270	3.4966319314369582e-16
R201_202	201	202	4.4918092699511719e+08
C201_202	201	202	1.9711851694665234e-15
R201_204	201	204	1.9327408761979234e+09
C201_204	201	204	4.5811561839670454e-16
R201_215	201	215	2.0573467444854422e+09
C201_215	201	215	4.3036925305532294e-16
R201_219	201	219	1.0317954251402618e+09
C201_219	201	219	8.5813404491460765e-16
R201_253	201	253	1.0991778391540406e+09
C201_253	201	253	8.0552823224806309e-16
R201_257	201	257	1.9729099406648607e+09
C201_257	201	257	4.4878824088727462e-16
R201_263	201	263	2.1979653944994340e+09
C201_263	201	263	4.0283563331607676e-16
R201_271	201	271	9.8684998135266793e+08
C201_271	201	271	8.9721720467214598e-16
R201_272	201	272	1.1747914967405419e+09
C201_272	201	272	7.5368163981148468e-16
R202_219	202	219	1.8461586643959448e+09
C202_219	202	219	4.7960058838697118e-16
R202_263	202	263	2.8427161807906556e+09
C202_263	202	263	3.1146928690353294e-16
R202_270	202	270	1.4284467133106046e+09
C202_270	202	270	6.1984726027891578e-16
R202_271	202	271	4.2819337442412639e+09
C202_271	202	271	2.0678012192290275e-16
R202_272	202	272	4.5550950972846136e+09
C202_272	202	272	1.9437986755267006e-16
R203_206	203	206	1.5874906907706242e+09
C203_206	203	206	5.5774738513281372e-16
R203_212	203	212	1.9420862067780409e+09
C203_212	203	212	4.5591116326855911e-16
R203_213	203	213	1.1850226335667698e+09
C203_213	203	213	7.4717457423998738e-16
R203_233	203	233	1.3606860360352428e+09
C203_233	203	233	6.5071497630704497e-16
R203_245	203	245	1.9666576945310619e+09
C203_245	203	245	4.5021499377456381e-16
R203_244	203	244	2.6050114998603969e+09
C203_244	203	244	3.3989054625956532e-16
R203_267	203	267	2.7801748497085891e+09
C203_267	203	267	3.1847593391214483e-16
R203_274	203	274	1.8739334565068963e+09
C203_274	203	274	4.7249211471492906e-16
R204_205	204	205	1.4795806761079655e+09
C204_205	204	205	5.9842548365060626e-16
R204_207	204	207	9.9972608689001548e+08
C204_207	204	207	8.8566137596188308e-16
R204_209	204	209	8.6592349972603452e+08
C204_209	204	209	1.0225138617673890e-15
R204_215	204	215	2.7970580615229087e+09
C204_215	204	215	3.1655359389211889e-16
R204_253	204	253	1.4969028287484248e+09
C204_253	204	253	5.9150050670978251e-16
R204_275	204	275	1.3404819302276275e+09
C204_275	204	275	6.6052272823226116e-16
R205_207	205	207	9.3843083741344869e+08
C205_207	205	207	9.4350989588155151e-16
R205_240	205	240	1.2120984636061752e+09
C205_240	205	240	7.3048420428299695e-16
R205_252	205	252	1.4492071103282878e+09
C205_252	205	252	6.1096773221008194e-16
R205_253	205	253	1.4048671753822141e+09
C205_253	205	253	6.3025088578862225e-16
R205_265	205	265	1.6096348677477992e+09
C205_265	205	265	5.5007430532296922e-16
R205_266	205	266	9.3429428861796224e+08
C205_266	205	266	9.4768724639186197e-16
R205_275	205	275	1.4689576379652898e+09
C205_275	205	275	6.0275310792925789e-16
R206_210	206	210	2.6934341902758131e+09
C206_210	206	210	3.2873228716582506e-16
R206_207	206	207	2.9168576691861243e+09
C206_207	206	207	3.0355227512594195e-16
R206_213	206	213	1.5259313477743061e+09
C206_213	206	213	5.8024811076294806e-16
R206_242	206	242	2.2916621259922404e+09
C206_242	206	242	3.8636532482581089e-16
R206_245	206	245	3.7178799686307778e+09
C206_245	206	245	2.3815152430165261e-16
R206_244	206	244	1.5811351187135248e+09
C206_244	206	244	5.5998932110268504e-16
R206_265	206	265	2.1884709248118768e+09
C206_265	206	265	4.0458329679482102e-16
R206_274	206	274	2.3013106293213749e+09
C206_274	206	274	3.8474544479946971e-16
R206_276	206	276	2.0580575374355583e+09
C206_276	206	276	4.3022061608796216e-16
R207_209	207	209	1.0704327551442990e+09
C207_209	207	209	8.2715964869800862e-16
R207_210	207	210	9.5260600077303684e+08
C207_210	207	210	9.2947008624917907e-16
R207_265	207	265	2.1861337632480617e+09
C207_265	207	265	4.0501583049725353e-16
R207_275	207	275	1.0506528121884904e+09
C207_275	207	275	8.4273203424420402e-16
R207_276	207	276	1.3804243423881977e+09
C207_276	207	276	6.4141058260982610e-16
R207_277	207	277	2.3304141834870348e+09
C207_277	207	277	3.7994052215007296e-16
R208_209	208	209	1.0168888623289665e+09
C208_209	208	209	8.7071342257809533e-16
R208_210	208	210	2.1892839357250738e+09
C208_210	208	210	4.0443305103170926e-16
R208_211	208	211	1.5592064306038702e+09
C208_211	208	211	5.6786501410020692e-16
R208_215	208	215	1.4817172638974564e+09
C208_215	208	215	5.9756257369305797e-16
R208_216	208	216	1.5166438779176557e+09
C208_216	208	216	5.8380137525473383e-16
R208_277	208	277	1.5611948858234005e+09
C208_277	208	277	5.6714173851076587e-16
R209_210	209	210	9.8082435634520960e+08
C209_210	209	210	9.0272919506127075e-16
R209_215	209	215	1.6312713170835989e+09
C209_215	209	215	5.4277836704868914e-16
R209_275	209	275	2.3031574995277166e+09
C209_275	209	275	3.8443692273826834e-16
R209_277	209	277	8.9222876172970212e+08
C209_277	209	277	9.9236745067879238e-16
R210_211	210	211	2.5025854533407016e+09
C210_211	210	211	3.5380161765028023e-16
R210_212	210	212	4.1131497363513203e+09
C210_212	210	212	2.1526538989690040e-16
R210_213	210	213	1.5123864357794573e+09
C210_213	210	213	5.8544480481515996e-16
R210_276	210	276	1.8987844877167835e+09
C210_276	210	276	4.6630820265689162e-16
R210_277	210	277	1.1275752528580344e+09
C210_277	210	277	7.8524141023470767e-16
R210_278	210	278	2.3900208695568223e+09
C210_278	210	278	3.7046487458671510e-16
R211_212	211	212	4.2533988737803912e+09
C211_212	211	212	2.0816735226927965e-16
R211_216	211	216	5.2696532063964052e+09
C211_216	211	216	1.6802221076431783e-16
R211_277	211	277	4.7586239335621204e+09
C211_277	211	277	1.8606613888002914e-16
R211_278	211	278	4.8571120593198271e+09
C211_278	211	278	1.8229325798672040e-16
R212_213	212	213	8.8477992011583364e+08
C212_213	212	213	1.0007220570558189e-15
R212_233	212	233	3.3324872305196185e+09
C212_233	212	233	2.6569307560765692e-16
R212_278	212	278	3.2973321924509101e+09
C212_278	212	278	2.6852580511212234e-16
R212_279	212	279	5.0432310831890116e+09
C212_279	212	279	1.7556577660132096e-16
R213_233	213	233	4.1439535535264468e+09
C213_233	213	233	2.1366522820858381e-16
R213_274	213	274	1.6117855107273455e+09
C213_274	213	274	5.4934032835450903e-16
R213_276	213	276	1.9602292289559853e+09
C213_276	213	276	4.5169144945949636e-16
R213_278	213	278	3.6254903022805085e+09
C213_278	213	278	2.4422042479138699e-16
R213_279	213	279	2.5635833826416945e+09
C213_279	213	279	3.4538325833100191e-16
R214_215	214	215	1.2906042966248748e+09
C214_215	214	215	6.8604977065046504e-16
R214_216	214	216	4.2541311799855270e+09
C214_216	214	216	2.0813151833813751e-16
R214_219	214	219	3.5235974302803321e+09
C214_219	214	219	2.5128261647913553e-16
R214_220	214	220	3.5529196223819900e+09
C214_220	214	220	2.4920878483211712e-16
R214_273	214	273	2.4841866536169262e+09
C214_273	214	273	3.5642200251371939e-16
R214_281	214	281	4.5366152390590906e+09
C214_281	214	281	1.9517167205999135e-16
R215_216	215	216	9.0604358080664003e+08
C215_216	215	216	9.7723641605817914e-16
R215_219	215	219	1.7335025137326562e+09
C215_219	215	219	5.1076867479902078e-16
R215_253	215	253	4.7662027201207285e+09
C215_253	215	253	1.8577027325383515e-16
R215_272	215	272	1.3640890060729125e+09
C215_272	215	272	6.4909164853475345e-16
R215_273	215	273	2.7254634945880208e+09
C215_273	215	273	3.2486906665900482e-16
R215_275	215	275	2.0821553320945129e+09
C215_275	215	275	4.2524146400226842e-16
R215_277	215	277	1.2346323494279187e+09
C215_277	215	277	7.1715177567659663e-16
R215_280	215	280	2.0320556995646553e+09
C215_280	215	280	4.3572564565513185e-16
R215_281	215	281	1.0270641919005619e+09
C215_281	215	281	8.6208709122800804e-16
R215_282	215	282	2.5373888114698439e+09
C215_282	215	282	3.4894880031692891e-16
R216_277	216	277	1.5277866224682963e+09
C216_277	216	277	5.7954348380765046e-16
R216_278	216	278	5.9934558711587515e+09
C216_278	216	278	1.4773092531818655e-16
R216_281	216	281	4.5263119307320976e+09
C216_281	216	281	1.9561594411739762e-16
R216_282	216	282	2.6858838152010612e+09
C216_282	216	282	3.2965639715644928e-16
R217_218	217	218	2.7147163926632595e+09
C217_218	217	218	3.2615516821312009e-16
R217_221	217	221	2.6454823059617996e+09
C217_221	217	221	3.3469087270197951e-16
R217_261	217	261	2.5964372199122458e+09
C217_261	217	261	3.4101297536087754e-16
R217_270	217	270	2.8602008335007753e+09
C217_270	217	270	3.0956524847112977e-16
R217_260	217	260	3.5757523202833080e+09
C217_260	217	260	2.4761748085221070e-16
R217_286	217	286	5.3852907129970598e+09
C217_286	217	286	1.6441429606819511e-16
R218_221	218	221	5.8871197386386118e+09
C218_221	218	221	1.5039931596579894e-16
R218_260	218	260	5.2667948949119825e+09
C218_260	218	260	1.6811339711659628e-16
R218_286	218	286	3.1996846040906234e+09
C218_286	218	286	2.7672064320590855e-16
R218_251	218	251	1.3936967054169426e+10
C218_251	218	251	6.3530234251010554e-17
R219_220	219	220	9.5461790182375813e+08
C219_220	219	220	9.2751118537421524e-16
R219_270	219	270	1.7111580990644979e+09
C219_270	219	270	5.1743832564861464e-16
R219_272	219	272	8.0744639273318064e+08
C219_272	219	272	1.0965666447562982e-15
R219_273	219	273	1.4395598280233772e+09
C219_273	219	273	6.1506216307504626e-16
R219_287	219	287	2.9762095161960158e+09
C219_287	219	287	2.9749880741987576e-16
R220_221	220	221	4.3653533491779299e+09
C220_221	220	221	2.0282866262515478e-16
R220_270	220	270	6.0324372066916056e+09
C220_270	220	270	1.4677629478145764e-16
R220_273	220	273	5.0558368088592920e+09
C220_273	220	273	1.7512803818123430e-16
R220_287	220	287	4.7713202732463408e+09
C220_287	220	287	1.8557102248296010e-16
R221_270	221	270	2.6565657831548705e+09
C221_270	221	270	3.3329450650700587e-16
R221_286	221	286	3.3493449540291562e+09
C221_286	221	286	2.6435580504625815e-16
R221_287	221	287	3.9617784661077504e+09
C221_287	221	287	2.2349023027778728e-16
R222_235	222	235	2.1084005717569358e+09
C222_235	222	235	4.1994808461002183e-16
R222_236	222	236	2.9345846533662782e+09
C222_236	222	236	3.0171860289814141e-16
R222_246	222	246	3.2446611989744983e+09
C222_246	222	246	2.7288481829161204e-16
R222_248	222	248	1.3676202935886924e+09
C222_248	222	248	6.4741565027279941e-16
R222_288	222	288	6.0026996064641981e+09
C222_288	222	288	1.4750343008111029e-16
R223_224	223	224	3.2776134220091133e+09
C223_224	223	224	2.7014130945230743e-16
R223_228	223	228	3.5120173319696636e+09
C223_228	223	228	2.5211116518135913e-16
R223_254	223	254	4.5436440939865379e+09
C223_254	223	254	1.9486974846287849e-16
R223_255	223	255	3.5047201177102666e+09
C223_255	223	255	2.5263608846416800e-16
R223_257	223	257	4.8626405309744606e+09
C223_257	223	257	1.8208600369695936e-16
R223_258	223	258	3.5745304971747642e+09
C223_258	223	258	2.4770211987275449e-16
R223_290	223	290	2.1784945747688313e+09
C223_290	223	290	4.0643607377078517e-16
R224_228	224	228	3.5084822300288315e+09
C224_228	224	228	2.5236518917546974e-16
R224_247	224	247	4.1869015202711740e+09
C224_247	224	247	2.1147351505956942e-16
R224_258	224	258	2.0658990358665667e+09
C224_258	224	258	4.2858763488826560e-16
R224_246	224	246	2.1437091296745093e+09
C224_246	224	246	4.1303121279071941e-16
R224_290	224	290	3.8378344829837909e+09
C224_290	224	290	2.3070791239845648e-16
R224_291	224	291	3.1878688839604201e+09
C224_291	224	291	2.7774629821036047e-16
R224_289	224	289	3.3648995394834704e+09
C224_289	224	289	2.6313379383561528e-16
R224_292	224	292	3.6739112030508065e+09
C224_292	224	292	2.4100168261136809e-16
R225_226	225	226	5.9421643141352072e+09
C225_226	225	226	1.4900610869910949e-16
R225_227	225	227	4.0075599497526755e+09
C225_227	225	227	2.2093712703028759e-16
R225_229	225	229	6.0390722158595572e+09
C225_229	225	229	1.4661503457016967e-16
R225_254	225	254	4.5752194787419538e+09
C225_254	225	254	1.9352487586966284e-16
R225_262	225	262	4.8165892313518267e+09
C225_262	225	262	1.8382692381918111e-16
R225_294	225	294	8.3891685002104988e+09
C225_294	225	294	1.0554309186634922e-16
R226_229	226	229	9.1147832686908972e+08
C226_229	226	229	9.7140958331000180e-16
R226_231	226	231	3.7889276721294761e+09
C226_231	226	231	2.3368584948531669e-16
R226_294	226	294	6.4842255021516037e+09
C226_294	226	294	1.3654965907743327e-16
R227_261	227	261	2.6756247351698399e+09
C227_261	227	261	3.3092039031542164e-16
R227_262	227	262	2.0944849475766296e+09
C227_262	227	262	4.2273819285474037e-16
R227_264	227	264	1.5205959849842904e+09
C227_264	227	264	5.8228404549492959e-16
R227_294	227	294	8.5839014846579475e+09
C227_294	227	294	1.0314875855489649e-16
R227_296	227	296	4.7274166438857765e+09
C227_296	227	296	1.8729442492553730e-16
R228_229	228	229	1.9411568739212072e+09
C228_229	228	229	4.5612943167824555e-16
R228_230	228	230	5.0308848566497564e+09
C228_230	228	230	1.7599663020107992e-16
R228_247	228	247	1.9727474702503014e+09
C228_247	228	247	4.4882520193406124e-16
R228_254	228	254	2.3672969643003607e+09
C228_254	228	254	3.7402100161171790e-16
R228_290	228	290	2.7006511050500522e+09
C228_290	228	290	3.2785382015630277e-16
R228_291	228	291	3.7439852128207250e+09
C228_291	228	291	2.3649099325179336e-16
R228_298	228	298	3.4217780755490384e+09
C228_298	228	298	2.5875985004022536e-16
R228_299	228	299	2.3376699977939196e+09
C228_299	228	299	3.7876123770060697e-16
R229_230	229	230	3.1849973626509209e+09
C229_230	229	230	2.7799670796683258e-16
R229_231	229	231	1.1336919041785414e+09
C229_231	229	231	7.8100476720045285e-16
R229_254	229	254	2.3832024654071679e+09
C229_254	229	254	3.7152478421455762e-16
R229_262	229	262	4.9656010296188288e+09
C229_262	229	262	1.7831049583296202e-16
R229_294	229	294	1.8763051978772137e+09
C229_294	229	294	4.7189486161512099e-16
R229_298	229	298	3.1176799462574391e+09
C229_298	229	298	2.8399925488274846e-16
R229_299	229	299	1.2589167693434627e+09
C229_299	229	299	7.0331796609695993e-16
R229_300	229	300	5.8027623857289467e+09
C229_300	229	300	1.5258573810941478e-16
R230_231	230	231	2.9777762748160977e+09
C230_231	230	231	2.9734227825919594e-16
R230_232	230	232	5.1474020609290304e+09
C230_232	230	232	1.7201274958113434e-16
R230_247	230	247	4.5203831875433893e+09
C230_247	230	247	1.9587250570701788e-16
R230_298	230	298	1.6381923930361841e+09
C230_298	230	298	5.4048522350844734e-16
R230_301	230	301	3.6302486703540082e+09
C230_301	230	301	2.4390031154908663e-16
R230_302	230	302	3.7560597014540563e+09
C230_302	230	302	2.3573075299022385e-16
R231_232	231	232	5.5390954184265060e+09
C231_232	231	232	1.5984898522501376e-16
R231_294	231	294	7.5062693140034790e+09
C231_294	231	294	1.1795723609972114e-16
R231_298	231	298	5.0729032096001520e+09
C231_298	231	298	1.7453886761024743e-16
R231_300	231	300	2.8899603840075264e+09
C231_300	231	300	3.0637748067403754e-16
R231_302	231	302	4.0402435621148267e+09
C231_302	231	302	2.1914985274712897e-16
R232_302	232	302	5.4958664395117831e+08
C232_302	232	302	1.6110631352581688e-15
R232_300	232	300	3.7598341128341632e+09
C232_300	232	300	2.3549410828462626e-16
R232_301	232	301	3.7598341128341556e+09
C232_301	232	301	2.3549410828462675e-16
R232_304	232	304	2.0286711400632045e+09
C232_304	232	304	4.3645259412149683e-16
R232_305	232	305	2.0813458338401158e+09
C232_305	232	305	4.2540685325051849e-16
R232_306	232	306	6.0909312627913427e+09
C232_306	232	306	1.4536673350902861e-16
R233_274	233	274	1.7976794731468554e+09
C233_274	233	274	4.9253428930245611e-16
R233_267	233	267	4.1817090650754781e+09
C233_267	233	267	2.1173610309114572e-16
R233_279	233	279	2.6427043077954955e+09
C233_279	233	279	3.3504269815135064e-16
R233_308	233	308	3.9832272189106164e+09
C233_308	233	308	2.2228678733074022e-16
R234_237	234	237	1.6549833250117931e+09
C234_237	234	237	5.3500163313953064e-16
R234_241	234	241	1.9108141370268238e+09
C234_241	234	241	4.6337253034860218e-16
R234_243	234	243	1.6820545671409893e+09
C234_243	234	243	5.2639123545495801e-16
R234_312	234	312	3.0919810927255306e+09
C234_312	234	312	2.8635970115830102e-16
R235_236	235	236	9.6527531999128199e+08
C235_236	235	236	9.1727071371512632e-16
R235_237	235	237	1.1667179417661915e+09
C235_237	235	237	7.5889703072504631e-16
R235_238	235	238	2.2321083880048418e+09
C235_238	235	238	3.9667373970644268e-16
R235_239	235	239	6.9776460423508811e+08
C235_239	235	239	1.2689362233709529e-15
R235_241	235	241	1.9484546877188432e+09
C235_241	235	241	4.5442102774101753e-16
R235_248	235	248	1.0104816080543650e+09
C235_248	235	248	8.7623443578041224e-16
R235_311	235	311	1.5168808190072517e+09
C235_311	235	311	5.8371018382279859e-16
R235_312	235	312	2.1912214387975426e+09
C235_312	235	312	4.0407544669966519e-16
R235_313	235	313	1.5511978300655925e+09
C235_313	235	313	5.7079681555676255e-16
R236_238	236	238	4.0365062654042516e+09
C236_238	236	238	2.1935275792550428e-16
R236_248	236	248	1.9908268031722937e+09
C236_248	236	248	4.4474927717927283e-16
R236_288	236	288	8.8578975757398891e+09
C236_288	236	288	9.9958119195800503e-17
R236_250	236	250	3.4058066119692340e+09
C236_250	236	250	2.5997329930252617e-16
R236_249	236	249	4.4299895481635151e+09
C236_249	236	249	1.9986927103858677e-16
R236_311	236	311	3.4491544009138532e+09
C236_311	236	311	2.5670604408588046e-16
R236_313	236	313	4.1209535445424919e+09
C236_313	236	313	2.1485774399776673e-16
R237_238	237	238	4.7530466710808172e+09
C237_238	237	238	1.8628447035607599e-16
R237_241	237	241	8.0789452284614096e+09
C237_241	237	241	1.0959583914255886e-16
R237_312	237	312	5.5221519988838787e+09
C237_312	237	312	1.6033944409334593e-16
R237_313	237	313	9.0887535200560932e+09
C237_313	237	313	9.7419165317461002e-17
R238_313	238	313	2.5583906747221580e+09
C238_313	238	313	3.4608427494997687e-16
R238_249	238	249	1.1324229472644638e+10
C238_249	238	249	7.8187993614829237e-17
R239_241	239	241	9.1528918015187919e+08
C239_241	239	241	9.6736506986030090e-16
R239_240	239	240	1.8962713403462207e+09
C239_240	239	240	4.6692620558107501e-16
R239_248	239	248	1.5135681590506566e+09
C239_248	239	248	5.8498771687649290e-16
R239_252	239	252	2.9520132680275836e+09
C239_252	239	252	2.9993726359217940e-16
R239_256	239	256	1.0055606808636498e+09
C239_256	239	256	8.8052247721095950e-16
R239_259	239	259	2.0774661425768757e+09
C239_259	239	259	4.2620130530826955e-16
R239_310	239	310	1.5241571619698877e+09
C239_310	239	310	5.8092354502054493e-16
R239_311	239	311	1.1440456789472520e+09
C239_311	239	311	7.7393656389206452e-16
R239_312	239	312	2.5968326782210927e+09
C239_312	239	312	3.4096104424661598e-16
R239_315	239	315	6.3394197600683284e+08
C239_315	239	315	1.3966874181091563e-15
R239_316	239	316	2.5353388625137181e+09
C239_316	239	316	3.4923094296836199e-16
R240_241	240	241	1.1357481769033701e+09
C240_241	240	241	7.7959075762208488e-16
R240_242	240	242	1.4188647224042842e+09
C240_242	240	242	6.2403326245200226e-16
R240_252	240	252	1.7034085541573508e+09
C240_252	240	252	5.1979237719514853e-16
R240_256	240	256	3.0767723874557242e+09
C240_256	240	256	2.8777519757715305e-16
R240_265	240	265	1.6724009683535993e+09
C240_265	240	265	5.2942972316719810e-16
R240_266	240	266	1.8808904863609498e+09
C240_266	240	266	4.7074446285975037e-16
R240_316	240	316	2.6016613407234397e+09
C240_316	240	316	3.4032822329357955e-16
R241_242	241	242	1.0590442479709516e+09
C241_242	241	242	8.3605456844357084e-16
R241_243	241	243	1.9282668944610856e+09
C241_243	241	243	4.5917854226681505e-16
R241_312	241	312	6.6926564846762860e+08
C241_312	241	312	1.3229706077508717e-15
R241_315	241	315	2.2368824811425290e+09
C241_315	241	315	3.9582713404226585e-16
R241_316	241	316	1.8916035244612286e+09
C241_316	241	316	4.6807841614282634e-16
R241_318	241	318	1.5926856879106271e+09
C241_318	241	318	5.5592813347970813e-16
R242_243	242	243	1.6882330193626664e+09
C242_243	242	243	5.2446479339342557e-16
R242_245	242	245	1.4112485432163465e+09
C242_245	242	245	6.2740102440216572e-16
R242_244	242	244	1.4337855419695501e+09
C242_244	242	244	6.1753920358530440e-16
R242_265	242	265	1.0199766314887934e+09
C242_265	242	265	8.6807751703841663e-16
R242_316	242	316	3.9182635276348147e+09
C242_316	242	316	2.2597223883878639e-16
R242_318	242	318	1.6564267598425207e+09
C242_318	242	318	5.3453542478641082e-16
R243_245	243	245	2.5476382614019284e+09
C243_245	243	245	3.4754493803714764e-16
R243_312	243	312	5.4784408899830656e+09
C243_312	243	312	1.6161875239339070e-16
R243_318	243	318	4.4160699505684443e+09
C243_318	243	318	2.0049926554855118e-16
R244_245	244	245	5.4730498289362013e+08
C244_245	244	245	1.6177795002317734e-15
R244_265	244	265	8.5859306066251600e+08
C244_265	244	265	1.0312438130082073e-15
R244_267	244	267	9.3061515234659517e+08
C244_267	244	267	9.5143387625633441e-16
R244_274	244	274	8.7600849699938834e+08
C244_274	244	274	1.0107422299359482e-15
R244_317	244	317	1.3920128224986241e+09
C244_317	244	317	6.3607085178331774e-16
R244_318	244	318	2.4340855716150498e+09
C244_318	244	318	3.6375828032722466e-16
R244_319	244	319	8.7405192475276244e+08
C244_319	244	319	1.0130047845274786e-15
R245_267	245	267	5.8488906285621710e+09
C245_267	245	267	1.5138234546158061e-16
R245_318	245	318	4.6010487397114916e+09
C245_318	245	318	1.9243847039871176e-16
R245_319	245	319	5.4260429181422110e+09
C245_319	245	319	1.6317946523046544e-16
R246_248	246	248	2.6527958461290655e+09
C246_248	246	248	3.3376815746752431e-16
R246_258	246	258	1.2206601753098881e+09
C246_258	246	258	7.2536058733563542e-16
R246_259	246	259	2.7525580631966338e+09
C246_259	246	259	3.2167124593612929e-16
R246_288	246	288	3.5639710277047973e+09
C246_288	246	288	2.4843602117332901e-16
R246_292	246	292	2.3987495557100024e+09
C246_292	246	292	3.6911680904425488e-16
R246_289	246	289	2.3242084040588942e+09
C246_289	246	289	3.8095498671880889e-16
R246_320	246	320	2.3827897086656246e+09
C246_320	246	320	3.7158914128256817e-16
R247_291	247	291	1.3414103248022983e+09
C247_291	247	291	6.6006557824168821e-16
R247_289	247	289	5.8553395603658514e+09
C247_289	247	289	1.5121561654482044e-16
R247_298	247	298	1.9132770846914902e+09
C247_298	247	298	4.6277603426310355e-16
R247_301	247	301	5.4795630397325735e+09
C247_301	247	301	1.6158565478301574e-16
R247_321	247	321	4.0490163015126271e+09
C247_321	247	321	2.1867503506202882e-16
R248_259	248	259	9.0811662683976519e+08
C248_259	248	259	9.7500558356832065e-16
R248_288	248	288	8.0474756036380947e+08
C248_288	248	288	1.1002441328305749e-15
R248_250	248	250	2.2235884282003536e+09
C248_250	248	250	3.9819364522264934e-16
R248_310	248	310	1.3067217726728401e+09
C248_310	248	310	6.7758783867886134e-16
R248_311	248	311	1.1114821674609795e+09
C248_311	248	311	7.9661087475889204e-16
R248_320	248	320	1.8811842017665656e+09
C248_320	248	320	4.7067096399625776e-16
R248_322	248	322	1.8544168492800462e+09
C248_322	248	322	4.7746480627791571e-16
R249_250	249	250	1.8337446420781085e+09
C249_250	249	250	4.8284737219277746e-16
R249_311	249	311	3.1768558344362102e+09
C249_311	249	311	2.7870914761139406e-16
R249_313	249	313	2.7980748004651227e+09
C249_313	249	313	3.1643856752965193e-16
R249_323	249	323	1.6971819496778677e+09
C249_323	249	323	5.2169938636694566e-16
R249_324	249	324	9.9604530105443153e+09
C249_324	249	324	8.8893424903734786e-17
R250_288	250	288	2.3972361625779815e+09
C250_288	250	288	3.6934983524853192e-16
R250_311	250	311	1.8753727286002967e+09
C250_311	250	311	4.7212949628463527e-16
R250_309	250	309	1.6652658214321108e+09
C250_309	250	309	5.3169816512450215e-16
R250_322	250	322	1.1361037616517246e+09
C250_322	250	322	7.7934675650816767e-16
R250_323	250	323	1.2979162086437960e+09
C250_323	250	323	6.8218485585073470e-16
R250_324	250	324	2.3667940646065106e+09
C250_324	250	324	3.7410047411421266e-16
R250_326	250	326	2.5259268814369974e+09
C250_326	250	326	3.5053222965673737e-16
R251_260	251	260	2.7822802337830329e+09
C251_260	251	260	3.1823493943890281e-16
R251_286	251	286	4.5803432015026484e+09
C251_286	251	286	1.9330839256969334e-16
R251_297	251	297	2.5518417311493454e+09
C251_297	251	297	3.4697245165796735e-16
R251_328	251	328	1.7972274243964493e+09
C251_328	251	328	4.9265817429719232e-16
R251_329	251	329	1.0212118976478289e+10
C251_329	251	329	8.6702748346292957e-17
R252_253	252	253	3.7921587939448705e+09
C252_253	252	253	2.3348673666139517e-16
R252_256	252	256	2.3338472989521399e+09
C252_256	252	256	3.7938162539491715e-16
R252_257	252	257	2.6305363451808953e+09
C252_257	252	257	3.3659249123171180e-16
R252_258	252	258	3.5448794845813460e+09
C252_258	252	258	2.4977401504090030e-16
R252_259	252	259	2.8654909341256986e+09
C252_259	252	259	3.0899374733850058e-16
R252_266	252	266	1.7771482615820072e+09
C252_266	252	266	4.9822448742222849e-16
R252_283	252	283	1.1142047244591501e+09
C252_283	252	283	7.9466435769224913e-16
R252_330	252	330	3.9449355674416504e+09
C252_330	252	330	2.2444442160412962e-16
R253_257	253	257	3.6359005435284386e+09
C253_257	253	257	2.4352117751844504e-16
R253_266	253	266	3.0992336848671622e+09
C253_266	253	266	2.8568958385529103e-16
R253_271	253	271	2.2758422549730158e+09
C253_271	253	271	3.8905103364050955e-16
R253_272	253	272	3.6405414291714959e+09
C253_272	253	272	2.4321074184328151e-16
R253_269	253	269	1.3472246814827676e+09
C253_269	253	269	6.5721686506329448e-16
R253_275	253	275	1.0254363956357445e+09
C253_275	253	275	8.6345558385516703e-16
R253_268	253	268	1.4404660847693980e+09
C253_268	253	268	6.1467520204874892e-16
R253_330	253	330	1.5786451739090621e+09
C253_330	253	330	5.6087257373201477e-16
R254_255	254	255	6.8378905972052372e+08
C254_255	254	255	1.2948712312856923e-15
R254_262	254	262	9.5799025620524132e+08
C254_262	254	262	9.2424612459764592e-16
R254_290	254	290	2.0572812575651057e+09
C254_290	254	290	4.3038295247385721e-16
R254_299	254	299	2.4516964889599705e+09
C254_299	254	299	3.6114534800170228e-16
R254_293	254	293	4.0395775802145576e+09
C254_293	254	293	2.1918598272173105e-16
R254_331	254	331	3.5494135108442612e+09
C254_331	254	331	2.4945495333097862e-16
R255_257	255	257	7.0957643332171607e+08
C255_257	255	257	1.2478131179683058e-15
R255_262	255	262	2.8915522542566376e+09
C255_262	255	262	3.0620881237632152e-16
R255_263	255	263	1.4408577357305877e+09
C255_263	255	263	6.1450812231024882e-16
R255_290	255	290	1.2185655770648515e+09
C255_290	255	290	7.2660741314611944e-16
R255_331	255	331	1.3512682430097725e+09
C255_331	255	331	6.5525019645828887e-16
R256_259	256	259	9.8287418207512105e+08
C256_259	256	259	9.0084651509579224e-16
R256_266	256	266	6.6646309581304204e+08
C256_266	256	266	1.3285338487044750e-15
R256_283	256	283	3.5817111554018766e+08
C256_283	256	283	2.4720552364046057e-15
R256_285	256	285	3.2815589793564153e+08
C256_285	256	285	2.6981650711444774e-15
R256_310	256	310	4.3119913156460619e+08
C256_310	256	310	2.0533872099585585e-15
R256_315	256	315	1.0245147233311075e+09
C256_315	256	315	8.6423236439311393e-16
R256_314	256	314	4.4528700771409494e+08
C256_314	256	314	1.9884226720320122e-15
R256_316	256	316	6.3246163771911407e+08
C256_316	256	316	1.3999565015407753e-15
R256_332	256	332	1.0964446125956542e+09
C256_332	256	332	8.0753625995198705e-16
R257_258	257	258	3.9445946274009194e+09
C257_258	257	258	2.2446382083205331e-16
R257_263	257	263	4.6868600922083654e+09
C257_263	257	263	1.8891512959218850e-16
R257_271	257	271	4.6639980543099880e+09
C257_271	257	271	1.8984115589023173e-16
R257_283	257	283	8.2062540322314520e+09
C257_283	257	283	1.0789560964386039e-16
R257_290	257	290	3.2424296275741668e+09
C257_290	257	290	2.7307262867642515e-16
R257_330	257	330	3.4265270747713666e+09
C257_330	257	330	2.5840122152225492e-16
R257_331	257	331	3.4866196723782210e+09
C257_331	257	331	2.5394762403094472e-16
R257_333	257	333	5.2975649477047281e+09
C257_333	257	333	1.6713693752515951e-16
R258_259	258	259	2.0531228017516012e+09
C258_259	258	259	4.3125466286995304e-16
R258_283	258	283	4.3815377105390100e+09
C258_283	258	283	2.0207946163975319e-16
R258_290	258	290	2.4478299463906245e+09
C258_290	258	290	3.6171580587351190e-16
R258_292	258	292	1.6065761646519499e+09
C258_292	258	292	5.5112157218628854e-16
R258_333	258	333	4.1468536115062885e+09
C258_333	258	333	2.1351580370313188e-16
R259_283	259	283	1.1733825808565466e+09
C259_283	259	283	7.5458660810667695e-16
R259_292	259	292	2.6012397665387144e+09
C259_292	259	292	3.4038337914469310e-16
R259_310	259	310	1.8116929620639064e+09
C259_310	259	310	4.8872452465196892e-16
R259_320	259	320	3.0665183334209657e+09
C259_320	259	320	2.8873748186994828e-16
R259_332	259	332	2.3802541012573156e+09
C259_332	259	332	3.7198498312944718e-16
R259_333	259	333	5.4218058646309824e+09
C259_333	259	333	1.6330698734087989e-16
R260_261	260	261	3.0568506957892318e+09
C260_261	260	261	2.8965064696147963e-16
R260_270	260	270	7.1969964284283638e+09
C260_270	260	270	1.2302615271595353e-16
R260_286	260	286	3.0438160925967908e+09
C260_286	260	286	2.9089102454433012e-16
R260_297	260	297	3.6581607816638713e+09
C260_297	260	297	2.4203932920008992e-16
R260_328	260	328	6.9098086955788412e+09
C260_328	260	328	1.2813940598189424e-16
R260_334	260	334	3.9659723949615283e+09
C260_334	260	334	2.2325389425928901e-16
R260_296	260	296	8.9815122577994671e+09
C260_296	260	296	9.8582371908595918e-17
R261_264	261	264	2.5811560829137168e+09
C261_264	261	264	3.4303186373003150e-16
R261_270	261	270	4.6084673178542891e+09
C261_270	261	270	1.9212868848384338e-16
R261_296	261	296	5.9363485502358589e+09
C261_296	261	296	1.4915208805669287e-16
R261_334	261	334	8.9541065951085567e+09
C261_334	261	334	9.8884101087615613e-17
R262_263	262	263	2.6100101595394964e+09
C262_263	262	263	3.3923959202374174e-16
R262_264	262	264	1.2004679073993237e+09
C262_264	262	264	7.3756139272240804e-16
R262_294	262	294	1.8642929710996399e+09
C262_294	262	294	4.7493542883323855e-16
R262_295	262	295	1.5092654342658806e+09
C262_295	262	295	5.8665544283843946e-16
R262_293	262	293	2.2285499692280798e+09
C262_293	262	293	3.9730712522757086e-16
R262_296	262	296	4.4672212566145239e+09
C262_296	262	296	1.9820347612936752e-16
R262_299	262	299	5.5215502846699314e+09
C262_299	262	299	1.6035691717927166e-16
R262_331	262	331	3.3163313887980423e+09
C262_331	262	331	2.6698742613322112e-16
R262_335	262	335	3.2299807545174384e+09
C262_335	262	335	2.7412509516090975e-16
R263_264	263	264	1.2346378892755792e+09
C263_264	263	264	7.1714855780063380e-16
R263_270	263	270	2.5875496037717447e+09
C263_270	263	270	3.4218427365000783e-16
R263_271	263	271	1.2030322924288232e+09
C263_271	263	271	7.3598920600245259e-16
R263_331	263	331	1.6628730121493666e+09
C263_331	263	331	5.3246325800641950e-16
R263_335	263	335	1.6145366295485506e+09
C263_335	263	335	5.4840426999019329e-16
R264_270	264	270	2.1777421164830780e+09
C264_270	264	270	4.0657650646436401e-16
R264_296	264	296	3.2953464701650777e+09
C264_296	264	296	2.6868761440299955e-16
R264_295	264	295	2.7142606662163305e+09
C264_295	264	295	3.2620992991593202e-16
R264_334	264	334	3.4950926308911443e+09
C264_334	264	334	2.5333199294184223e-16
R264_335	264	335	2.5817840233985825e+09
C264_335	264	335	3.4294843165636357e-16
R265_266	265	266	1.2012448911434858e+09
C265_266	265	266	7.3708432662481893e-16
R265_274	265	274	3.6355302448633022e+09
C265_274	265	274	2.4354598148400012e-16
R265_275	265	275	3.5476355455637994e+09
C265_275	265	275	2.4957997244310707e-16
R265_276	265	276	1.7617159364207497e+09
C265_276	265	276	5.0258884726835776e-16
R265_284	265	284	3.3918224708135219e+09
C265_284	265	284	2.6104514293392079e-16
R265_316	265	316	1.7031725966897480e+09
C265_316	265	316	5.1986438921157043e-16
R265_317	265	317	1.5968709904763925e+09
C265_317	265	317	5.5447107936744115e-16
R265_318	265	318	4.6209744665997629e+09
C265_318	265	318	1.9160867217505206e-16
R265_319	265	319	4.0601732948549385e+09
C265_319	265	319	2.1807413560943445e-16
R265_338	265	338	3.5048291986892200e+09
C265_338	265	338	2.5262822565822618e-16
R266_275	266	275	3.2753659346799550e+09
C266_275	266	275	2.7032667474650177e-16
R266_268	266	268	1.9099069654337537e+09
C266_268	266	268	4.6359262399931350e-16
R266_283	266	283	3.6431647385124965e+09
C266_283	266	283	2.4303561470610750e-16
R266_284	266	284	3.5107103687753053e+09
C266_284	266	284	2.5220502083425188e-16
R266_285	266	285	8.8945357938682365e+08
C266_285	266	285	9.9546373438667241e-16
R266_316	266	316	3.5929090786462970e+09
C266_316	266	316	2.4643506482318222e-16
R266_330	266	330	2.3614400128308139e+09
C266_330	266	330	3.7494866559772997e-16
R266_337	266	337	1.7476827143566761e+09
C266_337	266	337	5.0662444299903925e-16
R266_338	266	338	3.9156195977543769e+09
C266_338	266	338	2.2612482126910161e-16
R267_274	267	274	9.3231699054501522e+08
C267_274	267	274	9.4969714236613953e-16
R267_308	267	308	2.3484089207233100e+09
C267_308	267	308	3.7702921918184975e-16
R267_317	267	317	1.1983474996052201e+09
C267_317	267	317	7.3886646568853334e-16
R267_319	267	319	1.6276936354696453e+09
C267_319	267	319	5.4397139756863799e-16
R267_339	267	339	3.6474125737600842e+09
C267_339	267	339	2.4275257152695233e-16
R268_275	268	275	1.5636340145832081e+09
C268_275	268	275	5.6625704828761450e-16
R268_269	268	269	1.0794028612609794e+09
C268_269	268	269	8.2028574638540121e-16
R268_280	268	280	3.5098876179530358e+09
C268_280	268	280	2.5226414007419870e-16
R268_284	268	284	2.0012675609410789e+09
C268_284	268	284	4.4242898799780654e-16
R268_330	268	330	2.2607744738413720e+09
C268_330	268	330	3.9164401046847891e-16
R268_337	268	337	2.0309269866146679e+09
C268_337	268	337	4.3596780560580165e-16
R268_340	268	340	1.1088127210509055e+09
C268_340	268	340	7.9852870091607717e-16
R269_271	269	271	1.7539084509606266e+09
C269_271	269	271	5.0482611063026167e-16
R269_272	269	272	1.9559226505879395e+09
C269_272	269	272	4.5268599013046250e-16
R269_275	269	275	3.0479962972416496e+09
C269_275	269	275	2.9049207917387531e-16
R269_280	269	280	1.7079902984423811e+09
C269_280	269	280	5.1839801578935588e-16
R269_330	269	330	2.0663510878967352e+09
C269_330	269	330	4.2849387351751350e-16
R269_340	269	340	1.0044624388312597e+09
C269_340	269	340	8.8148520787917894e-16
R269_341	269	341	1.0505606111570754e+09
C269_341	269	341	8.4280599548160295e-16
R269_342	269	342	2.4618642964455047e+09
C269_342	269	342	3.5965377254074797e-16
R269_343	269	343	1.6781293385953467e+09
C269_343	269	343	5.2762249091069863e-16
R270_271	270	271	4.9044065941555204e+09
C270_271	270	271	1.8053535421698832e-16
R270_272	270	272	4.1129274012715249e+09
C270_272	270	272	2.1527702663224010e-16
R270_286	270	286	3.8561915024468102e+09
C270_286	270	286	2.2960965012712381e-16
R270_287	270	287	2.8736949676022091e+09
C270_287	270	287	3.0811160950697125e-16
R270_334	270	334	3.6669438829312682e+09
C270_334	270	334	2.4145959413816212e-16
R270_335	270	335	5.7236632931507454e+09
C270_335	270	335	1.5469442144850511e-16
R270_344	270	344	2.9184335968227239e+09
C270_344	270	344	3.0338835965428470e-16
R271_272	271	272	1.2624181797631927e+09
C271_272	271	272	7.0136726157261857e-16
R271_330	271	330	2.6033255010417047e+09
C271_330	271	330	3.4011067050420907e-16
R271_331	271	331	2.5936719827534814e+09
C271_331	271	331	3.4137654552601755e-16
R271_335	271	335	2.7958644243045321e+09
C271_335	271	335	3.1668873998432416e-16
R271_341	271	341	2.4037051571609254e+09
C271_341	271	341	3.6835581895817438e-16
R271_342	271	342	1.4667860829691050e+09
C271_342	271	342	6.0364547494731699e-16
R271_344	271	344	3.5930064064055328e+09
C271_344	271	344	2.4642838936259480e-16
R272_273	272	273	1.4861489119120266e+09
C272_273	272	273	5.9578066141491262e-16
R272_275	272	275	4.4954614991809225e+09
C272_275	272	275	1.9695837276358039e-16
R272_280	272	280	1.5229570844272747e+09
C272_280	272	280	5.8138130795259529e-16
R272_281	272	281	2.4148702334180055e+09
C272_281	272	281	3.6665273746274097e-16
R272_287	272	287	2.5620460989765658e+09
C272_287	272	287	3.4559049583599965e-16
R272_342	272	342	3.1380411645441318e+09
C272_342	272	342	2.8215652226111770e-16
R272_343	272	343	2.4483545969921489e+09
C272_343	272	343	3.6163829487270926e-16
R272_344	272	344	9.9449137855996549e+08
C272_344	272	344	8.9032323536288099e-16
R272_345	272	345	1.4636822428553457e+09
C272_345	272	345	6.0492554720943281e-16
R273_281	273	281	1.7097696566594131e+09
C273_281	273	281	5.1785851869072900e-16
R273_287	273	287	2.3581327336268458e+09
C273_287	273	287	3.7547453079039020e-16
R273_345	273	345	3.7447461004439874e+09
C273_345	273	345	2.3644294111021899e-16
R274_276	274	276	9.4939152135640013e+08
C274_276	274	276	9.3261711504964566e-16
R274_279	274	279	1.1369474273554356e+09
C274_279	274	279	7.7876844645271193e-16
R274_308	274	308	2.6254326728520479e+09
C274_308	274	308	3.3724680539537737e-16
R274_317	274	317	1.1012466359091556e+09
C274_317	274	317	8.0401497069639212e-16
R274_346	274	346	3.9115096103110356e+09
C274_346	274	346	2.2636242011676744e-16
R275_276	275	276	2.0982437531684444e+09
C275_276	275	276	4.2198089729230785e-16
R275_277	275	277	1.4397101301911013e+09
C275_277	275	277	6.1499795211031327e-16
R275_280	275	280	9.7134323340138996e+08
C275_280	275	280	9.1154058756295121e-16
R275_284	275	284	1.4560685768545296e+09
C275_284	275	284	6.0808865445934179e-16
R275_347	275	347	5.1850328095885315e+09
C275_347	275	347	1.7076435467536879e-16
R276_277	276	277	2.0592738361443508e+09
C276_277	276	277	4.2996650865909123e-16
R276_278	276	278	2.5557825387923889e+09
C276_278	276	278	3.4643744851561654e-16
R276_279	276	279	2.5988248075267978e+09
C276_279	276	279	3.4069968053853508e-16
R276_284	276	284	2.7811737581836700e+09
C276_284	276	284	3.1836154756409379e-16
R276_317	276	317	4.5773579855242090e+09
C276_317	276	317	1.9343446252185579e-16
R276_346	276	346	5.7629562718321075e+09
C276_346	276	346	1.5363968420647335e-16
R276_347	276	347	2.5854570824664965e+09
C276_347	276	347	3.4246121805871189e-16
R277_278	277	278	1.4959481296966693e+09
C277_278	277	278	5.9187799638449687e-16
R277_280	277	280	4.5284760493871174e+09
C277_280	277	280	1.9552246098769418e-16
R277_282	277	282	2.0618473764709790e+09
C277_282	277	282	4.2942983646804499e-16
R277_347	277	347	4.5054571244375563e+09
C277_347	277	347	1.9652140887047778e-16
R278_279	278	279	4.2762114892300715e+09
C278_279	278	279	2.0705682680334854e-16
R278_282	278	282	6.1762281602235107e+09
C278_282	278	282	1.4335914391931364e-16
R278_347	278	347	5.0152750411435127e+09
C278_347	278	347	1.7654441170949604e-16
R279_308	279	308	7.7547299222194510e+09
C279_308	279	308	1.1417790053049167e-16
R279_346	279	346	4.5750128500338182e+09
C279_346	279	346	1.9353361634677267e-16
R279_347	279	347	6.4750273267268667e+09
C279_347	279	347	1.3674363628478775e-16
R280_281	280	281	1.8466316605417893e+09
C280_281	280	281	4.7947774351503548e-16
R280_282	280	282	1.5604702829595108e+09
C280_282	280	282	5.6740509022751693e-16
R280_284	280	284	1.7062171019412062e+09
C280_284	280	284	5.1893676408039555e-16
R280_340	280	340	3.1504231483203511e+09
C280_340	280	340	2.8104757361628117e-16
R280_343	280	343	1.4551845727305088e+09
C280_343	280	343	6.0845805974880557e-16
R280_345	280	345	3.7390242497270808e+09
C280_345	280	345	2.3680477112835755e-16
R280_347	280	347	2.9426036825009456e+09
C280_347	280	347	3.0089637519500235e-16
R280_348	280	348	9.7770234579443467e+08
C280_348	280	348	9.0561180047139055e-16
R281_282	281	282	2.2633895219609480e+09
C281_282	281	282	3.9119151746045625e-16
R281_345	281	345	3.5817263611339869e+09
C281_345	281	345	2.4720447416303277e-16
R281_348	281	348	5.3647233515210438e+09
C281_348	281	348	1.6504463020426954e-16
R282_347	282	347	5.9382442356392202e+09
C282_347	282	347	1.4910447374091368e-16
R282_348	282	348	9.0287217595128193e+09
C282_348	282	348	9.8066903077072607e-17
R283_285	283	285	3.4338666910476890e+09
C283_285	283	285	2.5784890951309892e-16
R283_310	283	310	9.2609212869189892e+09
C283_310	283	310	9.5608066872423376e-17
R283_330	283	330	4.1594320867947211e+09
C283_330	283	330	2.1287011380976967e-16
R283_332	283	332	2.2923495627995095e+09
C283_332	283	332	3.8624946040894866e-16
R283_333	283	333	3.1774739170149465e+09
C283_333	283	333	2.7865493307709031e-16
R283_349	283	349	6.7773714495791273e+09
C283_349	283	349	1.3064339003508273e-16
R284_317	284	317	9.6006276690241890e+09
C284_317	284	317	9.2225093215180821e-17
R284_337	284	337	2.9780521072038093e+09
C284_337	284	337	2.9731473789803794e-16
R284_338	284	338	3.0646614271705947e+09
C284_338	284	338	2.8891243053802863e-16
R284_340	284	340	2.8360857449892964e+09
C284_340	284	340	3.1219746556123316e-16
R284_343	284	343	7.5512868310069475e+09
C284_343	284	343	1.1725402590513587e-16
R284_346	284	346	7.9362959083579798e+09
C284_346	284	346	1.1156574703414673e-16
R284_347	284	347	3.1784728319727950e+09
C284_347	284	347	2.7856735876217754e-16
R284_348	284	348	6.9920918555769186e+09
C284_348	284	348	1.2663145736476371e-16
R284_350	284	350	1.8559407927942584e+09
C284_350	284	350	4.7707275207143630e-16
R285_316	285	316	6.9434226961287603e+09
C285_316	285	316	1.2751906666918853e-16
R285_314	285	314	1.6852086213912952e+09
C285_314	285	314	5.2540603606039316e-16
R285_330	285	330	6.6527745665329742e+09
C285_330	285	330	1.3309015251382960e-16
R285_332	285	332	6.4951809526403503e+09
C285_332	285	332	1.3631934016250452e-16
R285_337	285	337	2.5676942484360061e+09
C285_337	285	337	3.4483030144235931e-16
R285_338	285	338	6.9820778264285469e+09
C285_338	285	338	1.2681307824277104e-16
R285_349	285	349	2.4467348163283787e+09
C285_349	285	349	3.6187770566353329e-16
R285_351	285	351	5.5226966248587780e+09
C285_351	285	351	1.6032363206672453e-16
R286_287	286	287	2.8158231393173976e+09
C286_287	286	287	3.1444403213287045e-16
R286_328	286	328	2.8807170258544250e+09
C286_328	286	328	3.0736055424860183e-16
R286_334	286	334	3.0548659483498173e+09
C286_334	286	334	2.8983883308473393e-16
R286_344	286	344	4.2250903267496428e+09
C286_344	286	344	2.0956209529871800e-16
R286_353	286	353	4.6734436343692942e+09
C286_353	286	353	1.8945746455322166e-16
R287_344	287	344	2.1470221995157616e+09
C287_344	287	344	4.1239386434835043e-16
R287_345	287	345	4.6215674495846996e+09
C287_345	287	345	1.9158408729479108e-16
R287_353	287	353	1.1477787240604179e+10
C287_353	287	353	7.7141940614451786e-17
R288_320	288	320	1.2346136754802997e+09
C288_320	288	320	7.1716262283871668e-16
R288_289	288	289	7.4628649433917627e+09
C288_289	288	289	1.1864328088692306e-16
R288_322	288	322	3.7342957888368926e+09
C288_322	288	322	2.3710461938950425e-16
R288_309	288	309	4.0698547829831328e+09
C288_309	288	309	2.1755537455589594e-16
R288_354	288	354	6.1073212704273062e+09
C288_354	288	354	1.4497661781562878e-16
R289_291	289	291	1.2958894810119977e+09
C289_291	289	291	6.8325177005723579e-16
R289_292	289	292	2.7904144913673520e+09
C289_292	289	292	3.1730726185633069e-16
R289_320	289	320	1.2396513652968998e+09
C289_320	289	320	7.1424822049701052e-16
R289_321	289	321	3.4841174450314312e+09
C289_321	289	321	2.5413000441838222e-16
R289_354	289	354	6.0281585280212259e+09
C289_354	289	354	1.4688047395970580e-16
R290_291	290	291	2.0618708397407081e+09
C290_291	290	291	4.2942494972737784e-16
R290_292	290	292	1.6425909387578118e+09
C290_292	290	292	5.3903790700902477e-16
R290_299	290	299	3.8265847419018006e+09
C290_299	290	299	2.3138616845577805e-16
R290_293	290	293	4.0616597407246685e+09
C290_293	290	293	2.1799432700436552e-16
R290_331	290	331	1.9653076984816046e+09
C290_331	290	331	4.5052425245373735e-16
R290_333	290	333	1.9108591462640345e+09
C290_333	290	333	4.6336161586326400e-16
R290_355	290	355	4.1646864310415478e+09
C290_355	290	355	2.1260154788617913e-16
R290_356	290	356	2.8367973229753070e+09
C290_356	290	356	3.1211915441718965e-16
R290_357	290	357	3.3959461905559902e+09
C290_357	290	357	2.6072815410394881e-16
R291_292	291	292	1.5713941556909411e+09
C291_292	291	292	5.6346065593624524e-16
R291_298	291	298	2.7472387324856400e+09
C291_298	291	298	3.2229408068183902e-16
R291_299	291	299	4.3746130359829454e+09
C291_299	291	299	2.0239933781961414e-16
R291_320	291	320	3.3403195135307255e+09
C291_320	291	320	2.6507008629366421e-16
R291_321	291	321	1.3473584183052428e+09
C291_321	291	321	6.5715163068021074e-16
R291_355	291	355	1.3780041863358784e+09
C291_355	291	355	6.4253707679534272e-16
R291_357	291	357	1.4219022456044345e+09
C291_357	291	357	6.2270017818532844e-16
R292_320	292	320	1.0889738046124816e+09
C292_320	292	320	8.1307629067816012e-16
R292_332	292	332	2.8195732452201557e+09
C292_332	292	332	3.1402581337477028e-16
R292_333	292	333	1.1432675301516311e+09
C292_333	292	333	7.7446333281464522e-16
R292_357	292	357	8.9317492403283024e+08
C292_357	292	357	9.9131621127717093e-16
R293_295	293	295	1.1683025279281795e+09
C293_295	293	295	7.5786772735155013e-16
R293_294	293	294	4.6961372450778809e+09
C293_294	293	294	1.8854193041909626e-16
R293_299	293	299	1.3011847264763792e+09
C293_299	293	299	6.8047123800609210e-16
R293_331	293	331	7.2691974591293859e+08
C293_331	293	331	1.2180420007548464e-15
R293_335	293	335	1.9363478615549147e+09
C293_335	293	335	4.5726225089999903e-16
R293_355	293	355	3.1618899547849422e+09
C293_355	293	355	2.8002833569842642e-16
R293_356	293	356	1.3179140601327276e+09
C293_356	293	356	6.7183347418786127e-16
R293_358	293	358	7.2691974591293871e+08
C293_358	293	358	1.2180420007548460e-15
R293_360	293	360	4.4784640828267175e+08
C293_360	293	360	1.9770590214070478e-15
R293_361	293	361	1.5384332632348783e+09
C293_361	293	361	5.7553278576297926e-16
R294_295	294	295	3.9705557234795933e+09
C294_295	294	295	2.2299618576415898e-16
R294_296	294	296	5.9157818523342142e+09
C294_296	294	296	1.4967062745064488e-16
R294_299	294	299	3.8530723391840796e+09
C294_299	294	299	2.2979552516979085e-16
R294_300	294	300	4.5991476391216488e+09
C294_300	294	300	1.9251801663603444e-16
R294_358	294	358	3.8879514005952859e+09
C294_358	294	358	2.2773401477303271e-16
R294_363	294	363	6.0262947788207464e+09
C294_363	294	363	1.4692589961111443e-16
R295_296	295	296	2.5018543286178021e+09
C295_296	295	296	3.5390501020463760e-16
R295_334	295	334	4.8008521255725384e+09
C295_334	295	334	1.8442950512548998e-16
R295_335	295	335	1.6629667954431267e+09
C295_335	295	335	5.3243322965090505e-16
R295_358	295	358	4.0867279542203255e+09
C295_358	295	358	2.1665713784193455e-16
R295_359	295	359	1.8573895674996595e+09
C295_359	295	359	4.7670063253984667e-16
R295_360	295	360	2.8507425161425333e+09
C295_360	295	360	3.1059233750023124e-16
R295_363	295	363	8.7840902651275387e+09
C295_363	295	363	1.0079800582367359e-16
R296_334	296	334	3.6860368398597984e+09
C296_334	296	334	2.4020888020578701e-16
R296_297	296	297	4.8553327777611189e+09
C296_297	296	297	1.8236006103546268e-16
R296_359	296	359	3.4274564179503770e+09
C296_359	296	359	2.5833115690774605e-16
R296_363	296	363	6.6244498328021326e+09
C296_363	296	363	1.3365921760259888e-16
R296_364	296	364	9.2913675710278893e+09
C296_364	296	364	9.5294774954430902e-17
R297_328	297	328	3.8221774157287898e+09
C297_328	297	328	2.3165297823601258e-16
R297_329	297	329	5.1875676976233635e+09
C297_329	297	329	1.7068091123044939e-16
R297_334	297	334	5.7035051404420547e+09
C297_334	297	334	1.5524116484470723e-16
R297_336	297	336	5.3809223586014442e+09
C297_336	297	336	1.6454777130999700e-16
R297_359	297	359	6.0667934569288979e+09
C297_359	297	359	1.4594510065094788e-16
R297_362	297	362	8.6714970029216976e+09
C297_362	297	362	1.0210679671591594e-16
R297_364	297	364	5.3454239186816626e+09
C297_364	297	364	1.6564051704216756e-16
R298_299	298	299	2.0092757352167704e+09
C298_299	298	299	4.4066564194310381e-16
R298_300	298	300	7.8299294631893415e+09
C298_300	298	300	1.1308132287303456e-16
R298_301	298	301	2.4111308822601247e+09
C298_301	298	301	3.6722136828591977e-16
R298_302	298	302	2.1876548167212234e+09
C298_302	298	302	4.0473422723381609e-16
R298_303	298	303	4.8545315938191996e+09
C298_303	298	303	1.8239015744120754e-16
R298_321	298	321	9.0896344712588100e+09
C298_321	298	321	9.7409723625264724e-17
R298_355	298	355	4.7845488886171465e+09
C298_355	298	355	1.8505794429365902e-16
R298_366	298	366	2.4894789534689250e+09
C298_366	298	366	3.5566429692696425e-16
R299_300	299	300	5.8236409428112135e+09
C299_300	299	300	1.5203869716469624e-16
R299_355	299	355	3.3241918260167356e+09
C299_355	299	355	2.6635610339038914e-16
R299_358	299	358	2.9039548067120633e+09
C299_358	299	358	3.0490101968993630e-16
R299_366	299	366	3.8616762202548332e+09
C299_366	299	366	2.2928353678537323e-16
R300_302	300	302	1.8722342208352640e+09
C300_302	300	302	4.7292094752171895e-16
R300_304	300	304	2.7409201768901744e+09
C300_304	300	304	3.2303705491510847e-16
R300_358	300	358	4.2552445211194458e+09
C300_358	300	358	2.0807706285867425e-16
R300_363	300	363	6.0686403773338194e+09
C300_363	300	363	1.4590068395006754e-16
R300_366	300	366	2.7472862848636565e+09
C300_366	300	366	3.2228850214055581e-16
R300_368	300	368	4.5027318403362694e+09
C300_368	300	368	1.9664035370000538e-16
R300_367	300	367	9.6240466997400665e+09
C300_367	300	367	9.2000673866629725e-17
R301_302	301	302	9.5040516349654305e+08
C301_302	301	302	9.3162244451886397e-16
R301_303	301	303	1.0074194828204676e+09
C301_303	301	303	8.7889781446463318e-16
R301_305	301	305	1.8538163685283060e+09
C301_305	301	305	4.7761946476009907e-16
R301_321	301	321	3.1246085508835855e+09
C301_321	301	321	2.8336950606168534e-16
R301_370	301	370	4.7600999849490433e+09
C301_370	301	370	1.8600844194441401e-16
R302_303	302	303	2.1967274039954548e+09
C302_303	302	303	4.0306265588055277e-16
R302_304	302	304	1.6602573859681427e+09
C302_304	302	304	5.3330211880592691e-16
R302_305	302	305	1.6670755211173918e+09
C302_305	302	305	5.3112097831448563e-16
R302_366	302	366	1.2752687984552720e+09
C302_366	302	366	6.9429972941587237e-16
R302_372	302	372	4.0887313913123918e+09
C302_372	302	372	2.1655097803228410e-16
R303_305	303	305	2.5717151581802645e+09
C303_305	303	305	3.4429115482856150e-16
R303_321	303	321	3.1906730504463749e+09
C303_321	303	321	2.7750219709165431e-16
R303_355	303	355	3.8456117372993560e+09
C303_355	303	355	2.3024133536730880e-16
R303_366	303	366	1.4439628918445339e+09
C303_366	303	366	6.1318665922844899e-16
R303_370	303	370	1.4439628918445346e+09
C303_370	303	370	6.1318665922844870e-16
R303_372	303	372	1.1502502016704178e+09
C303_372	303	372	7.6976190085789665e-16
R303_373	303	373	2.0835180225397863e+09
C303_373	303	373	4.2496334186765703e-16
R303_374	303	374	4.2246948331777072e+09
C303_374	303	374	2.0958171339301464e-16
R304_305	304	305	3.6782668111707554e+09
C304_305	304	305	2.4071630122399418e-16
R304_306	304	306	5.1529706266201258e+09
C304_306	304	306	1.7182686373680211e-16
R304_366	304	366	7.4456942633414459e+09
C304_366	304	366	1.1891688677835205e-16
R304_368	304	368	8.8599650553025723e+09
C304_368	304	368	9.9934793892904646e-17
R304_367	304	367	7.0785111693645744e+09
C304_367	304	367	1.2508545377904412e-16
R304_372	304	372	4.1027914175508533e+09
C304_372	304	372	2.1580887049543162e-16
R304_375	304	375	3.6166606941239934e+09
C304_375	304	375	2.4481665729343762e-16
R305_306	305	306	2.3010461597643814e+09
C305_306	305	306	3.8478966531930136e-16
R305_370	305	370	4.3493300018897352e+09
C305_370	305	370	2.0357590279774021e-16
R305_372	305	372	2.1364539852388449e+09
C305_372	305	372	4.1443381782033301e-16
R305_375	305	375	5.0911432829960375e+09
C305_375	305	375	1.7391354603144237e-16
R305_376	305	376	2.9518261807406936e+09
C305_376	305	376	2.9995627367117675e-16
R306_375	306	375	4.6837303496226625e+09
C306_375	306	375	1.8904136566515461e-16
R306_376	306	376	7.7435777151149216e+09
C306_376	306	376	1.1434233816388574e-16
R306_307	306	307	1.7417085486985291e+10
C306_307	306	307	5.0836219547846783e-17
R307_376	307	376	5.6575391298607883e+09
C307_376	307	376	1.5650245829086947e-16
R307_375	307	375	9.8044795992252750e+09
C307_375	307	375	9.0307575505584566e-17
R307_378	307	378	5.3302772110970001e+09
C307_378	307	378	1.6611120709757156e-16
R307_380	307	380	1.0556223962645041e+10
C307_380	307	380	8.3876468028075399e-17
R307_381	307	381	2.2776595030013325e+10
C307_381	307	381	3.8874062630224597e-17
R308_317	308	317	5.8592774574804182e+09
C308_317	308	317	1.5111398771014064e-16
R308_339	308	339	5.5881967646582022e+09
C308_339	308	339	1.5844445336995142e-16
R308_346	308	346	4.2223913922569814e+09
C308_346	308	346	2.0969604649244036e-16
R308_385	308	385	1.9289936310209564e+10
C308_385	308	385	4.5900554955765995e-17
R309_322	309	322	1.4940090073964288e+09
C309_322	309	322	5.9264621385582990e-16
R309_320	309	320	5.5206988043482466e+09
C309_320	309	320	1.6038164969308253e-16
R309_326	309	326	2.0260439359651968e+09
C309_326	309	326	4.3701854929330104e-16
R309_324	309	324	6.6816164207566938e+09
C309_324	309	324	1.3251565578494049e-16
R309_325	309	325	8.5927238364957130e+08
C309_325	309	325	1.0304285329634100e-15
R309_327	309	327	2.5303659307342529e+09
C309_327	309	327	3.4991728703961498e-16
R309_354	309	354	3.3408082103783441e+09
C309_354	309	354	2.6503131156988117e-16
R309_384	309	384	6.4118088274297218e+09
C309_384	309	384	1.3809188725530587e-16
R309_386	309	386	3.1842078255168576e+09
C309_386	309	386	2.7806563836840002e-16
R310_311	310	311	3.6945984545684009e+09
C310_311	310	311	2.3965223625457130e-16
R310_315	310	315	2.9856498106918197e+09
C310_315	310	315	2.9655814909345837e-16
R310_314	310	314	2.2126364698050742e+09
C310_314	310	314	4.0016459720471057e-16
R310_320	310	320	6.3136724489720497e+09
C310_320	310	320	1.4023831436554145e-16
R310_322	310	322	2.3260234329303942e+09
C310_322	310	322	3.8065772217286872e-16
R310_332	310	332	1.6476323001618526e+09
C310_332	310	332	5.3738857972924105e-16
R310_386	310	386	6.8922438559751673e+09
C310_386	310	386	1.2846596844254061e-16
R310_387	310	387	2.9567171666996045e+09
C310_387	310	387	2.9946008758366868e-16
R310_389	310	389	2.8493740916342854e+09
C310_389	310	389	3.1074150084384315e-16
R311_312	311	312	3.5502955522579408e+09
C311_312	311	312	2.4939297832173023e-16
R311_313	311	313	9.0860998911141825e+08
C311_313	311	313	9.7447616943536088e-16
R311_315	311	315	1.1513823602067316e+09
C311_315	311	315	7.6900499113172289e-16
R311_322	311	322	2.8318790608105083e+09
C311_322	311	322	3.1266122694045614e-16
R311_323	311	323	1.3298494769103770e+09
C311_323	311	323	6.6580375980376553e-16
R311_389	311	389	2.6733679694891305e+09
C311_389	311	389	3.3119974197536291e-16
R311_390	311	390	1.8477544097519338e+09
C311_390	311	390	4.7918639892131008e-16
R312_313	312	313	3.0375631056745887e+09
C312_313	312	313	2.9148983935376195e-16
R312_315	312	315	1.8778868890952637e+09
C312_315	312	315	4.7149739786861216e-16
R312_318	312	318	2.1044887252385578e+09
C312_318	312	318	4.2072868867455292e-16
R312_390	312	390	4.2839756227779384e+09
C312_390	312	390	2.0668156396414118e-16
R313_323	313	323	6.6397480769601431e+09
C313_323	313	323	1.3335126143902871e-16
R313_390	313	390	1.0740488570366537e+10
C313_390	313	390	8.2437477205916673e-17
R314_315	314	315	3.0652987248796382e+09
C314_315	314	315	2.8885236356034662e-16
R314_316	314	316	2.3470045232672524e+09
C314_316	314	316	3.7725482542633247e-16
R314_332	314	332	1.8786250215133221e+09
C314_332	314	332	4.7131214135897805e-16
R314_338	314	338	6.3244925866293526e+09
C314_338	314	338	1.3999839031701441e-16
R314_349	314	349	3.5417244867993283e+09
C314_349	314	349	2.4999651582163493e-16
R314_351	314	351	2.4686533633896260e+09
C314_351	314	351	3.5866468530205508e-16
R314_352	314	352	1.3293728880420887e+09
C314_352	314	352	6.6604245480291999e-16
R314_387	314	387	2.9291301849277139e+09
C314_387	314	387	3.0228044702692196e-16
R314_389	314	389	3.7952491555669971e+09
C314_389	314	389	2.3329661516457717e-16
R314_391	314	391	1.0768779849202616e+09
C314_391	314	391	8.2220900984020181e-16
R315_316	315	316	7.3522966730534601e+08
C315_316	315	316	1.2042751007927969e-15
R315_318	315	318	3.3366721751965065e+09
C315_318	315	318	2.6535983615107627e-16
R315_389	315	389	2.1911280199679604e+09
C315_389	315	389	4.0409267447227807e-16
R315_390	315	390	9.0656646428154945e+08
C315_390	315	390	9.7667277203077572e-16
R315_391	315	391	4.3528042325276308e+09
C315_391	315	391	2.0341341682298590e-16
R316_318	316	318	1.5695415501110966e+09
C316_318	316	318	5.6412573572029838e-16
R316_317	316	317	6.0695913185169401e+09
C316_317	316	317	1.4587782524974773e-16
R316_319	316	319	4.9702503025707769e+09
C316_319	316	319	1.7814370057822488e-16
R316_338	316	338	2.8884968442918887e+09
C316_338	316	338	3.0653271560594672e-16
R316_390	316	390	4.3196559049908838e+09
C316_390	316	390	2.0497437786120807e-16
R316_391	316	391	3.4587940024219666e+09
C316_391	316	391	2.5599060859941339e-16
R316_392	316	392	2.3400502292865005e+09
C316_392	316	392	3.7837597271147939e-16
R317_319	317	319	1.9880853657872000e+09
C317_319	317	319	4.4536255682834355e-16
R317_338	317	338	2.3756390065082898e+09
C317_338	317	338	3.7270762909445032e-16
R317_339	317	339	1.7217117420724294e+09
C317_339	317	339	5.1426656394537856e-16
R317_346	317	346	3.8794326548190417e+09
C317_346	317	346	2.2823409000285919e-16
R317_392	317	392	8.8825573359086761e+09
C317_392	317	392	9.9680615414729828e-17
R318_319	318	319	1.2688550238943908e+09
C318_319	318	319	6.9780925718563028e-16
R318_390	318	390	4.1870855067014146e+09
C318_390	318	390	2.1146422261568112e-16
R318_392	318	392	5.0630425524071569e+09
C318_392	318	392	1.7487879521751983e-16
R319_339	319	339	5.1884997724914713e+09
C319_339	319	339	1.7065024969150759e-16
R319_392	319	392	6.0022988596330490e+09
C319_392	319	392	1.4751327822988976e-16
R320_321	320	321	4.1157364885163169e+09
C320_321	320	321	2.1513009498311807e-16
R320_322	320	322	3.4020502745172977e+09
C320_322	320	322	2.6026034604254289e-16
R320_332	320	332	2.6692323383711324e+09
C320_332	320	332	3.3171289324342458e-16
R320_354	320	354	1.3400995547259085e+09
C320_354	320	354	6.6071119759538721e-16
R320_357	320	357	1.2107941425896671e+09
C320_357	320	357	7.3127111418482027e-16
R320_386	320	386	1.0836560580283201e+09
C320_386	320	386	8.1706624084305227e-16
R320_395	320	395	3.5738333752612147e+09
C320_395	320	395	2.4775043733964908e-16
R321_354	321	354	4.2620818270954857e+09
C321_354	321	354	2.0774326200663148e-16
R321_355	321	355	2.1898649767458630e+09
C321_355	321	355	4.0432574204448507e-16
R321_357	321	357	4.4006549314508476e+09
C321_357	321	357	2.0120159282929441e-16
R321_370	321	370	4.3035369075606661e+09
C321_370	321	370	2.0574211415369822e-16
R321_373	321	373	3.8632480660699081e+09
C321_373	321	373	2.2919024783224409e-16
R321_374	321	374	3.8179353317998242e+09
C321_374	321	374	2.3191036640282803e-16
R321_371	321	371	4.0309264474229770e+09
C321_371	321	371	2.1965639741852885e-16
R321_395	321	395	2.0968092142456951e+09
C321_395	321	395	4.2226959691157211e-16
R322_323	322	323	5.0250381316134195e+09
C322_323	322	323	1.7620140554350643e-16
R322_326	322	326	1.5756909107759476e+09
C322_326	322	326	5.6192415380753607e-16
R322_325	322	325	2.8394850642968831e+09
C322_325	322	325	3.1182371509295072e-16
R322_386	322	386	2.3361323553726559e+09
C322_386	322	386	3.7901053836427840e-16
R322_387	322	387	2.1437326818556032e+09
C322_387	322	387	4.1302667501135741e-16
R322_389	322	389	1.6733193758903496e+09
C322_389	322	389	5.2913914370284585e-16
R322_397	322	397	3.7877529921962452e+09
C322_397	322	397	2.3375832149672708e-16
R323_324	323	324	3.0463226612299900e+09
C323_324	323	324	2.9065167421973008e-16
R323_326	323	326	2.1375937662724369e+09
C323_326	323	326	4.1421283859935864e-16
R323_389	323	389	2.5441577972937078e+09
C323_389	323	389	3.4802038719526157e-16
R323_390	323	390	3.4637343399132500e+09
C323_390	323	390	2.5562548821864203e-16
R323_398	323	398	2.3297364228620105e+09
C323_398	323	398	3.8005105342015047e-16
R324_326	324	326	1.4533287809928520e+09
C324_326	324	326	6.0923501500818002e-16
R324_327	324	327	3.4885181063541532e+09
C324_327	324	327	2.5380942701350926e-16
R324_398	324	398	6.2986605704561644e+09
C324_398	324	398	1.4057255059163729e-16
R324_383	324	383	1.0203830124138981e+10
C324_383	324	383	8.6773179377553910e-17
R324_399	324	399	3.3014991127540088e+09
C324_399	324	399	2.6818689070051301e-16
R325_326	325	326	1.6843980888728321e+09
C325_326	325	326	5.2565886149425989e-16
R325_327	325	327	1.8201778358536396e+09
C325_327	325	327	4.8644630445395484e-16
R325_384	325	384	2.0730228053317425e+09
C325_384	325	384	4.2711482933170531e-16
R325_354	325	354	7.3144879738594751e+09
C325_354	325	354	1.2105000170405785e-16
R325_386	325	386	2.4711291068016911e+09
C325_386	325	386	3.5830535088713823e-16
R325_387	325	387	6.3232050039788294e+09
C325_387	325	387	1.4002689793275040e-16
R325_397	325	397	2.9967104580850468e+09
C325_397	325	397	2.9546357383682609e-16
R325_400	325	400	3.3307254553629336e+09
C325_400	325	400	2.6583361299693796e-16
R325_401	325	401	1.1853896662599189e+09
C325_401	325	401	7.4694322626721420e-16
R325_402	325	402	2.0469608863386898e+09
C325_402	325	402	4.3255285804884650e-16
R326_327	326	327	3.6182584247864766e+09
C326_327	326	327	2.4470855249988152e-16
R326_389	326	389	5.0146330347631073e+09
C326_389	326	389	1.7656701408896369e-16
R326_397	326	397	1.2432348702261331e+09
C326_397	326	397	7.1218946870348831e-16
R326_398	326	398	1.8415306127306612e+09
C326_398	326	398	4.8080589895113504e-16
R326_399	326	399	2.4113234432364936e+09
C326_399	326	399	3.6719204310127120e-16
R326_402	326	402	4.6430910977691107e+09
C326_402	326	402	1.9069597452555298e-16
R327_384	327	384	6.6417268363677301e+09
C327_384	327	384	1.3331153230388251e-16
R327_383	327	383	3.8199071776529994e+09
C327_383	327	383	2.3179065367866163e-16
R327_399	327	399	4.6250467491432829e+09
C327_399	327	399	1.9143996368555844e-16
R327_402	327	402	1.5771747066756763e+09
C327_402	327	402	5.6139549914940021e-16
R327_404	327	404	7.3912834496171980e+09
C327_404	327	404	1.1979229151952720e-16
R328_329	328	329	1.4825945617738878e+10
C328_329	328	329	5.9720897710606607e-17
R328_334	328	334	1.0410730296615093e+10
C328_334	328	334	8.5048671560330585e-17
R328_336	328	336	3.9106581786435122e+09
C328_336	328	336	2.2641170392630041e-16
R328_353	328	353	1.4111858598994688e+10
C328_353	328	353	6.2742889286254339e-17
R328_406	328	406	1.6228272591955048e+10
C328_406	328	406	5.4560260599697763e-17
R329_336	329	336	6.2590920289273443e+09
C329_336	329	336	1.4146121795428203e-16
R329_362	329	362	4.0637800034134479e+09
C329_362	329	362	2.1788058924358016e-16
R329_364	329	364	9.1514574408847408e+09
C329_364	329	364	9.6751669055940020e-17
R329_365	329	365	4.9118598457751532e+09
C329_365	329	365	1.8026141003627724e-16
R329_406	329	406	6.1009716272564821e+09
C329_406	329	406	1.4512750358391030e-16
R329_382	329	382	1.4825361054233278e+10
C329_382	329	382	5.9723252503666680e-17
R329_407	329	407	4.6125147894193068e+09
C329_407	329	407	1.9196009598301370e-16
R330_331	330	331	6.7191021134205790e+09
C330_331	330	331	1.3177635445240299e-16
R330_333	330	333	3.7950184080643725e+09
C330_333	330	333	2.3331080023709372e-16
R330_337	330	337	3.1678819024243312e+09
C330_337	330	337	2.7949867102760458e-16
R330_340	330	340	3.1722679703933678e+09
C330_340	330	340	2.7911222821135326e-16
R330_341	330	341	1.7156229517510808e+09
C330_341	330	341	5.1609170930960201e-16
R330_349	330	349	2.0160759554287508e+09
C330_349	330	349	4.3917927760400357e-16
R330_408	330	408	5.5494582633247604e+09
C330_408	330	408	1.5955048937867549e-16
R331_333	331	333	5.6956497025350542e+09
C331_333	331	333	1.5545527340031332e-16
R331_335	331	335	1.7741829201853144e+09
C331_335	331	335	4.9905721198551357e-16
R331_341	331	341	9.2948134036218739e+09
C331_341	331	341	9.5259446666781120e-17
R331_342	331	342	9.9509745621108627e+09
C331_342	331	342	8.8978097187717002e-17
R331_356	331	356	3.3235615783497558e+09
C331_356	331	356	2.6640661255316236e-16
R331_360	331	360	4.0598759382399368e+09
C331_360	331	360	2.1809010796616918e-16
R331_408	331	408	4.2597598272898917e+09
C331_408	331	408	2.0785650308912224e-16
R332_333	332	333	2.3909991340224609e+09
C332_333	332	333	3.7031330087118406e-16
R332_349	332	349	2.3221419031353230e+09
C332_349	332	349	3.8129400296533149e-16
R332_352	332	352	4.2384682696677566e+09
C332_352	332	352	2.0890065121789995e-16
R332_357	332	357	3.6724439475065722e+09
C332_357	332	357	2.4109797027703048e-16
R332_386	332	386	5.2898804559804268e+09
C332_386	332	386	1.6737973363821443e-16
R332_387	332	387	3.9324723660369506e+09
C332_387	332	387	2.2515575426466466e-16
R332_388	332	388	2.8530265190117059e+09
C332_388	332	388	3.1034369144479979e-16
R332_409	332	409	7.6338122516147432e+09
C332_409	332	409	1.1598644982560473e-16
R333_349	333	349	2.6744027544862437e+09
C333_349	333	349	3.3107159354167291e-16
R333_356	333	356	2.1038193156793077e+09
C333_356	333	356	4.2086255939431983e-16
R333_357	333	357	1.9478128156145246e+09
C333_357	333	357	4.5457077528297049e-16
R333_408	333	408	3.8742872582977548e+09
C333_408	333	408	2.2853720508298770e-16
R333_409	333	409	3.2356351646877670e+09
C333_409	333	409	2.7364604988938591e-16
R334_335	334	335	2.1673621493853846e+09
C334_335	334	335	4.0852368947712993e-16
R334_336	334	336	2.7892775994541965e+09
C334_336	334	336	3.1743659428995449e-16
R334_344	334	344	6.2031556650351906e+09
C334_344	334	344	1.4273683097955546e-16
R334_342	334	342	9.2834572761169777e+09
C334_342	334	342	9.5375974204983570e-17
R334_353	334	353	5.7180235243725052e+09
C334_353	334	353	1.5484699877955915e-16
R334_359	334	359	2.8965619666453986e+09
C334_359	334	359	3.0567921276872656e-16
R334_410	334	410	6.5408266902095537e+09
C334_410	334	410	1.3536802359024638e-16
R335_342	335	342	6.1393691054011621e+09
C335_342	335	342	1.4421983211940221e-16
R335_344	335	344	1.5127732026678411e+10
C335_344	335	344	5.8529512562658150e-17
R335_359	335	359	7.7836313470909538e+09
C335_359	335	359	1.1375394622600098e-16
R335_360	335	360	2.8572377289839377e+09
C335_360	335	360	3.0988628377620642e-16
R335_408	335	408	1.3282463859657280e+10
C335_408	335	408	6.6660733359062647e-17
R335_410	335	410	9.8023242371392040e+09
C335_410	335	410	9.0327432584336589e-17
R336_353	336	353	4.1991175201993155e+09
C336_353	336	353	2.1085829997393665e-16
R336_359	336	359	5.1403856153186407e+09
C336_359	336	359	1.7224754093572318e-16
R336_362	336	362	3.0047999197882237e+09
C336_362	336	362	2.9466813276619224e-16
R336_406	336	406	2.4112554825395341e+09
C336_406	336	406	3.6720239232695379e-16
R336_410	336	410	3.8854367932460098e+09
C336_410	336	410	2.2788140145249794e-16
R337_338	337	338	3.3612485079087448e+09
C337_338	337	338	2.6341961316358538e-16
R337_340	337	340	1.0945666849868343e+09
C337_340	337	340	8.0892173482390428e-16
R337_349	337	349	2.4095539775615115e+09
C337_349	337	349	3.6746169205806760e-16
R337_350	337	350	2.6955874292353988e+09
C337_350	337	350	3.2846969536103989e-16
R337_351	337	351	2.4259186661774383e+09
C337_351	337	351	3.6498288011245226e-16
R337_413	337	413	3.2404940355181518e+09
C337_413	337	413	2.7323573874698473e-16
R338_339	338	339	3.2335546209352431e+09
C338_339	338	339	2.7382212008031885e-16
R338_346	338	346	3.1666992434369202e+09
C338_346	338	346	2.7960305467437650e-16
R338_350	338	350	1.2645397395804079e+09
C338_350	338	350	7.0019055470237288e-16
R338_351	338	351	1.1819075481760211e+09
C338_351	338	351	7.4914385906615334e-16
R338_391	338	391	4.0252322010864396e+09
C338_391	338	391	2.1996713170013370e-16
R338_392	338	392	3.9299786939259152e+09
C338_392	338	392	2.2529862135600958e-16
R338_393	338	393	1.4010321705841300e+09
C338_393	338	393	6.3197605329137006e-16
R338_414	338	414	3.7584404787832456e+09
C338_414	338	414	2.3558142977074491e-16
R338_415	338	415	3.7184519823529382e+09
C338_415	338	415	2.3811488918023635e-16
R339_346	339	346	5.1132136467759285e+09
C339_346	339	346	1.7316287619984147e-16
R339_385	339	385	5.3901254644166355e+09
C339_385	339	385	1.6426682227439163e-16
R339_392	339	392	5.3009343672869940e+09
C339_392	339	392	1.6703070069383925e-16
R339_393	339	393	5.5458028386040878e+09
C339_393	339	393	1.5965565445937588e-16
R339_394	339	394	3.6693056068917994e+09
C339_394	339	394	2.4130418028876636e-16
R339_415	339	415	6.6374477894044075e+09
C339_415	339	415	1.3339747592642843e-16
R340_341	340	341	7.8098116871251166e+08
C340_341	340	341	1.1337261603370784e-15
R340_343	340	343	1.1170198883168337e+09
C340_343	340	343	7.9266160876882977e-16
R340_349	340	349	3.5421709019286647e+09
C340_349	340	349	2.4996500909030149e-16
R340_350	340	350	1.8052560233538752e+09
C340_350	340	350	4.9046715271722752e-16
R340_413	340	413	1.4976709457588463e+09
C340_413	340	413	5.9119714127282623e-16
R340_416	340	416	5.0172818292945862e+09
C340_416	340	416	1.7647379832846403e-16
R341_342	341	342	1.0696961620148063e+09
C341_342	341	342	8.2772923110454655e-16
R341_343	341	343	3.8539534927346783e+09
C341_343	341	343	2.2974298557809711e-16
R341_349	341	349	5.7695929060283241e+09
C341_349	341	349	1.5346295590021192e-16
R341_408	341	408	1.7386831117443793e+09
C341_408	341	408	5.0924678322301087e-16
R341_413	341	413	4.2565700900236783e+09
C341_413	341	413	2.0801226409385277e-16
R341_416	341	416	6.1613732883719339e+09
C341_416	341	416	1.4370477818167724e-16
R342_343	342	343	3.0919054624296975e+09
C342_343	342	343	2.8636670572851715e-16
R342_344	342	344	2.9209695647449245e+09
C342_344	342	344	3.0312495973484056e-16
R342_353	342	353	9.8647822996695938e+09
C342_353	342	353	8.9755531830606711e-17
R342_408	342	408	5.4486365132211599e+09
C342_408	342	408	1.6250281690685814e-16
R342_410	342	410	7.2970085413699341e+09
C342_410	342	410	1.2133996783478786e-16
R342_416	342	416	7.1962718850094862e+09
C342_416	342	416	1.2303853937820375e-16
R342_417	342	417	1.1445759430118471e+10
C342_417	342	417	7.7357801123279026e-17
R343_344	343	344	4.6050790177201729e+09
C343_344	343	344	1.9227005189117097e-16
R343_345	343	345	2.7264603824822793e+09
C343_345	343	345	3.2475028333031540e-16
R343_348	343	348	2.2799592914879155e+09
C343_348	343	348	3.8834850473236761e-16
R343_350	343	350	5.2282106553019743e+09
C343_350	343	350	1.6935407543345430e-16
R343_416	343	416	4.7065946614098682e+09
C343_416	343	416	1.8812301576757654e-16
R343_417	343	417	1.6468955693244209e+09
C343_417	343	417	5.3762897793404784e-16
R344_345	344	345	1.4148362760749638e+09
C344_345	344	345	6.2581006486229436e-16
R344_353	344	353	1.8942265048050544e+09
C344_353	344	353	4.6743025686419876e-16
R344_417	344	417	5.5855755429875078e+09
C344_417	344	417	1.5851880882921941e-16
R345_348	345	348	2.5757247613000989e+09
C345_348	345	348	3.4375520047921739e-16
R345_353	345	353	6.6665214062108946e+09
C345_353	345	353	1.3281571118561109e-16
R345_417	345	417	3.6658443843661780e+09
C345_417	345	417	2.4153201523667196e-16
R346_347	346	347	2.1355389086884310e+09
C346_347	346	347	4.1461140234798699e-16
R346_350	346	350	2.9457766757967982e+09
C346_350	346	350	3.0057226977686784e-16
R346_385	346	385	4.4757006686323156e+09
C346_385	346	385	1.9782797091534861e-16
R346_415	346	415	1.4793107431078646e+09
C346_415	346	415	5.9853467963048476e-16
R346_418	346	418	5.3687418174116068e+09
C346_418	346	418	1.6492109544706712e-16
R347_348	347	348	1.7059997735553777e+09
C347_348	347	348	5.1900287176167030e-16
R347_350	347	350	3.7284221969984326e+09
C347_350	347	350	2.3747814354629866e-16
R347_418	347	418	5.7117240978460588e+09
C347_418	347	418	1.5501777861327355e-16
R348_350	348	350	3.9694622109692097e+09
C348_350	348	350	2.2305761703770202e-16
R348_417	348	417	3.5580803539451180e+09
C348_417	348	417	2.4884732597965863e-16
R348_418	348	418	7.6722204547234383e+09
C348_418	348	418	1.1540580551942924e-16
R349_351	349	351	1.1541421737852361e+09
C349_351	349	351	7.6716612719912589e-16
R349_352	349	352	1.2768172521373830e+09
C349_352	349	352	6.9345772092115401e-16
R349_388	349	388	2.4690425855598879e+09
C349_388	349	388	3.5860814506738032e-16
R349_408	349	408	1.3266688560982654e+09
C349_408	349	408	6.6739999030656196e-16
R349_409	349	409	1.8690668075581515e+09
C349_409	349	409	4.7372238280597282e-16
R349_413	349	413	8.9574971353606415e+08
C349_413	349	413	9.8846672046895598e-16
R349_419	349	419	1.3082726522097638e+09
C349_419	349	419	6.7678459853492012e-16
R350_351	350	351	1.3477972753124793e+09
C350_351	350	351	6.5693765517868470e-16
R350_413	350	413	1.2851485381846664e+09
C350_413	350	413	6.8896221362138930e-16
R350_414	350	414	3.0039280356381245e+09
C350_414	350	414	2.9475365960686559e-16
R350_415	350	415	2.7854811010997691e+09
C350_415	350	415	3.1786924756029310e-16
R350_416	350	416	2.4290844467948642e+09
C350_416	350	416	3.6450720470764015e-16
R350_417	350	417	3.8661002684650612e+09
C350_417	350	417	2.2902116350219070e-16
R350_418	350	418	6.1945545560973620e+08
C350_418	350	418	1.4293502037664257e-15
R350_420	350	420	7.5218532130831051e+08
C350_420	350	420	1.1771285035979572e-15
R351_352	351	352	9.7484570813119841e+08
C351_352	351	352	9.0826555865683402e-16
R351_391	351	391	1.3525721645046225e+09
C351_391	351	391	6.5461851495685872e-16
R351_393	351	393	1.9895096923666809e+09
C351_393	351	393	4.4504371358287967e-16
R351_413	351	413	1.0072472540809859e+09
C351_413	351	413	8.7904809679313310e-16
R351_414	351	414	2.0766986257678192e+09
C351_414	351	414	4.2635882294795349e-16
R351_419	351	419	1.6313730885548573e+09
C351_419	351	419	5.4274450639880500e-16
R351_420	351	420	1.2892550140624306e+09
C351_420	351	420	6.8676776281059685e-16
R351_421	351	421	6.0408434859082985e+08
C351_421	351	421	1.4657204474266706e-15
R352_387	352	387	2.2973851270332508e+09
C352_387	352	387	3.8540285269600994e-16
R352_388	352	388	1.1906933602358344e+09
C352_388	352	388	7.4361612424262584e-16
R352_391	352	391	1.7762313382959127e+09
C352_391	352	391	4.9848168006621044e-16
R352_396	352	396	2.8595992399651451e+09
C352_396	352	396	3.0963037383895521e-16
R352_412	352	412	1.6796636540304222e+09
C352_412	352	412	5.2714052576859726e-16
R352_419	352	419	2.5952181553508687e+09
C352_419	352	419	3.4117316105947678e-16
R352_421	352	421	3.1355708535308776e+09
C352_421	352	421	2.8237881491434172e-16
R353_406	353	406	6.6684181836440706e+09
C353_406	353	406	1.3277793283446237e-16
R353_410	353	410	4.0684661497812276e+09
C353_410	353	410	2.1762962971871147e-16
R353_416	353	416	8.5516609355047541e+09
C353_416	353	416	1.0353763887245829e-16
R353_417	353	417	4.7245972404927940e+09
C353_417	353	417	1.8740619287320400e-16
R353_422	353	422	7.1400183700314598e+09
C353_422	353	422	1.2400791367937318e-16
R354_384	354	384	3.0779973159636703e+09
C354_384	354	384	2.8766067374649095e-16
R354_386	354	386	1.8208156177622135e+09
C354_386	354	386	4.8627591561861815e-16
R354_371	354	371	4.3331776343401222e+09
C354_371	354	371	2.0433475301892073e-16
R354_395	354	395	1.9691340594318149e+09
C354_395	354	395	4.4964880753496492e-16
R354_400	354	400	3.3373622273134141e+09
C354_400	354	400	2.6530496883245562e-16
R354_423	354	423	4.4061076690233784e+09
C354_423	354	423	2.0095259766910211e-16
R355_356	355	356	1.2917153723503265e+09
C355_356	355	356	6.8545966135631415e-16
R355_357	355	357	1.2537545204824588e+09
C355_357	355	357	7.0621382992843059e-16
R355_358	355	358	3.1977402780038943e+09
C355_358	355	358	2.7688889801040997e-16
R355_361	355	361	2.4858578585950222e+09
C355_361	355	361	3.5618238534379783e-16
R355_366	355	366	1.2537545204824579e+09
C355_366	355	366	7.0621382992843118e-16
R355_369	355	369	2.5344495486338468e+09
C355_369	355	369	3.4935348473488871e-16
R355_373	355	373	1.1309984448992584e+09
C355_373	355	373	7.8286472071928200e-16
R355_395	355	395	2.9340506800093074e+09
C355_395	355	395	3.0177351322956408e-16
R355_426	355	426	1.1987812137094400e+09
C355_426	355	426	7.3859914684532894e-16
R356_357	356	357	8.3414880683390045e+09
C356_357	356	357	1.0614638232963496e-16
R356_360	356	360	1.0426860085423754e+10
C356_360	356	360	8.4917105863707977e-17
R356_361	356	361	3.3994641405616250e+09
C356_361	356	361	2.6045833845851954e-16
R356_408	356	408	1.0585434277006731e+10
C356_408	356	408	8.3645012432156162e-17
R356_409	356	409	7.8409328669810371e+09
C356_409	356	409	1.1292263264089254e-16
R356_426	356	426	9.5475869054141273e+09
C356_426	356	426	9.2737441457370525e-17
R357_386	357	386	5.1403692878978271e+09
C357_386	357	386	1.7224808804779380e-16
R357_388	357	388	8.4975751027029085e+09
C357_388	357	388	1.0419664092387557e-16
R357_395	357	395	2.3752245391679578e+09
C357_395	357	395	3.7277266510986905e-16
R357_409	357	409	4.7643345351349936e+09
C357_409	357	409	1.8584311726441612e-16
R357_426	357	426	3.9248239479713826e+09
C357_426	357	426	2.2559452180209126e-16
R357_427	357	427	5.8981529370803308e+09
C357_427	357	427	1.5011797610970304e-16
R358_360	358	360	1.1817774438219645e+09
C358_360	358	360	7.4922633388270082e-16
R358_359	358	359	3.3019450403178177e+09
C358_359	358	359	2.6815067207017381e-16
R358_361	358	361	1.6729261506893294e+09
C358_361	358	361	5.2926351909506768e-16
R358_363	358	363	1.4598712413206997e+09
C358_363	358	363	6.0650470852415004e-16
R358_366	358	366	1.9420668783072278e+09
C358_366	358	366	4.5591570073619784e-16
R358_368	358	368	1.6080698264880123e+09
C358_368	358	368	5.5060966079671692e-16
R358_369	358	369	1.5626452886539319e+09
C358_369	358	369	5.6661533370935569e-16
R358_428	358	428	2.2161747821279902e+09
C358_428	358	428	3.9952570024725809e-16
R358_429	358	429	1.5319433568991117e+09
C358_429	358	429	5.7797096590583046e-16
R359_360	359	360	1.6414719077604873e+09
C359_360	359	360	5.3940538215363372e-16
R359_362	359	362	1.4843865008778293e+09
C359_362	359	362	5.9648803136944825e-16
R359_363	359	363	5.6934860280977287e+09
C359_363	359	363	1.5551435049289661e-16
R359_364	359	364	3.5022174693987560e+09
C359_364	359	364	2.5281661959501454e-16
R359_410	359	410	3.0798871626123633e+09
C359_410	359	410	2.8748416255256154e-16
R359_428	359	428	4.4109325905682230e+09
C359_428	359	428	2.0073278462547059e-16
R359_429	359	429	1.8497767951469212e+09
C359_429	359	429	4.7866249810408850e-16
R360_361	360	361	4.3516100663901192e+08
C360_361	360	361	2.0346923740676511e-15
R360_408	360	408	1.7199133451462612e+09
C360_408	360	408	5.1480429766925506e-16
R360_410	360	410	1.5102332191520317e+09
C360_410	360	410	5.8627950337176834e-16
R360_428	360	428	1.0172151916319466e+09
C360_428	360	428	8.7043409200318573e-16
R360_429	360	429	2.3252536889106946e+09
C360_429	360	429	3.8078373380187585e-16
R361_369	361	369	7.8684253276685810e+08
C361_369	361	369	1.1252807834199148e-15
R361_408	361	408	2.0033801730266283e+09
C361_408	361	408	4.4196243609736044e-16
R361_409	361	409	2.2403382158514886e+09
C361_409	361	409	3.9521656838919639e-16
R361_410	361	410	3.2282894285180955e+09
C361_410	361	410	2.7426871143534371e-16
R361_426	361	426	1.6978031724720562e+09
C361_426	361	426	5.2150849760211118e-16
R361_428	361	428	7.4456998824585235e+08
C361_428	361	428	1.1891679703421518e-15
R361_432	361	432	7.5130576308774090e+08
C361_432	361	432	1.1785065750874546e-15
R362_364	362	364	1.5514313034587786e+09
C362_364	362	364	5.7071091689721451e-16
R362_365	362	365	2.1863369777652698e+09
C362_365	362	365	4.0497818529557924e-16
R362_406	362	406	1.5495506713565714e+09
C362_406	362	406	5.7140356754184131e-16
R362_407	362	407	2.1686742821718626e+09
C362_407	362	407	4.0827651666218849e-16
R362_410	362	410	1.4249060059286637e+09
C362_410	362	410	6.2138750066039627e-16
R362_411	362	411	8.8222565167913115e+08
C362_411	362	411	1.0036194028305473e-15
R362_428	362	428	1.9365388945466061e+09
C362_428	362	428	4.5721714353033930e-16
R362_429	362	429	1.5495506713565714e+09
C362_429	362	429	5.7140356754184131e-16
R362_431	362	431	1.5540100862581520e+09
C362_431	362	431	5.6976385773143208e-16
R362_433	362	433	1.1991022685416522e+09
C362_433	362	433	7.3840138988048617e-16
R363_364	363	364	5.0119651000445566e+09
C363_364	363	364	1.7666100302496693e-16
R363_367	363	367	7.8966824244120646e+09
C363_367	363	367	1.1212541344739749e-16
R363_368	363	368	2.9514328658156586e+09
C363_368	363	368	2.9999624655372459e-16
R363_429	363	429	1.7505747400066993e+09
C363_429	363	429	5.0578747737249537e-16
R363_434	363	434	5.1039877680210629e+09
C363_434	363	434	1.7347588237722170e-16
R364_365	364	365	2.5358325398000450e+09
C364_365	364	365	3.4916295449454906e-16
R364_429	364	429	2.1660697559689751e+09
C364_429	364	429	4.0876743662574924e-16
R364_434	364	434	6.5103716173010054e+09
C364_434	364	434	1.3600126594110870e-16
R365_382	365	382	1.5814258510313346e+09
C365_382	365	382	5.5988637160735042e-16
R365_407	365	407	1.9725696417606649e+09
C365_407	365	407	4.4886566383009830e-16
R365_429	365	429	4.4045900608299894e+09
C365_429	365	429	2.0102183619175542e-16
R365_433	365	433	9.8766323714802158e+08
C365_433	365	433	8.9647842341154358e-16
R365_434	365	434	2.9950665208322930e+09
C365_434	365	434	2.9562574839037385e-16
R365_435	365	435	3.4690543867029152e+09
C365_435	365	435	2.5523346797152018e-16
R366_368	366	368	2.4477280510239415e+09
C366_368	366	368	3.6173086357759761e-16
R366_369	366	369	3.0298461066651225e+09
C366_369	366	369	2.9223226214434990e-16
R366_372	366	372	1.9848741346149464e+09
C366_372	366	372	4.4608308721387313e-16
R366_373	366	373	3.8355440205906339e+09
C366_373	366	373	2.3084568367531206e-16
R366_440	366	440	4.8626485570573988e+09
C366_440	366	440	1.8208570315346945e-16
R367_368	367	368	6.8340506246377718e+08
C367_368	367	368	1.2955988041820079e-15
R367_372	367	372	3.6557493103768716e+09
C367_372	367	372	2.4219898754729493e-16
R367_375	367	375	2.9715258511148973e+09
C367_375	367	375	2.9796771963730242e-16
R367_434	367	434	3.5432205189442120e+09
C367_434	367	434	2.4989096133475544e-16
R367_437	367	437	4.2662873324687061e+09
C367_437	367	437	2.0753847847084613e-16
R367_438	367	438	1.0652088417754108e+09
C367_438	367	438	8.3121613994890433e-16
R367_436	367	436	3.0973785117111297e+09
C367_436	367	436	2.8586069747441216e-16
R367_441	367	441	2.2055681922721176e+09
C367_441	367	441	4.0144702158941873e-16
R368_369	368	369	1.2158064441503198e+09
C368_369	368	369	7.2825636511474898e-16
R368_372	368	372	2.4201819706126666e+09
C368_372	368	372	3.6584801988085930e-16
R368_428	368	428	2.7937906394641757e+09
C368_428	368	428	3.1692381282722585e-16
R368_429	368	429	2.0274680996269863e+09
C368_429	368	429	4.3671157236106430e-16
R368_434	368	434	4.0257694615050488e+09
C368_434	368	434	2.1993777591252901e-16
R368_438	368	438	2.1113962467598851e+09
C368_438	368	438	4.1935225709468296e-16
R368_440	368	440	9.7582415380946493e+08
C368_440	368	440	9.0735485306800781e-16
R368_441	368	441	1.2612399128747985e+09
C368_441	368	441	7.0202248807828066e-16
R368_442	368	442	3.1706814876231055e+09
C368_442	368	442	2.7925188485701616e-16
R369_373	369	373	4.4063109739506826e+09
C369_373	369	373	2.0094332581936146e-16
R369_426	369	426	3.6549143192629294e+09
C369_426	369	426	2.4225431962480548e-16
R369_428	369	428	1.5085946414629707e+09
C369_428	369	428	5.8691629770165341e-16
R369_432	369	432	2.7647766766892142e+09
C369_432	369	432	3.2024965674995425e-16
R369_439	369	439	3.6279446147368836e+09
C369_439	369	439	2.4405520914056596e-16
R369_440	369	440	1.8260421784834478e+09
C369_440	369	440	4.8488407996980226e-16
R369_442	369	442	2.3339927834625630e+09
C369_442	369	442	3.7935797744260769e-16
R370_372	370	372	2.0242854981624014e+09
C370_372	370	372	4.3739817456764984e-16
R370_374	370	374	7.5815691050222301e+08
C370_374	370	374	1.1678569032807149e-15
R370_371	370	371	4.9837667591503363e+09
C370_371	370	371	1.7766055766441041e-16
R370_376	370	376	3.4706096438209910e+09
C370_376	370	376	2.5511909219649154e-16
R370_377	370	377	1.9763247524638405e+09
C370_377	370	377	4.4801279779356507e-16
R370_379	370	379	3.7267314111274552e+09
C370_379	370	379	2.3758588533004381e-16
R370_444	370	444	5.0610013548141432e+09
C370_444	370	444	1.7494932714407773e-16
R371_374	371	374	1.4495985167497206e+09
C371_374	371	374	6.1080276467533895e-16
R371_395	371	395	3.4191262332493019e+09
C371_395	371	395	2.5896054175764054e-16
R371_423	371	423	9.9694373521714818e+08
C371_423	371	423	8.8813315177425095e-16
R371_384	371	384	7.4870735981357908e+09
C371_384	371	384	1.1825966047942426e-16
R371_425	371	425	5.2393229701537342e+09
C371_425	371	425	1.6899488478642493e-16
R371_444	371	444	3.4936065864300022e+09
C371_444	371	444	2.5343975052576803e-16
R372_373	372	373	2.4191300712254910e+09
C372_373	372	373	3.6600709992061805e-16
R372_374	372	374	3.0877853683895950e+09
C372_374	372	374	2.8674881057609964e-16
R372_375	372	375	2.0159417260212412e+09
C372_375	372	375	4.3920851990474195e-16
R372_376	372	376	2.6267015576729341e+09
C372_376	372	376	3.3708389105476322e-16
R372_377	372	377	7.7933998626729906e+08
C372_377	372	377	1.1361136311518834e-15
R372_438	372	438	1.2479415186053216e+09
C372_438	372	438	7.0950342503992422e-16
R372_440	372	440	1.2007681393715110e+09
C372_440	372	440	7.3737697784306073e-16
R372_445	372	445	1.8291387906138709e+09
C372_445	372	445	4.8406320299119986e-16
R373_374	373	374	1.1503451245384190e+09
C373_374	373	374	7.6969838252261759e-16
R373_395	373	395	2.0979500398580492e+09
C373_395	373	395	4.2203997467923930e-16
R373_426	373	426	1.6087365468143694e+09
C373_426	373	426	5.5038146765131438e-16
R373_439	373	439	2.5453240140292401e+09
C373_439	373	439	3.4786093118981142e-16
R373_440	373	440	3.1959776412679362e+09
C373_440	373	440	2.7704160700846739e-16
R373_443	373	443	2.0577771865737393e+09
C373_443	373	443	4.3027922919791380e-16
R373_445	373	445	3.1242567743627186e+09
C373_445	373	445	2.8340141212644298e-16
R374_377	374	377	4.1128930090403366e+09
C374_377	374	377	2.1527882679024398e-16
R374_379	374	379	4.9484898377061510e+09
C374_379	374	379	1.7892706881063975e-16
R374_395	374	395	4.2438152223842530e+09
C374_395	374	395	2.0863744892327230e-16
R374_423	374	423	2.7907230021640458e+09
C374_423	374	423	3.1727218395140203e-16
R374_443	374	443	1.5746840481618474e+09
C374_443	374	443	5.6228345154925705e-16
R374_444	374	444	1.3220370642070262e+09
C374_444	374	444	6.6973824386011811e-16
R374_445	374	445	1.9441060205984852e+09
C374_445	374	445	4.5543749791352810e-16
R375_376	375	376	1.5183832286848533e+09
C375_376	375	376	5.8313261433143269e-16
R375_377	375	377	3.5848555946696124e+09
C375_377	375	377	2.4698868847507984e-16
R375_378	375	378	2.2760045297905231e+09
C375_378	375	378	3.8902329503777017e-16
R375_437	375	437	1.7178898295032654e+09
C375_437	375	437	5.1541068961099938e-16
R375_438	375	438	1.6752635550115244e+09
C375_438	375	438	5.2852506642986633e-16
R375_447	375	447	2.7903824651536746e+09
C375_447	375	447	3.1731090370482150e-16
R376_377	376	377	8.2971913334701920e+08
C376_377	376	377	1.0671307266692684e-15
R376_378	376	378	3.9148628734028263e+09
C376_378	376	378	2.2616853012028689e-16
R376_379	376	379	2.7177391167651525e+09
C376_379	376	379	3.2579241187575393e-16
R376_380	376	380	2.8775024496625195e+09
C376_380	376	380	3.0770391934986688e-16
R376_447	376	447	2.1903085797447557e+09
C376_447	376	447	4.0424385398845538e-16
R377_379	377	379	8.5769341492323625e+08
C377_379	377	379	1.0323254980093854e-15
R377_438	377	438	2.4985529422838912e+09
C377_438	377	438	3.5437263174045514e-16
R377_445	377	445	8.1823347965184402e+08
C377_445	377	445	1.0821101845853867e-15
R377_447	377	447	8.3153463042525291e+08
C377_447	377	447	1.0648008505035929e-15
R378_380	378	380	3.8228102272259088e+09
C378_380	378	380	2.3161463140233366e-16
R378_381	378	381	5.2170879651427174e+09
C378_381	378	381	1.6971513373280428e-16
R378_447	378	447	2.8057401893827386e+09
C378_447	378	447	3.1557404532698085e-16
R378_437	378	437	2.4461211940469046e+09
C378_437	378	437	3.6196848457665663e-16
R378_448	378	448	1.2834752814630935e+09
C378_448	378	448	6.8986040828980345e-16
R378_450	378	450	7.9105657524309893e+09
C378_450	378	450	1.1192862930542013e-16
R378_451	378	451	6.5294973335275583e+09
C378_451	378	451	1.3560290118407213e-16
R379_444	379	444	2.4124608332394762e+09
C379_444	379	444	3.6701892503309621e-16
R379_445	379	445	3.0559897409477024e+09
C379_445	379	445	2.8973224937117108e-16
R379_447	379	447	2.3215962954289269e+09
C379_447	379	447	3.8138361240640011e-16
R379_380	379	380	4.8984422705093527e+09
C379_380	379	380	1.8075517333961186e-16
R379_449	379	449	2.4413661277493167e+09
C379_449	379	449	3.6267349318730137e-16
R379_405	379	405	3.0379477392768416e+09
C379_405	379	405	2.9145293391741058e-16
R379_452	379	452	3.0551276944871254e+09
C379_452	379	452	2.8981400132561014e-16
R380_381	380	381	2.9149430990417004e+09
C380_381	380	381	3.0375165195886164e-16
R380_447	380	447	1.7611006887251155e+09
C380_447	380	447	5.0276442872835770e-16
R380_448	380	448	1.7233489900490282e+09
C380_448	380	448	5.1377799088437126e-16
R380_452	380	452	2.2083402222197533e+09
C380_452	380	452	4.0094310323705705e-16
R380_453	380	453	4.2241639765695629e+09
C380_453	380	453	2.0960805182071727e-16
R381_448	381	448	5.1286493827019672e+09
C381_448	381	448	1.7264170654487751e-16
R381_450	381	450	4.7794190192065020e+09
C381_450	381	450	1.8525657159204270e-16
R381_453	381	453	5.5244090266079941e+09
C381_453	381	453	1.6027393653066453e-16
R381_446	381	446	2.1567371837785931e+10
C381_446	381	446	4.1053624352539352e-17
R382_407	382	407	2.5869364417160473e+09
C382_407	382	407	3.4226537901049339e-16
R382_433	382	433	5.4873221586304617e+09
C382_433	382	433	1.6135717133126822e-16
R382_435	382	435	4.6208511408480740e+09
C382_435	382	435	1.9161378601291567e-16
R382_459	382	459	4.3363094029822264e+09
C382_459	382	459	2.0418717840822605e-16
R382_460	382	460	1.5243865004972395e+10
C382_460	382	460	5.8083614713931501e-17
R383_399	383	399	3.3715914809430213e+09
C383_399	383	399	2.6261152535963573e-16
R383_402	383	402	3.7050315841140008e+09
C383_402	383	402	2.3897739104206146e-16
R383_404	383	404	6.4686448177781668e+09
C383_404	383	404	1.3687855905560780e-16
R383_461	383	461	5.6671216464571962e+09
C383_461	383	461	1.5623782881977134e-16
R383_462	383	462	2.0818161848101299e+10
C383_462	383	462	4.2531073980518310e-17
R384_400	384	400	2.0527437148049250e+09
C384_400	384	400	4.3133430408975466e-16
R384_401	384	401	5.1299017281752768e+09
C384_401	384	401	1.7259956011183601e-16
R384_402	384	402	4.7116301933296919e+09
C384_402	384	402	1.8792196020678734e-16
R384_403	384	403	2.4529074396583223e+09
C384_403	384	403	3.6096705786147989e-16
R384_404	384	404	6.6770273803474092e+09
C384_404	384	404	1.3260673219733468e-16
R384_423	384	423	3.5339208600324721e+09
C384_423	384	423	2.5054855973539383e-16
R384_424	384	424	2.4812217023667531e+09
C384_424	384	424	3.5684791119448505e-16
R384_425	384	425	7.8463478687050943e+09
C384_425	384	425	1.1284470132040213e-16
R384_463	384	463	6.9269835302961693e+09
C384_463	384	463	1.2782169581138635e-16
R385_394	385	394	3.8051342016669598e+09
C385_394	385	394	2.3269055301968440e-16
R385_415	385	415	3.0412280296041088e+09
C385_415	385	415	2.9113857069614716e-16
R385_466	385	466	1.4662168301733175e+10
C385_466	385	466	6.0387983787864250e-17
R386_387	386	387	2.5941804914734101e+09
C386_387	386	387	3.4130962922981171e-16
R386_388	386	388	6.9571945930445910e+09
C386_388	386	388	1.2726664028992256e-16
R386_395	386	395	4.0930184753294711e+09
C386_395	386	395	2.1632415955042262e-16
R386_400	386	400	2.8808119417319946e+09
C386_400	386	400	3.0735042745194632e-16
R386_401	386	401	6.5210825288205996e+09
C386_401	386	401	1.3577788316384590e-16
R386_427	386	427	6.4079893799233999e+09
C386_427	386	427	1.3817419617986074e-16
R386_467	386	467	7.5083863153597212e+09
C386_467	386	467	1.1792397787108007e-16
R387_388	387	388	2.0197315692119911e+09
C387_388	387	388	4.3838438493361310e-16
R387_389	387	389	1.1315241683055565e+09
C387_389	387	389	7.8250098981615539e-16
R387_391	387	391	3.7503472969730525e+09
C387_391	387	391	2.3608981024627546e-16
R387_396	387	396	4.1912452133088094e+08
C387_396	387	396	2.1125434963539137e-15
R387_397	387	397	1.8844314838693283e+09
C387_397	387	397	4.6985989635556174e-16
R387_401	387	401	2.8378677740783162e+09
C387_401	387	401	3.1200142226061491e-16
R387_467	387	467	3.1120968068354244e+09
C387_467	387	467	2.8450875299099372e-16
R388_396	388	396	5.4099421493391943e+09
C388_396	388	396	1.6366511087519685e-16
R388_409	388	409	2.6204053851510272e+09
C388_409	388	409	3.3789381853562651e-16
R388_412	388	412	3.3023922416604571e+09
C388_412	388	412	2.6811435980566849e-16
R388_419	388	419	2.8741881122548804e+09
C388_419	388	419	3.0805874463288494e-16
R388_427	388	427	2.0895850972323601e+09
C388_427	388	427	4.2372946805216514e-16
R388_430	388	430	5.8841888850488749e+09
C388_430	388	430	1.5047422830863892e-16
R388_467	388	467	3.6124070450789866e+09
C388_467	388	467	2.4510493160126145e-16
R388_468	388	468	3.1133565822479382e+09
C388_468	388	468	2.8439363057497918e-16
R389_390	389	390	2.8974519398472800e+09
C389_390	389	390	3.0558532120007108e-16
R389_391	389	391	2.4874239847380567e+09
C389_391	389	391	3.5595812661315992e-16
R389_396	389	396	3.9926515893093209e+09
C389_396	389	396	2.2176209516272031e-16
R389_397	389	397	1.9684032369850676e+09
C389_397	389	397	4.4981575170347921e-16
R389_398	389	398	3.1924096874102168e+09
C389_398	389	398	2.7735123884374614e-16
R389_469	389	469	6.2881235891856384e+09
C389_469	389	469	1.4080810740150686e-16
R389_471	389	471	4.5313135376963568e+09
C389_471	389	471	1.9540002569544811e-16
R390_391	390	391	6.8934509010820389e+09
C390_391	390	391	1.2844347401691354e-16
R390_392	390	392	9.0011637702718010e+09
C390_392	390	392	9.8367144993437176e-17
R390_398	390	398	1.3824065220876106e+10
C390_398	390	398	6.4049088857227353e-17
R390_471	390	471	9.5171858816882019e+09
C390_471	390	471	9.3033675364438759e-17
R391_392	391	392	2.5172681493945827e+09
C391_392	391	392	3.5173796717403680e-16
R391_393	391	393	2.2121176748775258e+09
C391_393	391	393	4.0025844545047597e-16
R391_396	391	396	2.5340177084110284e+09
C391_396	391	396	3.4941302058035239e-16
R391_412	391	412	3.4069157716142440e+09
C391_412	391	412	2.5988866207880341e-16
R391_421	391	421	1.7505059961359730e+09
C391_421	391	421	5.0580734008021297e-16
R391_469	391	469	1.7441507504925897e+09
C391_469	391	469	5.0765037451604252e-16
R391_470	391	470	3.0328904347671371e+09
C391_470	391	470	2.9193892781292698e-16
R391_471	391	471	1.9786004834096324e+09
C391_471	391	471	4.4749750600191807e-16
R391_472	391	472	5.6778558113610477e+09
C391_472	391	472	1.5594245629280165e-16
R392_393	392	393	2.3573844546398382e+09
C392_393	392	393	3.7559371359953866e-16
R392_394	392	394	8.2959641147669096e+09
C392_394	392	394	1.0672885868972656e-16
R392_471	392	471	9.7078519521982956e+09
C392_471	392	471	9.1206457006124957e-17
R392_472	392	472	6.6379878111620522e+09
C392_472	392	472	1.3338662361071702e-16
R393_394	393	394	1.0992376858555861e+09
C393_394	393	394	8.0548437621190061e-16
R393_414	393	414	7.5335658377010250e+08
C393_414	393	414	1.1752983922553706e-15
R393_415	393	415	3.4533272577860560e+09
C393_415	393	415	2.5639585119067060e-16
R393_421	393	421	2.6730997119284182e+09
C393_421	393	421	3.3123297935685469e-16
R393_470	393	470	4.0662901296205239e+09
C393_470	393	470	2.1774609127131549e-16
R393_472	393	472	1.5641176963564966e+09
C393_472	393	472	5.6608194112407371e-16
R394_415	394	415	3.4798300005815258e+09
C394_415	394	415	2.5444311404638582e-16
R394_414	394	414	3.7948969916297498e+09
C394_414	394	414	2.3331826493655357e-16
R394_466	394	466	5.6717344430249910e+09
C394_466	394	466	1.5611076128376813e-16
R394_472	394	472	4.2151247786212335e+09
C394_472	394	472	2.1005754946823192e-16
R395_400	395	400	2.5777591379413857e+09
C395_400	395	400	3.4348390765752497e-16
R395_423	395	423	1.5564818660419238e+09
C395_423	395	423	5.6885904103180316e-16
R395_426	395	426	2.0437840509960356e+09
C395_426	395	426	4.3322521343118050e-16
R395_427	395	427	1.5108911447079890e+09
C395_427	395	427	5.8602420485502663e-16
R395_443	395	443	3.4961698446678014e+09
C395_443	395	443	2.5325393817763192e-16
R395_473	395	473	4.1420520569989796e+09
C395_473	395	473	2.1376331574681081e-16
R396_397	396	397	2.4037660668704400e+09
C396_397	396	397	3.6834648508569830e-16
R396_401	396	401	5.1880599110837212e+09
C396_401	396	401	1.7066471800150186e-16
R396_412	396	412	9.9825787141008389e+08
C396_412	396	412	8.8696398702001363e-16
R396_467	396	467	2.3134983577430787e+09
C396_467	396	467	3.8271856936339733e-16
R396_469	396	469	1.6322057323589561e+09
C396_469	396	469	5.4246763391790258e-16
R396_475	396	475	3.0428424214821916e+09
C396_475	396	475	2.9098410599544158e-16
R397_398	397	398	1.3661007415706508e+09
C397_398	397	398	6.4813578878670775e-16
R397_399	397	399	2.1772347997646089e+09
C397_399	397	399	4.0667124271379780e-16
R397_401	397	401	1.3759347873252194e+09
C397_401	397	401	6.4350344933223957e-16
R397_402	397	402	2.4366921476354098e+09
C397_402	397	402	3.6336916116351390e-16
R397_469	397	469	2.0924798695849695e+09
C397_469	397	469	4.2314327347656514e-16
R397_471	397	471	4.0887042481106887e+09
C397_471	397	471	2.1655241562388258e-16
R397_475	397	475	1.0050221430711974e+09
C397_475	397	475	8.8099430226909524e-16
R397_476	397	476	2.1432710995795047e+09
C397_476	397	476	4.1311562586446178e-16
R398_399	398	399	3.4425334342240586e+09
C398_399	398	399	2.5719976250559555e-16
R398_471	398	471	5.5489671091353636e+09
C398_471	398	471	1.5956461162696735e-16
R398_476	398	476	9.0042127825563641e+09
C398_476	398	476	9.8333835847959960e-17
R399_402	399	402	8.2680004798521566e+08
C399_402	399	402	1.0708983191977665e-15
R399_461	399	461	2.3325664143748264e+09
C399_461	399	461	3.7958995561432270e-16
R399_475	399	475	4.5608189585825090e+09
C399_475	399	475	1.9413591939093016e-16
R399_476	399	476	2.7373065528933320e+09
C399_476	399	476	3.2346350859537921e-16
R399_478	399	478	3.1890133869661393e+09
C399_478	399	478	2.7764661801634556e-16
R400_401	400	401	6.1019650346366346e+08
C400_401	400	401	1.4510387664860252e-15
R400_403	400	403	1.6258901484576759e+09
C400_403	400	403	5.4457478725725154e-16
R400_423	400	423	1.0102304629704403e+09
C400_423	400	423	8.7645226921444330e-16
R400_424	400	424	9.6430818158249390e+08
C400_424	400	424	9.1819067660192279e-16
R400_427	400	427	2.2824533166826134e+09
C400_427	400	427	3.8792415828547782e-16
R400_467	400	467	1.4491970352829630e+09
C400_467	400	467	6.1097197975368310e-16
R400_473	400	473	6.7943566921249890e+08
C400_473	400	473	1.3031679404265690e-15
R400_479	400	479	1.6961271287650425e+09
C400_479	400	479	5.2202383104660153e-16
R401_402	401	402	2.4675969294058356e+09
C401_402	401	402	3.5881823775538465e-16
R401_403	401	403	1.6748140835516241e+09
C401_403	401	403	5.2866690720821626e-16
R401_467	401	467	1.9451728014399378e+09
C401_467	401	467	4.5518772473302021e-16
R401_475	401	475	1.2962800525264776e+09
C401_475	401	475	6.8304590506835310e-16
R401_479	401	479	3.3564386316123161e+09
C401_479	401	479	2.6379710129682175e-16
R402_403	402	403	9.8178624487576818e+08
C402_403	402	403	9.0184476134317592e-16
R402_404	402	404	1.1908203288695958e+09
C402_404	402	404	7.4353683778685342e-16
R402_461	402	461	1.5411369214652803e+09
C402_461	402	461	5.7452311301332180e-16
R402_475	402	475	2.7118912517510147e+09
C402_475	402	475	3.2649494375126682e-16
R402_478	402	478	1.2554356550483632e+09
C402_478	402	478	7.0526814985662557e-16
R402_480	402	480	3.6731354334746432e+09
C402_480	402	480	2.4105258238801949e-16
R403_404	403	404	2.7339311453154073e+09
C403_404	403	404	3.2386286802327326e-16
R403_424	403	424	1.2054792185460010e+09
C403_424	403	424	7.3449526800466575e-16
R403_463	403	463	3.9861070936733069e+09
C403_463	403	463	2.2212619001263772e-16
R403_475	403	475	3.7890666317654624e+09
C403_475	403	475	2.3367727932708634e-16
R403_478	403	478	2.4108376395696330e+09
C403_478	403	478	3.6726603532623587e-16
R403_479	403	479	1.2192548398509653e+09
C403_479	403	479	7.2619665123349314e-16
R403_480	403	480	1.2673432155339305e+09
C403_480	403	480	6.9864167089652498e-16
R404_461	404	461	3.8931810993558593e+09
C404_461	404	461	2.2742810033843432e-16
R404_462	404	462	3.5697699967004051e+09
C404_462	404	462	2.4803244537278501e-16
R404_463	404	463	4.0184100660587306e+09
C404_463	404	463	2.2034057429296206e-16
R404_480	404	480	1.6698560954105625e+09
C404_480	404	480	5.3023657795033213e-16
R404_481	404	481	6.1659423092722473e+09
C404_481	404	481	1.4359829159746130e-16
R405_444	405	444	4.3120545107175741e+09
C405_444	405	444	2.0533571166581946e-16
R405_449	405	449	1.0735520979623569e+09
C405_449	405	449	8.2475623062966276e-16
R405_452	405	452	3.9150044472823405e+09
C405_452	405	452	2.2616035144343880e-16
R405_464	405	464	2.7381535643149033e+09
C405_464	405	464	3.2336344945705599e-16
R405_482	405	482	4.1770098975731144e+09
C405_482	405	482	2.1197430779717261e-16
R406_407	406	407	3.6355716407918777e+09
C406_407	406	407	2.4354320838170680e-16
R406_410	406	410	4.4811615976961126e+09
C406_410	406	410	1.9758688955899694e-16
R406_411	406	411	1.5572006623270168e+09
C406_411	406	411	5.6859645845312350e-16
R406_422	406	422	6.2589352286626883e+09
C406_422	406	422	1.4146476187279263e-16
R406_483	406	483	8.7067715654107895e+09
C406_483	406	483	1.0169312184753816e-16
R407_411	407	411	1.3306664915876687e+09
C407_411	407	411	6.6539496357466210e-16
R407_433	407	433	1.8911732542595489e+09
C407_433	407	433	4.6818491098356188e-16
R407_458	407	458	2.2537772950081573e+09
C407_458	407	458	3.9285992616089220e-16
R407_459	407	459	2.8447078385589671e+09
C407_459	407	459	3.1125121873623522e-16
R407_483	407	483	3.5889317040724511e+09
C407_483	407	483	2.4670817243339934e-16
R408_409	408	409	1.5729870978657970e+09
C408_409	408	409	5.6289004716015887e-16
R408_410	408	410	2.0298551527500389e+09
C408_410	408	410	4.3619801171548545e-16
R408_413	408	413	2.0796124417820361e+09
C408_413	408	413	4.2576143704029666e-16
R408_416	408	416	3.2700442812391534e+09
C408_416	408	416	2.7076660300284334e-16
R408_419	408	419	4.0705358354195962e+09
C408_419	408	419	2.1751897477368108e-16
R408_432	408	432	4.8453068095542374e+09
C408_432	408	432	1.8273740270772609e-16
R408_484	408	484	3.3088290661768193e+09
C408_484	408	484	2.6759278403071316e-16
R409_419	409	419	1.3057162035862744e+09
C409_419	409	419	6.7810966829400798e-16
R409_426	409	426	1.0839016560311489e+09
C409_426	409	426	8.1688110427110117e-16
R409_427	409	427	2.0753723100557296e+09
C409_427	409	427	4.2663129762785745e-16
R409_430	409	430	7.5588546973441565e+08
C409_430	409	430	1.1713663208939532e-15
R409_432	409	432	1.8918661468122499e+09
C409_432	409	432	4.6801343910715348e-16
R409_484	409	484	3.6618973203180366e+09
C409_484	409	484	2.4179235632502698e-16
R410_411	410	411	2.4717732035933981e+09
C410_411	410	411	3.5821198336999613e-16
R410_416	410	416	1.7390447144067202e+09
C410_416	410	416	5.0914089463309938e-16
R410_422	410	422	2.4140145325029821e+09
C410_422	410	422	3.6678270564591410e-16
R410_428	410	428	2.2201259165656300e+09
C410_428	410	428	3.9881466861558798e-16
R410_431	410	431	1.1098123310153468e+09
C410_431	410	431	7.9780946467764238e-16
R410_432	410	432	2.7205513851096520e+09
C410_432	410	432	3.2545563614278632e-16
R410_484	410	484	2.8013967935869651e+09
C410_484	410	484	3.1606332374154405e-16
R410_485	410	485	2.5181489452844453e+09
C410_485	410	485	3.5161493658191254e-16
R411_422	411	422	4.0228443083526611e+09
C411_422	411	422	2.2009770049057047e-16
R411_431	411	431	1.2636537763053296e+09
C411_431	411	431	7.0068146695116700e-16
R411_433	411	433	2.1761118642620816e+09
C411_433	411	433	4.0688109662057522e-16
R411_458	411	458	1.0495638548210987e+09
C411_458	411	458	8.4360639672649780e-16
R411_483	411	483	1.1207059592711170e+09
C411_483	411	483	7.9005449589637009e-16
R411_485	411	485	1.9209135590150020e+09
C411_485	411	485	4.6093629645366321e-16
R412_419	412	419	4.9262890339626827e+09
C412_419	412	419	1.7973342116058778e-16
R412_421	412	421	3.3721243515466647e+09
C412_421	412	421	2.6257002690125949e-16
R412_467	412	467	2.2496952135980639e+09
C412_467	412	467	3.9357277214627664e-16
R412_468	412	468	4.3688672687742777e+09
C412_468	412	468	2.0266552569092164e-16
R412_469	412	469	1.5752755496953275e+09
C412_469	412	469	5.6207231926582496e-16
R412_475	412	475	6.5991295160558691e+09
C412_475	412	475	1.3417205701839173e-16
R412_477	412	477	5.8312619986995916e+09
C412_477	412	477	1.5183999310911667e-16
R412_486	412	486	1.3874667968330975e+09
C412_486	412	486	6.3815493366830431e-16
R413_416	413	416	1.1383860341880548e+09
C413_416	413	416	7.7778429733769385e-16
R413_419	413	419	1.2558954994756250e+09
C413_419	413	419	7.0500991688376119e-16
R413_420	413	420	1.7716053757376862e+09
C413_420	413	420	4.9978330040419794e-16
R413_484	413	484	4.0114195831233077e+09
C413_484	413	484	2.2072454983893991e-16
R413_488	413	488	3.2446378773362813e+09
C413_488	413	488	2.7288677971881829e-16
R414_415	414	415	6.6737542207133329e+08
C414_415	414	415	1.3267176950447552e-15
R414_420	414	420	1.1895660883392513e+09
C414_420	414	420	7.4432079930601400e-16
R414_421	414	421	1.8404360802893879e+09
C414_421	414	421	4.8109184077763675e-16
R414_466	414	466	2.0562832959161389e+09
C414_466	414	466	4.3059182723434910e-16
R414_470	414	470	3.9342869118527279e+09
C414_470	414	470	2.2505190941527956e-16
R414_472	414	472	2.0838819612084773e+09
C414_472	414	472	4.2488912432762323e-16
R414_487	414	487	7.8536180377121818e+08
C414_487	414	487	1.1274023990577584e-15
R414_489	414	489	1.1257994065501752e+09
C414_489	414	489	7.8648005723614506e-16
R415_418	415	418	4.7865446915963335e+09
C415_418	415	418	1.8498078232812013e-16
R415_420	415	420	5.2209378408724794e+09
C415_420	415	420	1.6958998721808888e-16
R415_466	415	466	5.3194387760275126e+09
C415_466	415	466	1.6644966113534618e-16
R415_489	415	489	3.2909974417866998e+09
C415_489	415	489	2.6904268306550297e-16
R416_417	416	417	2.0520281079043818e+09
C416_417	416	417	4.3148472396132390e-16
R416_418	416	418	9.1685642814383659e+09
C416_418	416	418	9.6571148384978701e-17
R416_420	416	420	4.6604556119846277e+09
C416_420	416	420	1.8998545537545617e-16
R416_422	416	422	2.2778110577230558e+09
C416_422	416	422	3.8871476134859128e-16
R416_484	416	484	3.1971239553841491e+09
C416_484	416	484	2.7694227501217198e-16
R416_485	416	485	6.4242764301955271e+09
C416_485	416	485	1.3782389212555283e-16
R416_488	416	488	1.1467345027358313e+09
C416_488	416	488	7.7212186394287853e-16
R416_490	416	490	3.0384237183818526e+09
C416_490	416	490	2.9140727685325597e-16
R417_418	417	418	7.2523577033815727e+09
C417_418	417	418	1.2208702575262581e-16
R417_422	417	422	9.2357630758563118e+09
C417_422	417	422	9.5868503168365093e-17
R417_490	417	490	1.0920257983587654e+10
C417_490	417	490	8.1080390502744488e-17
R418_420	418	420	3.4907562400065913e+09
C418_420	418	420	2.5364669453353983e-16
R418_489	418	489	1.4389517464040289e+10
C418_489	418	489	6.1532208005770905e-17
R418_490	418	490	8.4218743025581141e+09
C418_490	418	490	1.0513322211791468e-16
R419_420	419	420	2.1802361921967974e+09
C419_420	419	420	4.0611140429141107e-16
R419_421	419	421	1.2251721566550624e+09
C419_421	419	421	7.2268927831118098e-16
R419_430	419	430	7.3922252634006214e+08
C419_430	419	430	1.1977702926394372e-15
R419_468	419	468	9.8574785406433928e+08
C419_468	419	468	8.9822034919916672e-16
R419_484	419	484	9.8086884874027145e+08
C419_484	419	484	9.0268824709556482e-16
R419_486	419	486	2.1335704141037929e+09
C419_486	419	486	4.1499393497726231e-16
R419_488	419	488	2.3511357425042815e+09
C419_488	419	488	3.7659194477512723e-16
R419_491	419	491	1.0082883441145304e+09
C419_491	419	491	8.7814045145743199e-16
R420_421	420	421	2.4486523109271059e+09
C420_421	420	421	3.6159432588645625e-16
R420_487	420	487	3.2037394514214840e+09
C420_487	420	487	2.7637040874442642e-16
R420_488	420	488	2.6312110780718026e+09
C420_488	420	488	3.3650617735649335e-16
R420_489	420	489	1.7976572563243010e+09
C420_489	420	489	4.9254037641771049e-16
R420_490	420	490	1.9406121385961530e+09
C420_490	420	490	4.5625746850193145e-16
R420_491	420	491	1.6990984840855436e+09
C420_491	420	491	5.2111092440679399e-16
R421_469	421	469	3.1243822967675252e+09
C421_469	421	469	2.8339002644332328e-16
R421_470	421	470	1.2104211987770915e+09
C421_470	421	470	7.3149642669390880e-16
R421_486	421	486	1.3280379984811172e+09
C421_486	421	486	6.6671193347830209e-16
R421_487	421	487	1.4971907099271443e+09
C421_487	421	487	5.9138677245939222e-16
R421_491	421	491	2.7258431584984298e+09
C421_491	421	491	3.2482381788530562e-16
R422_483	422	483	3.3693537794901452e+09
C422_483	422	483	2.6278593452836607e-16
R422_485	422	485	1.0707277235506134e+09
C422_485	422	485	8.2693177941062810e-16
R422_488	422	488	1.9726391575509386e+09
C422_488	422	488	4.4884984580720825e-16
R422_490	422	490	3.2539345211411700e+09
C422_490	422	490	2.7210712936825768e-16
R422_494	422	494	2.7236337845513258e+09
C422_494	422	494	3.2508731046081454e-16
R423_424	423	424	1.6558547249762840e+09
C423_424	423	424	5.3472008645727145e-16
R423_425	423	425	2.4305106908482757e+09
C423_425	423	425	3.6429330882349614e-16
R423_443	423	443	1.8157722290045679e+09
C423_443	423	443	4.8762656877145832e-16
R423_444	423	444	3.6971419177973561e+09
C423_444	423	444	2.3948736656219713e-16
R423_473	423	473	1.3657092630421405e+09
C423_473	423	473	6.4832157594634354e-16
R423_495	423	495	3.0596247769905877e+09
C423_495	423	495	2.8938802834865520e-16
R424_425	424	425	3.6083627684460311e+09
C424_425	424	425	2.4537964681453373e-16
R424_463	424	463	2.3378162584268780e+09
C424_463	424	463	3.7873754128812522e-16
R424_473	424	473	2.3963714763699360e+09
C424_473	424	473	3.6948310828722074e-16
R424_479	424	479	2.1058762143762577e+09
C424_479	424	479	4.2045148506615978e-16
R424_480	424	480	3.5858260908149705e+09
C424_480	424	480	2.4692184151595769e-16
R424_495	424	495	1.8327099057979095e+09
C424_495	424	495	4.8311998472803256e-16
R425_444	425	444	2.3483637119041452e+09
C425_444	425	444	3.7703647744670175e-16
R425_463	425	463	3.7117630443965182e+09
C425_463	425	463	2.3854399408299436e-16
R425_464	425	464	4.3187495508467922e+09
C425_464	425	464	2.0501739479808292e-16
R425_495	425	495	1.7367361450617788e+09
C425_495	425	495	5.0981767392680364e-16
R425_465	425	465	3.6182525197320271e+09
C425_465	425	465	2.4470895186872563e-16
R426_427	426	427	1.3360570712379134e+09
C426_427	426	427	6.6271029940331963e-16
R426_430	426	430	3.8910994563213716e+09
C426_430	426	430	2.2754976880932028e-16
R426_432	426	432	2.8274934972261057e+09
C426_432	426	432	3.1314617790231326e-16
R426_439	426	439	3.3987270853329835e+09
C426_439	426	439	2.6051482201115097e-16
R426_443	426	443	4.1608092653111234e+09
C426_443	426	443	2.1279965632690279e-16
R426_497	426	497	2.6308755168607125e+09
C426_497	426	497	3.3654909782904678e-16
R427_430	427	430	2.9777687542757535e+09
C427_430	427	430	2.9734302921562807e-16
R427_443	427	443	5.0185763188244295e+09
C427_443	427	443	1.7642827874886316e-16
R427_467	427	467	2.0691830816042387e+09
C427_467	427	467	4.2790741407644519e-16
R427_468	427	468	2.1306692737753565e+09
C427_468	427	468	4.1555899481814772e-16
R427_473	427	473	1.8779802690735686e+09
C427_473	427	473	4.7147395331090900e-16
R427_474	427	474	3.3362859840658207e+09
C427_474	427	474	2.6539055282694006e-16
R427_497	427	497	2.4284938179345355e+09
C427_497	427	497	3.6459585573623560e-16
R427_498	427	498	5.4619377625136824e+09
C427_498	427	498	1.6210707997751231e-16
R428_429	428	429	7.9489231281287658e+08
C428_429	428	429	1.1138851985708334e-15
R428_431	428	431	1.5408963607424729e+09
C428_431	428	431	5.7461280606397543e-16
R428_432	428	432	1.0598564170838357e+09
C428_432	428	432	8.3541389892812478e-16
R428_433	428	433	5.2119732727221823e+09
C428_433	428	433	1.6988168115404612e-16
R428_441	428	441	6.7291594871579704e+09
C428_441	428	441	1.3157940206198808e-16
R428_442	428	442	2.4773126651577010e+09
C428_442	428	442	3.5741099383740322e-16
R428_499	428	499	2.0103027039409750e+09
C428_499	428	499	4.4044052667503009e-16
R429_433	429	433	3.9079150449073353e+09
C429_433	429	433	2.2657063204427849e-16
R429_434	429	434	2.2338099295410953e+09
C429_434	429	434	3.9637158470411886e-16
R429_441	429	441	6.6065941201282997e+09
C429_441	429	441	1.3402045980127583e-16
R429_499	429	499	5.4055551306187983e+09
C429_499	429	499	1.6379793754848676e-16
R430_432	430	432	1.7056937699618759e+09
C430_432	430	432	5.1909598152532984e-16
R430_468	430	468	6.8252823482163560e+08
C430_468	430	468	1.2972632288705033e-15
R430_484	430	484	1.3509579091778867e+09
C430_484	430	484	6.5540071654698230e-16
R430_491	430	491	5.3756816771842108e+09
C430_491	430	491	1.6470818676967933e-16
R430_496	430	496	1.0672753409490668e+09
C430_496	430	496	8.2960670759304524e-16
R430_497	430	497	7.9693294708648217e+08
C430_497	430	497	1.1110329732721107e-15
R430_500	430	500	4.3288998475862465e+09
C430_500	430	500	2.0453667510781083e-16
R431_432	431	432	1.9719976481644659e+09
C431_432	431	432	4.4899586088459446e-16
R431_433	431	433	3.1544619382542171e+09
C431_433	431	433	2.8068773661920282e-16
R431_458	431	458	2.9435479163061509e+09
C431_458	431	458	3.0079985339973985e-16
R431_484	431	484	4.3336554544903421e+09
C431_484	431	484	2.0431222347927275e-16
R431_485	431	485	1.8464119559986370e+09
C431_485	431	485	4.7953479656771338e-16
R431_499	431	499	2.0273939114588115e+09
C431_499	431	499	4.3672755289222346e-16
R431_500	431	500	1.4556924143145590e+09
C431_500	431	500	6.0824578942174173e-16
R432_439	432	439	6.5446373545958643e+09
C432_439	432	439	1.3528920453907643e-16
R432_442	432	442	4.1708860610907745e+09
C432_442	432	442	2.1228553567067338e-16
R432_484	432	484	3.0523968250710893e+09
C432_484	432	484	2.9007328746627792e-16
R432_497	432	497	3.5808777268508334e+09
C432_497	432	497	2.4726305929431239e-16
R432_499	432	499	5.2743861427641478e+09
C432_499	432	499	1.6787143711779486e-16
R432_500	432	500	2.6292263660058422e+09
C432_500	432	500	3.3676019423351276e-16
R432_503	432	503	4.8157123344196768e+09
C432_503	432	503	1.8386039701158739e-16
R433_434	433	434	6.2939910533350487e+09
C433_434	433	434	1.4067684148213650e-16
R433_435	433	435	4.9557968509318600e+09
C433_435	433	435	1.7866325201234003e-16
R433_458	433	458	2.3080692958634906e+09
C433_458	433	458	3.8361880351116085e-16
R433_459	433	459	8.0558732838316736e+09
C433_459	433	459	1.0990972058573168e-16
R433_499	433	499	2.3631954186904244e+09
C433_499	433	499	3.7467014987303038e-16
R433_501	433	501	6.5491373869150696e+09
C433_501	433	501	1.3519624484730361e-16
R433_505	433	505	5.4427026274610662e+09
C433_505	433	505	1.6267998498257728e-16
R434_435	434	435	6.9000021318349524e+09
C434_435	434	435	1.2832152291879603e-16
R434_441	434	441	2.1961369882724996e+09
C434_441	434	441	4.0317101639296109e-16
R434_436	434	436	1.2175878236434389e+10
C434_436	434	436	7.2719089703979161e-17
R434_499	434	499	7.0075556792697096e+09
C434_499	434	499	1.2635201519972420e-16
R434_505	434	505	4.3799127962453718e+09
C434_505	434	505	2.0215443158115265e-16
R434_506	434	506	8.0106809116101389e+09
C434_506	434	506	1.1052977786404326e-16
R435_459	435	459	5.3578218701962729e+09
C435_459	435	459	1.6525722637874196e-16
R435_460	435	460	4.6763792740452642e+09
C435_460	435	460	1.8933853090450368e-16
R435_501	435	501	5.2544352060683117e+09
C435_501	435	501	1.6850884005143613e-16
R435_502	435	502	6.1788179078149462e+09
C435_502	435	502	1.4329905734560092e-16
R435_505	435	505	4.8491719599050779e+09
C435_505	435	505	1.8259174742017852e-16
R435_506	435	506	9.7954605925415649e+09
C435_506	435	506	9.0390724696924736e-17
R436_437	436	437	2.7286067175332494e+09
C436_437	436	437	3.2449483320939997e-16
R436_438	436	438	3.4688107944776478e+09
C436_438	436	438	2.5525139137297089e-16
R436_441	436	441	1.9528033089314125e+09
C436_441	436	441	4.5340909535047214e-16
R436_506	436	506	3.8054024736698318e+09
C436_506	436	506	2.3267414887816720e-16
R436_508	436	508	1.8598958925969021e+09
C436_508	436	508	4.7605824886452299e-16
R436_507	436	507	9.1899098883327084e+09
C436_507	436	507	9.6346840443354809e-17
R436_451	436	451	7.6594967562404451e+09
C436_451	436	451	1.1559751376337097e-16
R437_438	437	438	1.8207513902556841e+09
C437_438	437	438	4.8629306913540924e-16
R437_447	437	447	4.1157403102450695e+09
C437_447	437	447	2.1512989522103215e-16
R437_448	437	448	5.4594468072565928e+09
C437_448	437	448	1.6218104378691229e-16
R437_451	437	451	4.4419163149604416e+09
C437_451	437	451	1.9933261207958738e-16
R437_508	437	508	4.1623619379523773e+09
C437_508	437	508	2.1272027634760924e-16
R438_440	438	440	1.6365592371785128e+09
C438_440	438	440	5.4102458474188444e-16
R438_441	438	441	1.6177518827430165e+09
C438_441	438	441	5.4731432622331917e-16
R438_445	438	445	4.1077276626773376e+09
C438_445	438	445	2.1554953356447715e-16
R438_447	438	447	2.3887697653817182e+09
C438_447	438	447	3.7065890339520137e-16
R438_508	438	508	3.8284563771611638e+09
C438_508	438	508	2.3127304962438837e-16
R438_510	438	510	2.1594348549775095e+09
C438_510	438	510	4.1002338165428085e-16
R439_440	439	440	3.7120305627706718e+09
C439_440	439	440	2.3852680271013735e-16
R439_442	439	442	4.0689338398477998e+09
C439_442	439	442	2.1760461500477962e-16
R439_443	439	443	4.0689338398478012e+09
C439_443	439	443	2.1760461500477959e-16
R439_445	439	445	4.5624336374079580e+09
C439_445	439	445	1.9406721326099780e-16
R439_497	439	497	4.5029158930168695e+09
C439_497	439	497	1.9663231620051119e-16
R439_503	439	503	3.7190070164883842e+09
C439_503	439	503	2.3807935230411137e-16
R439_509	439	509	2.8447221647270908e+09
C439_509	439	509	3.1124965125898093e-16
R439_510	439	510	6.1273159651626959e+09
C439_510	439	510	1.4450352923435215e-16
R440_441	440	441	4.0672759382836480e+09
C440_441	440	441	2.1769331492016704e-16
R440_442	440	442	2.0642413209871342e+09
C440_442	440	442	4.2893181756316490e-16
R440_445	440	445	3.0235347421841412e+09
C440_445	440	445	2.9284227144695922e-16
R440_510	440	510	2.6911562325631146e+09
C440_510	440	510	3.2901054609405127e-16
R441_442	441	442	2.0908944215722191e+09
C441_442	441	442	4.2346412739205723e-16
R441_499	441	499	2.9386404394651585e+09
C441_499	441	499	3.0130218376125964e-16
R441_505	441	505	2.1951109103353596e+09
C441_505	441	505	4.0335947378837888e-16
R441_506	441	506	4.9699486888277578e+09
C441_506	441	506	1.7815451167340731e-16
R441_508	441	508	2.9879452667960515e+09
C441_508	441	508	2.9633032155553068e-16
R441_510	441	510	3.0575705134754310e+09
C441_510	441	510	2.8958245698594734e-16
R441_511	441	511	4.4335022007308540e+09
C441_511	441	511	1.9971091512124218e-16
R442_499	442	499	1.9574008953863513e+09
C442_499	442	499	4.5234411805315757e-16
R442_503	442	503	1.7933753127222407e+09
C442_503	442	503	4.9371638798572801e-16
R442_510	442	510	3.5398759675471187e+09
C442_510	442	510	2.5012706372125580e-16
R442_511	442	511	3.4709922180827537e+09
C442_511	442	511	2.5509097285993696e-16
R443_444	443	444	3.6836309622551589e+09
C443_444	443	444	2.4036576703056517e-16
R443_445	443	445	1.7337363810610116e+09
C443_445	443	445	5.1069977614367283e-16
R443_473	443	473	2.1655972667938957e+09
C443_473	443	473	4.0885662134716170e-16
R443_495	443	495	2.7028334740236058e+09
C443_495	443	495	3.2758909870311418e-16
R443_497	443	497	3.7232106012411594e+09
C443_497	443	497	2.3781055560081378e-16
R443_498	443	498	1.2413935238592277e+09
C443_498	443	498	7.1324585208679196e-16
R443_509	443	509	2.2100856878494287e+09
C443_509	443	509	4.0062644926748330e-16
R443_512	443	512	2.3323745941918206e+09
C443_512	443	512	3.7962117401934835e-16
R444_445	444	445	3.1135308608033314e+09
C444_445	444	445	2.8437771176340627e-16
R444_449	444	449	1.8856325057297208e+09
C444_449	444	449	4.6956062700953063e-16
R444_464	444	464	2.2498922867072024e+09
C444_464	444	464	3.9353829822486396e-16
R444_495	444	495	2.7390064914707494e+09
C444_495	444	495	3.2326275401580426e-16
R444_512	444	512	4.7154537241293373e+09
C444_512	444	512	1.8776958348021622e-16
R445_447	445	447	1.5302090806208670e+09
C445_447	445	447	5.7862601451871530e-16
R445_449	445	449	2.4746964494082971e+09
C445_449	445	449	3.5778884392536497e-16
R445_509	445	509	1.9037058689435551e+09
C445_509	445	509	4.6510272208771162e-16
R445_510	445	510	1.6246602285679972e+09
C445_510	445	510	5.4498704783364019e-16
R445_512	445	512	2.2551636352519560e+09
C445_512	445	512	3.9261841928427394e-16
R445_515	445	515	2.3742732156542454e+09
C445_515	445	515	3.7292202761762501e-16
R446_450	446	450	4.1381023645414453e+09
C446_450	446	450	2.1396734630998325e-16
R446_453	446	453	3.8288619226365485e+09
C446_453	446	453	2.3124855364079101e-16
R446_454	446	454	2.3757450641816945e+09
C446_454	446	454	3.7269099073345858e-16
R446_456	446	456	1.3023940182177780e+10
C446_456	446	456	6.7983941058914324e-17
R446_455	446	455	2.3833416901337337e+09
C446_455	446	455	3.7150308131030828e-16
R446_518	446	518	3.4031096314700737e+09
C446_518	446	518	2.6017932937338761e-16
R447_448	447	448	8.8397448808233178e+08
C447_448	447	448	1.0016338634622833e-15
R447_449	447	449	3.4886121132167664e+09
C447_449	447	449	2.5380258766675453e-16
R447_452	447	452	3.3901292796928101e+09
C447_452	447	452	2.6117552124154706e-16
R447_508	447	508	3.8512096813724060e+09
C447_508	447	508	2.2990666698378129e-16
R447_510	447	510	2.8796382111230035e+09
C447_510	447	510	3.0747570242676556e-16
R447_515	447	515	1.3658670103190782e+09
C447_515	447	515	6.4824669972310029e-16
R447_519	447	519	3.5855411513867302e+09
C447_519	447	519	2.4694146415180843e-16
R448_450	448	450	1.4956414507675154e+09
C448_450	448	450	5.9199936003754877e-16
R448_451	448	451	2.7052282673837647e+09
C448_451	448	451	3.2729910166002059e-16
R448_452	448	452	6.6293212095569525e+09
C448_452	448	452	1.3356100175438234e-16
R448_453	448	453	3.0113878399893517e+09
C448_453	448	453	2.9402349639000038e-16
R448_508	448	508	5.4777647203873863e+09
C448_508	448	508	1.6163870244455909e-16
R448_515	448	515	4.9426953389161100e+09
C448_515	448	515	1.7913683142246123e-16
R448_517	448	517	2.6619546391877265e+09
C448_517	448	517	3.3261978572639329e-16
R448_518	448	518	3.3161847502131710e+09
C448_518	448	518	2.6699923206723736e-16
R448_519	448	519	2.3855956347111411e+09
C448_519	448	519	3.7115207993210920e-16
R449_452	449	452	1.1253064757599337e+09
C449_452	449	452	7.8682456803784517e-16
R449_464	449	464	1.1361536486690135e+09
C449_464	449	464	7.7931253641376276e-16
R449_482	449	482	1.2483723365298707e+09
C449_482	449	482	7.0925857277582647e-16
R449_495	449	495	3.1598375540026708e+09
C449_495	449	495	2.8021022174966265e-16
R449_512	449	512	6.8658580131456256e+08
C449_512	449	512	1.2895966971713433e-15
R449_513	449	513	7.4923146049442565e+08
C449_513	449	513	1.1817693575169719e-15
R449_515	449	515	1.8723026695667841e+09
C449_515	449	515	4.7290365820226566e-16
R449_516	449	516	1.3445291862632120e+09
C449_516	449	516	6.5853444517690518e-16
R449_519	449	519	2.0377121405103550e+09
C449_519	449	519	4.3451612428350280e-16
R449_520	449	520	1.4248756057119961e+09
C449_520	449	520	6.2140075817886230e-16
R450_451	450	451	3.8180575496207700e+09
C450_451	450	451	2.3190294284274068e-16
R450_453	450	453	3.2878345786006508e+09
C450_453	450	453	2.6930149937070340e-16
R450_517	450	517	4.1177249651639347e+09
C450_517	450	517	2.1502620723595364e-16
R450_518	450	518	1.0443519553325840e+09
C450_518	450	518	8.4781646376870131e-16
R450_455	450	455	4.4197927998193951e+09
C450_455	450	455	2.0033038239624734e-16
R450_521	450	521	5.0425759241634197e+09
C450_521	450	521	1.7558858706661798e-16
R451_508	451	508	1.5847209936013203e+09
C451_508	451	508	5.5872218849569396e-16
R451_507	451	507	2.3947898020676999e+09
C451_507	451	507	3.6972713886434432e-16
R451_517	451	517	1.2954148243114326e+09
C451_517	451	517	6.8350212231872329e-16
R451_521	451	521	7.5196486480650826e+09
C451_521	451	521	1.1774736069986881e-16
R452_453	452	453	2.3287011023227077e+09
C452_453	452	453	3.8022002085920771e-16
R452_482	452	482	3.1008825762677369e+09
C452_482	452	482	2.8553766868711992e-16
R452_519	452	519	2.3134878162489820e+09
C452_519	452	519	3.8272031323492794e-16
R452_520	452	520	3.0754326611564775e+09
C452_520	452	520	2.8790055880041591e-16
R452_522	452	522	5.7670286142305117e+09
C452_522	452	522	1.5353119273852265e-16
R452_523	452	523	5.1135151212048903e+09
C452_523	452	523	1.7315266714051877e-16
R453_518	453	518	1.2431842226020238e+09
C453_518	453	518	7.1221848347366463e-16
R453_454	453	454	2.6039556178633933e+09
C453_454	453	454	3.4002836900365716e-16
R453_519	453	519	3.7321663671014175e+09
C453_519	453	519	2.3723990160375930e-16
R453_522	453	522	2.8631334924342399e+09
C453_522	453	522	3.0924816605292685e-16
R453_523	453	523	6.3917994789718103e+09
C453_523	453	523	1.3852418002362445e-16
R454_456	454	456	3.7982424528379421e+09
C454_456	454	456	2.3311276009735490e-16
R454_455	454	455	2.7466079315792737e+09
C454_455	454	455	3.2236810049219250e-16
R454_518	454	518	1.9509788845050204e+09
C454_518	454	518	4.5383309308580156e-16
R454_522	454	522	2.1521206299421310e+09
C454_522	454	522	4.1141689242754407e-16
R454_523	454	523	5.0033525036870604e+09
C454_523	454	523	1.7696510110921011e-16
R454_524	454	524	2.6787424900724487e+09
C454_524	454	524	3.3053523620930554e-16
R454_526	454	526	2.6119156080969114e+09
C454_526	454	526	3.3899210945223927e-16
R455_456	455	456	4.1336827005354772e+09
C455_456	455	456	2.1419611659726640e-16
R455_518	455	518	1.2357433614229786e+09
C455_518	455	518	7.1650701054984909e-16
R455_521	455	521	3.7344889089815350e+09
C455_521	455	521	2.3709235809230733e-16
R455_526	455	526	2.4902813616368909e+09
C455_526	455	526	3.5554969624717586e-16
R455_527	455	527	1.9537624185223897e+09
C455_527	455	527	4.5318651505725711e-16
R455_528	455	528	2.8756029260335670e+09
C455_528	455	528	3.0790717789444364e-16
R456_457	456	457	1.7594881274443062e+00
C456_457	456	457	5.0322520958756886e-17
R456_526	456	526	6.3923075362446840e+00
C456_526	456	526	2.2162107197790614e-16
R456_524	456	524	1.4075905005478520e+01
C456_524	456	524	6.9193466318290839e-17
R456_528	456	528	1.4075905005478534e+01
C456_528	456	528	6.9193466318290765e-17
R457_526	457	526	4.1813251313524402e+00
C457_526	457	526	2.1175554492544643e-17
R457_524	457	524	7.5208295820803031e+00
C457_524	457	524	1.1772887180021545e-17
R457_528	457	528	1.1281244373120449e+01
C457_528	457	528	7.8485914533477000e-18
R457_525	457	525	1.8049990996992715e+01
C457_525	457	525	4.9053696583423137e-18
R457_529	457	529	5.9977755074928067e+00
C457_529	457	529	1.4762452855960983e-17
R457_530	457	530	9.0249954984963612e+00
C457_530	457	530	9.8107393166846243e-18
R458_459	458	459	1.7633023898949947e+09
C458_459	458	459	5.0213666514268553e-16
R458_483	458	483	1.2426056133113592e+09
C458_483	458	483	7.1255012227128979e-16
R458_485	458	485	3.3328315017143054e+09
C458_485	458	485	2.6566563033401720e-16
R458_499	458	499	2.0076540335565569e+09
C458_499	458	499	4.4102159381090255e-16
R458_500	458	500	4.1245129059303441e+09
C458_500	458	500	2.1467232662235563e-16
R458_501	458	501	1.2779899197648683e+09
C458_501	458	501	6.9282141275645141e-16
R458_504	458	504	1.3683717365671322e+09
C458_504	458	504	6.4706012119285066e-16
R458_533	458	533	3.7384474737828650e+09
C458_533	458	533	2.3684130589216528e-16
R459_460	459	460	3.6316498652743568e+09
C459_460	459	460	2.4380620779726799e-16
R459_483	459	483	9.5532413448980541e+09
C459_483	459	483	9.2682551370154751e-17
R459_501	459	501	1.6517437618623676e+09
C459_501	459	501	5.3605093123020268e-16
R459_533	459	533	4.1877953209942985e+09
C459_533	459	533	2.1142838028907710e-16
R459_534	459	534	6.4803810355470591e+09
C459_534	459	534	1.3663066675295507e-16
R460_501	460	501	4.5515262354350729e+09
C460_501	460	501	1.9453228123936414e-16
R460_502	460	502	2.8446749118841605e+09
C460_502	460	502	3.1125482142124494e-16
R460_532	460	532	1.1347408712716520e+10
C460_532	460	532	7.8028279769966481e-17
R460_534	460	534	3.0861694938519588e+09
C460_534	460	534	2.8689894818280933e-16
R461_462	461	462	4.0053037557763152e+09
C461_462	461	462	2.2106158126536062e-16
R461_478	461	478	1.2172545153308308e+09
C461_478	461	478	7.2739001626077916e-16
R461_476	461	476	8.3839267741224556e+09
C461_476	461	476	1.0560907860418148e-16
R461_480	461	480	4.6837230790167427e+09
C461_480	461	480	1.8904165911659247e-16
R461_539	461	539	4.2896227849233489e+09
C461_539	461	539	2.0640947376817462e-16
R461_540	461	540	4.3932139818278770e+09
C461_540	461	540	2.0154237543685621e-16
R462_480	462	480	4.0739445227838912e+09
C462_480	462	480	2.1733697568737572e-16
R462_481	462	481	3.1858592703643489e+09
C462_481	462	481	2.7792149827093267e-16
R462_540	462	540	2.2564647639276934e+09
C462_540	462	540	3.9239202661370361e-16
R462_541	462	541	1.0751113335441509e+10
C462_541	462	541	8.2356008542964454e-17
R463_480	463	480	1.1348866691702187e+09
C463_480	463	480	7.8018255545056394e-16
R463_481	463	481	5.1334882440893087e+09
C463_481	463	481	1.7247897328282965e-16
R463_495	463	495	3.1028881715495296e+09
C463_495	463	495	2.8535310741084075e-16
R463_465	463	465	2.7887924286075578e+09
C463_465	463	465	3.1749181926103018e-16
R463_542	463	542	4.6446344551953592e+09
C463_542	463	542	1.9063260849507657e-16
R463_544	463	544	4.0633373032919230e+09
C463_544	463	544	2.1790432730816511e-16
R464_482	464	482	2.3851354991169295e+09
C464_482	464	482	3.7122368185279906e-16
R464_495	464	495	2.5702764837686400e+09
C464_495	464	495	3.4448386673240868e-16
R464_465	464	465	1.5208787488460553e+09
C464_465	464	465	5.8217578644701209e-16
R464_513	464	513	1.5822677256488717e+09
C464_513	464	513	5.5958847377544724e-16
R464_545	464	545	3.7536067185793357e+09
C464_545	464	545	2.3588480309282732e-16
R465_495	465	495	1.4386989951391094e+09
C465_495	465	495	6.1543018010823585e-16
R465_513	465	513	2.2656580957054439e+09
C465_513	465	513	3.9079982252322702e-16
R465_542	465	542	9.9072588529885614e+08
C465_542	465	542	8.9370712407792810e-16
R465_544	465	544	3.0229098110544381e+09
C465_544	465	544	2.9290281121260185e-16
R465_545	465	545	1.6145298927034597e+09
C465_545	465	545	5.4840655828143575e-16
R466_472	466	472	5.6815627776047678e+09
C466_472	466	472	1.5584071079705200e-16
R466_487	466	487	4.3755894119486456e+09
C466_487	466	487	2.0235417411015340e-16
R466_489	466	489	5.6815627776047697e+09
C466_489	466	489	1.5584071079705195e-16
R466_492	466	492	5.0719079454622879e+09
C466_492	466	492	1.7457311749756077e-16
R466_493	466	493	4.7740583331494932e+09
C466_493	466	493	1.8546459215882281e-16
R466_548	466	548	1.3806197549579582e+10
C466_548	466	548	6.4131979751873251e-17
R467_468	467	468	1.4743688739013317e+09
C467_468	467	468	6.0054088049016585e-16
R467_473	467	473	2.1488681946197467e+09
C467_473	467	473	4.1203959550282217e-16
R467_474	467	474	1.2032693336917784e+09
C467_474	467	474	7.3584421783893248e-16
R467_475	467	475	1.0625036215008835e+09
C467_475	467	475	8.3333248356298792e-16
R467_477	467	477	4.1726341141980858e+09
C467_477	467	477	2.1219660230625408e-16
R467_479	467	479	1.4419403059682827e+09
C467_479	467	479	6.1404676603823007e-16
R467_486	467	486	3.5102358358274875e+09
C467_486	467	486	2.5223911529331061e-16
R467_549	467	549	2.2888366483574996e+09
C467_549	467	549	3.8684227742306937e-16
R468_474	468	474	8.1898908611633682e+08
C468_474	468	474	1.0811118203035821e-15
R468_486	468	486	9.9629711532016182e+08
C468_486	468	486	8.8870957075437179e-16
R468_491	468	491	3.4349018907865243e+09
C468_491	468	491	2.5777119983396581e-16
R468_496	468	496	7.3073509825773108e+08
C468_496	468	496	1.2116822961030287e-15
R468_497	468	497	1.3514525788204823e+09
C468_497	468	497	6.5516082145684597e-16
R468_549	468	549	2.0495553170239098e+09
C468_549	468	549	4.3200531078404205e-16
R469_470	469	470	5.5993849003900051e+08
C469_470	469	470	1.5812786537291437e-15
R469_471	469	471	8.5984537085114419e+08
C469_471	469	471	1.0297418718711498e-15
R469_475	469	475	1.2790171728719838e+09
C469_475	469	475	6.9226496757023724e-16
R469_476	469	476	1.8944290607520428e+09
C469_476	469	476	4.6738027833489317e-16
R469_477	469	477	7.5408095335143244e+08
C469_477	469	477	1.1741694015275822e-15
R469_486	469	486	1.5766197908878720e+09
C469_486	469	486	5.6159309100222397e-16
R469_553	469	553	2.0178052589681740e+09
C469_553	469	553	4.3880289129227873e-16
R470_471	470	471	3.0283884718634000e+09
C470_471	470	471	2.9237292042496526e-16
R470_472	470	472	1.2685920578158267e+09
C470_472	470	472	6.9795390586352286e-16
R470_486	470	486	1.4890520166221201e+09
C470_486	470	486	5.9461910787277380e-16
R470_477	470	477	1.9257160781646435e+09
C470_477	470	477	4.5978677321107105e-16
R470_487	470	487	1.5468248609916677e+09
C470_487	470	487	5.7241049328128792e-16
R470_492	470	492	3.0986176414671330e+09
C470_492	470	492	2.8574638246775489e-16
R470_552	470	552	8.2055265402103817e+08
C470_552	470	552	1.0790517553761988e-15
R470_553	470	553	1.1952324970822840e+09
C470_553	470	553	7.4079209179922830e-16
R471_472	471	472	7.7802338673763161e+09
C471_472	471	472	1.1380362040435487e-16
R471_476	471	476	9.2787564573770618e+09
C471_476	471	476	9.5424293736694551e-17
R471_553	471	553	8.1300592126931839e+09
C471_553	471	553	1.0890680603132952e-16
R472_487	472	487	4.6663384268627605e+09
C472_487	472	487	1.8974594225804543e-16
R472_492	472	492	3.6822264046648579e+09
C472_492	472	492	2.4045745274606148e-16
R472_553	472	553	9.6007052477754517e+09
C472_553	472	553	9.2224347987889495e-17
R473_474	473	474	1.9149122661305525e+09
C473_474	473	474	4.6238086065904139e-16
R473_479	473	479	1.6502214684049327e+09
C473_479	473	479	5.3654542656982053e-16
R473_495	473	495	2.4764539237747569e+09
C473_495	473	495	3.5753493057136832e-16
R473_498	473	498	1.9810093691098173e+09
C473_498	473	498	4.4695335393485307e-16
R473_554	473	554	5.3914299778426390e+09
C473_554	473	554	1.6422707618179939e-16
R474_479	474	479	1.3561348111861231e+09
C474_479	474	479	6.5289879324429523e-16
R474_496	474	496	1.9370717325086155e+09
C474_496	474	496	4.5709137500722976e-16
R474_497	474	497	1.4526932261071882e+09
C474_497	474	497	6.0950155599794095e-16
R474_498	474	498	9.0144983110927355e+08
C474_498	474	498	9.8221637094374179e-16
R474_549	474	549	5.2497757090883368e+08
C474_549	474	549	1.6865840195175871e-15
R474_550	474	550	6.5037044974452317e+08
C474_550	474	550	1.3614068444342879e-15
R474_554	474	554	9.9327008833850777e+08
C474_554	474	554	8.9141794572821956e-16
R475_476	475	476	1.2748584260772746e+09
C475_476	475	476	6.9452322202114931e-16
R475_477	475	477	1.3935055639896097e+09
C475_477	475	477	6.3538948431970662e-16
R475_478	475	478	9.5470872922666013e+08
C475_478	475	478	9.2742294544348957e-16
R475_479	475	479	1.0319080145779505e+09
C475_479	475	479	8.5804041561023791e-16
R475_549	475	549	3.8273492158246026e+09
C475_549	475	549	2.3133995143143385e-16
R475_556	475	556	1.3782614627755527e+09
C475_556	475	556	6.4241713609037401e-16
R476_477	476	477	1.6845061696537724e+09
C476_477	476	477	5.2562513432763868e-16
R476_478	476	478	1.1172722520393124e+09
C476_478	476	478	7.9248256643255991e-16
R476_539	476	539	2.2248237585113034e+09
C476_539	476	539	3.9797254875256298e-16
R476_553	476	553	3.0041906275557637e+09
C476_553	476	553	2.9472789561972123e-16
R476_556	476	556	1.6183852631494226e+09
C476_556	476	556	5.4710012619427253e-16
R476_557	476	557	2.3486549495347171e+09
C476_557	476	557	3.7698972421445181e-16
R477_486	477	486	1.0641012110633670e+09
C477_486	477	486	8.3208135889178459e-16
R477_549	477	549	1.1910374349327447e+09
C477_549	477	549	7.4340130354508783e-16
R477_552	477	552	8.9164101621378136e+08
C477_552	477	552	9.9302159232175848e-16
R477_553	477	553	1.0162204479758067e+09
C477_553	477	553	8.7128613035060618e-16
R477_555	477	555	9.8090967555385768e+08
C477_555	477	555	9.0265067596571530e-16
R477_556	477	556	1.2117233376283920e+09
C477_556	477	556	7.3071034798501016e-16
R477_557	477	557	2.9122659182164168e+09
C477_557	477	557	3.0403088404861893e-16
R478_479	478	479	1.7348428846479483e+09
C478_479	478	479	5.1037404570482366e-16
R478_480	478	480	1.3458817152885630e+09
C478_480	478	480	6.5787265822997105e-16
R478_539	478	539	1.1576939592158473e+09
C478_539	478	539	7.6481247453319190e-16
R478_540	478	540	3.3954603114590812e+09
C478_540	478	540	2.6076546343712734e-16
R478_556	478	556	1.5793556878018963e+09
C478_556	478	556	5.6062025073800914e-16
R478_558	478	558	1.5960786865804205e+09
C478_558	478	558	5.5474632243664585e-16
R479_480	479	480	1.5268184864086387e+09
C479_480	479	480	5.7991096491284301e-16
R479_495	479	495	2.8891021706226163e+09
C479_495	479	495	3.0646849069695156e-16
R479_549	479	549	2.9784090342555351e+09
C479_549	479	549	2.9727910824757280e-16
R479_554	479	554	8.0436206069207084e+08
C479_554	479	554	1.1007714373527121e-15
R479_556	479	556	1.7298848496161830e+09
C479_556	479	556	5.1183683231658553e-16
R479_558	479	558	1.9472304458360538e+09
C479_558	479	558	4.5470672646546507e-16
R479_559	479	559	3.1846931810274868e+09
C479_559	479	559	2.7802326044304680e-16
R480_481	480	481	1.8061714692281694e+09
C480_481	480	481	4.9021856273610929e-16
R480_495	480	495	5.4578739519183512e+09
C480_495	480	495	1.6222778127530597e-16
R480_540	480	540	3.4647058078645248e+09
C480_540	480	540	2.5555381345515415e-16
R480_542	480	542	6.2956155598806419e+09
C480_542	480	542	1.4064054154488218e-16
R480_544	480	544	6.5498671849802485e+09
C480_544	480	544	1.3518118103682895e-16
R480_558	480	558	2.2051027024382482e+09
C480_558	480	558	4.0153176571819811e-16
R480_559	480	559	3.3930130716410909e+09
C480_559	480	559	2.6095354276715227e-16
R480_560	480	560	1.9455084032074070e+09
C480_560	480	560	4.5510920448366072e-16
R481_540	481	540	3.8608858478465981e+09
C481_540	481	540	2.2933047403974416e-16
R481_541	481	541	4.0885881262845368e+09
C481_541	481	541	2.1655856602621779e-16
R481_544	481	544	4.3147500602340736e+09
C481_544	481	544	2.0520743249076313e-16
R481_543	481	543	6.3933172612196970e+09
C481_543	481	543	1.3849129419413209e-16
R481_560	481	560	2.3786837622894888e+09
C481_560	481	560	3.7223055697314814e-16
R482_513	482	513	1.0529549435225401e+09
C482_513	482	513	8.4088952442535943e-16
R482_520	482	520	1.6411616168992395e+09
C482_520	482	520	5.3950736635730209e-16
R482_523	482	523	3.7211388017730141e+09
C482_523	482	523	2.3794296017072083e-16
R482_545	482	545	1.9052368878335173e+09
C482_545	482	545	4.6472897273515800e-16
R482_562	482	562	3.0072198067750106e+09
C482_562	482	562	2.9443101555304568e-16
R482_546	482	546	2.9905786366881351e+09
C482_546	482	546	2.9606938631800761e-16
R482_564	482	564	2.5888704419171505e+09
C482_564	482	564	3.4200969170335005e-16
R483_485	483	485	1.3379188437526848e+09
C483_485	483	485	6.6178810907283264e-16
R483_494	483	494	3.5100203421103377e+09
C483_494	483	494	2.5225460122765499e-16
R483_504	483	504	1.6476788628797312e+09
C483_504	483	504	5.3737339335197222e-16
R483_533	483	533	4.1319384740855832e+09
C483_533	483	533	2.1428653578776908e-16
R483_568	483	568	6.2905604286676931e+09
C483_568	483	568	1.4075356110799293e-16
R484_485	484	485	1.6085638926036928e+09
C484_485	484	485	5.5044054250578879e-16
R484_488	484	488	1.1098474758749225e+09
C484_488	484	488	7.9778420093445796e-16
R484_491	484	491	2.9759715033894868e+09
C484_491	484	491	2.9752260083524028e-16
R484_496	484	496	2.3533344124073071e+09
C484_496	484	496	3.7624010299253419e-16
R484_500	484	500	1.4273116641239631e+09
C484_500	484	500	6.2034018494723142e-16
R484_569	484	569	5.7472294004911423e+09
C484_569	484	569	1.5406010792336470e-16
R484_570	484	570	2.2467120143024168e+09
C484_570	484	570	3.9409536071534043e-16
R485_488	485	488	2.1711359899331646e+09
C485_488	485	488	4.0781359887422647e-16
R485_494	485	494	1.3105644017830491e+09
C485_494	485	494	6.7560112306985455e-16
R485_500	485	500	9.2577836321205890e+08
C485_500	485	500	9.5640470428361713e-16
R485_504	485	504	1.8188848920014765e+09
C485_504	485	504	4.8679209200847072e-16
R485_570	485	570	2.2797774014463949e+09
C485_570	485	570	3.8837948877739118e-16
R486_487	486	487	3.0241077964107857e+09
C486_487	486	487	2.9278677921166518e-16
R486_491	486	491	1.7139391817130606e+09
C486_491	486	491	5.1659871665634895e-16
R486_496	486	496	4.4970290318701525e+09
C486_496	486	496	1.9688971883994847e-16
R486_549	486	549	1.2045819805594847e+09
C486_549	486	549	7.3504235991373114e-16
R486_551	486	551	1.5843450600200827e+09
C486_551	486	551	5.5885476216196021e-16
R486_552	486	552	2.0453273191235991e+09
C486_552	486	552	4.3289833046350380e-16
R486_571	486	571	3.3489496245096974e+09
C486_571	486	571	2.6438701114521229e-16
R487_489	487	489	1.8949308156928952e+09
C487_489	487	489	4.6725652164574692e-16
R487_491	487	491	2.5400599375543704e+09
C487_491	487	491	3.4858184588844873e-16
R487_492	487	492	3.4669311301827259e+09
C487_492	487	492	2.5538978089055201e-16
R487_493	487	493	2.4692733211996093e+09
C487_493	487	493	3.5857463574338167e-16
R487_551	487	551	2.1902946481335917e+09
C487_551	487	551	4.0424642522616264e-16
R487_552	487	552	4.9500246050190105e+09
C487_552	487	552	1.7887159203254094e-16
R487_573	487	573	5.7988141603408422e+09
C487_573	487	573	1.5268962881334296e-16
R488_490	488	490	8.2876383551729441e+08
C488_490	488	490	1.0683607847672830e-15
R488_491	488	491	1.0582790345827293e+09
C488_491	488	491	8.3665909723810531e-16
R488_494	488	494	2.0366905450614860e+09
C488_494	488	494	4.3473407575193021e-16
R488_570	488	570	1.7821259280912435e+09
C488_570	488	570	4.9683289364872949e-16
R488_573	488	573	3.8935119130657420e+09
C488_573	488	573	2.2740877682401218e-16
R489_490	489	490	7.0241054790109339e+09
C489_490	489	490	1.2605431173346732e-16
R489_491	489	491	6.5761492519250937e+09
C489_491	489	491	1.3464091944701586e-16
R489_493	489	493	5.6609362019991474e+09
C489_493	489	493	1.5640854270488271e-16
R489_573	489	573	6.5149200179804258e+09
C489_573	489	573	1.3590631646380107e-16
R490_491	490	491	5.9815595376475592e+09
C490_491	490	491	1.4802473771718398e-16
R490_494	490	494	1.5163429766068710e+10
C490_494	490	494	5.8391722411067355e-17
R490_573	490	573	7.9826708962988558e+09
C490_573	490	573	1.1091761055945852e-16
R491_496	491	496	5.6004781952511387e+09
C491_496	491	496	1.5809699651197301e-16
R491_551	491	551	4.4279423003957682e+09
C491_551	491	551	1.9996168008351455e-16
R491_570	491	570	3.1570677236959758e+09
C491_570	491	570	2.8045606214092910e-16
R491_571	491	571	3.4219672647506943e+09
C491_571	491	571	2.5874554406776498e-16
R491_573	491	573	2.7170154241887918e+09
C491_573	491	573	3.2587918854540767e-16
R491_574	491	574	8.6768926474596577e+09
C491_574	491	574	1.0204330255938166e-16
R492_493	492	493	4.6130497484724398e+09
C492_493	492	493	1.9193783505005487e-16
R492_548	492	548	4.1551465360665855e+09
C492_548	492	548	2.1308966459174988e-16
R492_551	492	551	6.5810953509349241e+09
C492_551	492	551	1.3453972849279808e-16
R492_552	492	552	3.4970232569890857e+09
C492_552	492	552	2.5319213417595051e-16
R492_553	492	553	7.3046549782446938e+09
C492_553	492	553	1.2121295041819564e-16
R492_567	492	567	4.1548016792247906e+09
C492_567	492	567	2.1310735145972186e-16
R492_575	492	575	9.7782285366476994e+09
C492_575	492	575	9.0550019196375916e-17
R493_548	493	548	6.1828260475949564e+09
C493_548	493	548	1.4320616088567089e-16
R493_551	493	551	6.6370518734720278e+09
C493_551	493	551	1.3340543340319152e-16
R493_573	493	573	6.7113924592290907e+09
C493_573	493	573	1.3192773140280704e-16
R493_575	493	575	4.6000463547080345e+09
C493_575	493	575	1.9248040420153501e-16
R494_504	494	504	4.5755362176192675e+09
C494_504	494	504	1.9351147922083308e-16
R494_568	494	568	4.1487850862178173e+09
C494_568	494	568	2.1341640101854008e-16
R494_570	494	570	1.1179346561336424e+09
C494_570	494	570	7.9201300079756508e-16
R494_573	494	573	6.6339591668111382e+09
C494_573	494	573	1.3346762610925293e-16
R494_576	494	576	6.2103630074045801e+09
C494_576	494	576	1.4257117992045235e-16
R495_498	495	498	2.8718711535236487e+09
C495_498	495	498	3.0830727925019675e-16
R495_512	495	512	1.5143961898891242e+09
C495_512	495	512	5.8466786142985849e-16
R495_513	495	513	2.2342056830255160e+09
C495_513	495	513	3.9630137387395061e-16
R495_514	495	514	2.4762523155368791e+09
C495_514	495	514	3.5756403987775027e-16
R495_542	495	542	1.6775563494346430e+09
C495_542	495	542	5.2780270659664996e-16
R495_554	495	554	3.9846686834924197e+09
C495_554	495	554	2.2220637448932446e-16
R495_559	495	559	2.1574878360463061e+09
C495_559	495	559	4.1039340612115340e-16
R495_577	495	577	2.2713506657127090e+09
C495_577	495	577	3.8982038091514666e-16
R496_497	496	497	1.3326611850447865e+09
C496_497	496	497	6.6439901727177868e-16
R496_500	496	500	3.8357916742190776e+09
C496_500	496	500	2.3083077938018129e-16
R496_503	496	503	4.8660820397568083e+09
C496_503	496	503	1.8195722440886970e-16
R496_549	496	549	5.0129537169514866e+09
C496_549	496	549	1.7662616327494192e-16
R496_550	496	550	2.4608469796146226e+09
C496_550	496	550	3.5980245380338912e-16
R496_569	496	569	1.4367672218325670e+09
C496_569	496	569	6.1625764302352814e-16
R496_570	496	570	5.2845837356867046e+09
C496_570	496	570	1.6754749777561132e-16
R496_571	496	571	1.8243154524449701e+09
C496_571	496	571	4.8534302579817051e-16
R496_578	496	578	7.3165251183753023e+09
C496_578	496	578	1.2101629767883784e-16
R497_498	497	498	1.9417320744680254e+09
C497_498	497	498	4.5599431216203064e-16
R497_500	497	500	6.8319075437825346e+09
C497_500	497	500	1.2960052167359714e-16
R497_503	497	503	1.7700622369403355e+09
C497_503	497	503	5.0021901107302443e-16
R497_509	497	509	4.8378321683763752e+09
C497_509	497	509	1.8301973918974443e-16
R497_550	497	550	4.5899575361415672e+09
C497_550	497	550	1.9290347998389225e-16
R497_578	497	578	4.2244267343768945e+09
C497_578	497	578	2.0959501427608491e-16
R498_509	498	509	1.0716314750222811e+09
C498_509	498	509	8.2623439338751291e-16
R498_512	498	512	2.1602155978338718e+09
C498_512	498	512	4.0987519143359687e-16
R498_550	498	550	9.1060885846099234e+08
C498_550	498	550	9.7233710552347830e-16
R498_554	498	554	2.3531347532798958e+09
C498_554	498	554	3.7627202626873237e-16
R498_577	498	577	9.0552596259329045e+08
C498_577	498	577	9.7779502551676537e-16
R498_578	498	578	1.2619042795033071e+09
C498_578	498	578	7.0165288768852271e-16
R499_500	499	500	1.1601917362451420e+09
C499_500	499	500	7.6316590959833913e-16
R499_501	499	501	2.1527892709861112e+09
C499_501	499	501	4.1128910926540591e-16
R499_503	499	503	2.9068747758747196e+09
C499_503	499	503	3.0459474520486187e-16
R499_504	499	504	2.6906507276658931e+09
C499_504	499	504	3.2907235881488431e-16
R499_505	499	505	6.7272867805776143e+08
C499_505	499	505	1.3161603044132106e-15
R499_511	499	511	1.4860325135707443e+09
C499_511	499	511	5.9582732787753961e-16
R499_581	499	581	2.8330989617132635e+09
C499_581	499	581	3.1252659849360136e-16
R500_503	500	503	2.4568628564399738e+09
C500_503	500	503	3.6038592035331736e-16
R500_504	500	504	1.3826097708216169e+09
C500_504	500	504	6.4039673405015744e-16
R500_511	500	511	6.1074631644754667e+09
C500_511	500	511	1.4497324958914317e-16
R500_569	500	569	1.0432385932693230e+09
C500_569	500	569	8.4872126799417598e-16
R500_570	500	570	4.7804229512320805e+09
C500_570	500	570	1.8521766603764570e-16
R500_581	500	581	5.8113696960393143e+09
C500_581	500	581	1.5235974099246331e-16
R501_502	501	502	7.3301089201702776e+09
C501_502	501	502	1.2079203615427746e-16
R501_504	501	504	3.8034352977551618e+09
C501_504	501	504	2.3279449034471177e-16
R501_505	501	505	2.4836534191329069e+09
C501_505	501	505	3.5649852547023944e-16
R501_533	501	533	2.0545338954957922e+09
C501_533	501	533	4.3095846879972455e-16
R501_534	501	534	3.8200377854199162e+09
C501_534	501	534	2.3178272871525294e-16
R501_581	501	581	2.7920954477095203e+09
C501_581	501	581	3.1711622982887216e-16
R501_582	501	582	3.0986633136445298e+09
C501_582	501	582	2.8574217076156108e-16
R502_505	502	505	6.8373585405951529e+09
C502_505	502	505	1.2949719931213811e-16
R502_506	502	506	4.0837099550500073e+09
C502_506	502	506	2.1681725476244249e-16
R502_532	502	532	2.8392134541884761e+09
C502_532	502	532	3.1185354535207940e-16
R502_534	502	534	3.4585053599906545e+09
C502_534	502	534	2.5601197324800233e-16
R502_531	502	531	4.0732649868989353e+09
C502_531	502	531	2.1737323364618332e-16
R502_582	502	582	1.6413054997783291e+09
C502_582	502	582	5.3946007115651691e-16
R502_536	502	536	5.6096048139861727e+09
C502_536	502	536	1.5783977856914726e-16
R503_509	503	509	1.2936730364336534e+09
C503_509	503	509	6.8442238244439827e-16
R503_510	503	510	3.0051509276000614e+09
C503_510	503	510	2.9463371492196661e-16
R503_511	503	511	6.2187562516406548e+08
C503_511	503	511	1.4237875643805878e-15
R503_569	503	569	1.5488387052657239e+09
C503_569	503	569	5.7166622882664500e-16
R503_578	503	578	8.3338928910495412e+08
C503_578	503	578	1.0624311990509557e-15
R503_583	503	583	3.9251694405073981e+09
C503_583	503	583	2.2557466502275216e-16
R504_533	504	533	2.9743746124611378e+09
C504_533	504	533	2.9768233563806641e-16
R504_568	504	568	2.4641807792186961e+09
C504_568	504	568	3.5931567568704714e-16
R504_570	504	570	7.4016667680405092e+09
C504_570	504	570	1.1962424268046353e-16
R504_569	504	569	3.3471185924827714e+09
C504_569	504	569	2.6453164333302832e-16
R504_581	504	581	2.2554486701662817e+09
C504_581	504	581	3.9256880168091932e-16
R504_584	504	584	4.0041343493885078e+09
C504_584	504	584	2.2112614224225941e-16
R505_506	505	506	3.3192269926658578e+09
C505_506	505	506	2.6675451352270139e-16
R505_508	505	508	1.0224858859471941e+10
C505_508	505	508	8.6594719190649745e-17
R505_511	505	511	3.2368237194983640e+09
C505_511	505	511	2.7354556763975399e-16
R505_581	505	581	5.4921262140708523e+09
C505_581	505	581	1.6121602949173912e-16
R505_582	505	582	6.3237692001021461e+09
C505_582	505	582	1.4001440496685081e-16
R505_586	505	586	6.8712534764713755e+09
C505_586	505	586	1.2885840767363061e-16
R506_508	506	508	4.7935685313487272e+09
C506_508	506	508	1.8470973678786168e-16
R506_507	506	507	6.6737493104562044e+09
C506_507	506	507	1.3267186711864588e-16
R506_531	506	531	4.7407967919076948e+09
C506_531	506	531	1.8676581607787236e-16
R506_582	506	582	7.8934995480869131e+09
C506_582	506	582	1.1217062550090248e-16
R506_586	506	586	6.1530498369891243e+09
C506_586	506	586	1.4389917279351383e-16
R507_508	507	508	3.3669410698348751e+09
C507_508	507	508	2.6297424378247990e-16
R507_517	507	517	6.0969706246221495e+09
C507_517	507	517	1.4522274031045911e-16
R507_521	507	521	1.3082601331900055e+10
C507_521	507	521	6.7679107483083862e-17
R507_585	507	585	3.1640419347660737e+09
C507_585	507	585	2.7983787824400673e-16
R507_535	507	535	1.6211223024011034e+10
C507_535	507	535	5.4617642381982778e-17
R507_531	507	531	6.1168220161707354e+09
C507_531	507	531	1.4475143781513716e-16
R507_586	507	586	1.0119904567474348e+10
C507_586	507	586	8.7492799541387029e-17
R508_510	508	510	3.5220756607119846e+09
C508_510	508	510	2.5139118718449490e-16
R508_511	508	511	9.4628089464475803e+09
C508_511	508	511	9.3568282600949444e-17
R508_515	508	515	6.2661683333378496e+09
C508_515	508	515	1.4130146759532662e-16
R508_517	508	517	2.8308832691080937e+09
C508_517	508	517	3.1277120867613967e-16
R508_585	508	585	7.7470108137523775e+09
C508_585	508	585	1.1429166719739409e-16
R508_586	508	586	4.8233903904221134e+09
C508_586	508	586	1.8356772104911742e-16
R508_587	508	587	6.2234489708514671e+09
C508_587	508	587	1.4227139739507828e-16
R509_510	509	510	2.3890848688978915e+09
C509_510	509	510	3.7061001608890195e-16
R509_511	509	511	5.9367721675439634e+09
C509_511	509	511	1.4914144533632945e-16
R509_512	509	512	1.2551272450472925e+09
C509_512	509	512	7.0544144842193880e-16
R509_515	509	515	3.6712585001133876e+09
C509_515	509	515	2.4117582068183257e-16
R509_516	509	516	4.7966195618343630e+09
C509_516	509	516	1.8459224674499528e-16
R509_577	509	577	5.5558340831624231e+09
C509_577	509	577	1.5936739082676364e-16
R509_578	509	578	8.5468173279982805e+08
C509_578	509	578	1.0359631518032814e-15
R509_579	509	579	1.5958460541732473e+09
C509_579	509	579	5.5482718986870238e-16
R509_587	509	587	3.3138748152804360e+09
C509_587	509	587	2.6718534376051000e-16
R510_511	510	511	3.1459890555132766e+09
C510_511	510	511	2.8144369420113626e-16
R510_515	510	515	1.9353036793528318e+09
C510_515	510	515	4.5750896417252998e-16
R510_587	510	587	4.7729552282692614e+09
C510_587	510	587	1.8550745593753771e-16
R511_569	511	569	4.8279221336857519e+09
C511_569	511	569	1.8339541466963345e-16
R511_578	511	578	3.6291849004124188e+09
C511_578	511	578	2.4397180248363249e-16
R511_581	511	581	9.3389376496840715e+08
C511_581	511	581	9.4809368572018811e-16
R511_583	511	583	1.9341182826256921e+09
C511_583	511	583	4.5778936565243886e-16
R511_586	511	586	2.2981245002078404e+09
C511_586	511	586	3.8527885744219842e-16
R511_587	511	587	1.3736489370005577e+09
C511_587	511	587	6.4457428521246742e-16
R511_588	511	588	3.1622438214070477e+09
C511_588	511	588	2.7999699950588594e-16
R512_513	512	513	2.2595083701893411e+09
C512_513	512	513	3.9186346613347764e-16
R512_514	512	514	2.2734727126874771e+09
C512_514	512	514	3.8945652470723721e-16
R512_515	512	515	4.3523971064968481e+09
C512_515	512	515	2.0343244424511044e-16
R512_516	512	516	1.6996430639495523e+09
C512_516	512	516	5.2094395610482161e-16
R512_577	512	577	2.9891967027800279e+09
C512_577	512	577	2.9620626199558505e-16
R512_579	512	579	1.2685857651856022e+09
C512_579	512	579	6.9795736795963305e-16
R512_591	512	591	4.7074812932530527e+09
C512_591	512	591	1.8808758368705936e-16
R513_514	513	514	1.4638624427949846e+09
C513_514	513	514	6.0485108150561653e-16
R513_516	513	516	5.0518075715207281e+09
C513_516	513	516	1.7526771737931922e-16
R513_520	513	520	2.6311214428306479e+09
C513_520	513	520	3.3651764121820124e-16
R513_542	513	542	1.8872486236212263e+09
C513_542	513	542	4.6915852560065505e-16
R513_545	513	545	2.0921595327776363e+09
C513_545	513	545	4.2320806220952094e-16
R513_562	513	562	1.5696512411094067e+09
C513_562	513	562	5.6408631325911536e-16
R513_564	513	564	4.7105876831708860e+09
C513_564	513	564	1.8796354961468186e-16
R513_591	513	591	2.2196739837217455e+09
C513_591	513	591	3.9889586857949801e-16
R514_542	514	542	1.3285234001740906e+09
C514_542	514	542	6.6646833739170425e-16
R514_559	514	559	2.2818386576054897e+09
C514_559	514	559	3.8802865344964344e-16
R514_562	514	562	2.1911369144874578e+09
C514_562	514	562	4.0409103413198335e-16
R514_563	514	563	1.0779652968602247e+09
C514_563	514	563	8.2137967175654712e-16
R514_577	514	577	1.4483608229673700e+09
C514_577	514	577	6.1132472493005809e-16
R514_579	514	579	2.3015417685407443e+09
C514_579	514	579	3.8470680558684169e-16
R514_590	514	590	9.7356969243448913e+08
C514_590	514	590	9.0945598304928693e-16
R514_591	514	591	7.3809889405117905e+08
C514_591	514	591	1.1995936978583331e-15
R515_516	515	516	9.7507192057578897e+08
C515_516	515	516	9.0805484499764106e-16
R515_517	515	517	3.2442488397057233e+09
C515_517	515	517	2.7291950323401022e-16
R515_519	515	519	1.6658034719806931e+09
C515_519	515	519	5.3152655555892749e-16
R515_587	515	587	2.5579405803475642e+09
C515_587	515	587	3.4614517182400408e-16
R515_592	515	592	4.3121218121400175e+09
C515_592	515	592	2.0533250688959197e-16
R516_519	516	519	2.8535291613383260e+09
C516_519	516	519	3.1028902514692794e-16
R516_520	516	520	2.3700996813316994e+09
C516_520	516	520	3.7357871007455079e-16
R516_579	516	579	1.6416145287768142e+09
C516_579	516	579	5.3935851942035134e-16
R516_587	516	587	4.4249708047214108e+09
C516_587	516	587	2.0009596012594364e-16
R516_591	516	591	2.9402787051280403e+09
C516_591	516	591	3.0113430409021129e-16
R516_592	516	592	1.5058980603159525e+09
C516_592	516	592	5.8796727682498658e-16
R517_518	517	518	3.0286025573588967e+09
C517_518	517	518	2.9235225320292023e-16
R517_519	517	519	2.4018991217354403e+09
C517_519	517	519	3.6863279297935703e-16
R517_521	517	521	2.1817823500741673e+09
C517_521	517	521	4.0582360640597397e-16
R517_585	517	585	1.3083644065585768e+09
C517_585	517	585	6.7673713627607673e-16
R517_587	517	587	5.0262026827566290e+09
C517_587	517	587	1.7616058037961787e-16
R517_592	517	592	3.4661480603767991e+09
C517_592	517	592	2.5544747837567781e-16
R517_594	517	594	2.2729269538930297e+09
C517_594	517	594	3.8955003819347124e-16
R518_519	518	519	1.3592775483188899e+09
C518_519	518	519	6.5138924923394571e-16
R518_521	518	521	2.7031083043934588e+09
C518_521	518	521	3.2755579207126002e-16
R518_522	518	522	8.9884321170950508e+08
C518_522	518	522	9.8506477010159168e-16
R518_526	518	526	4.1892789226166701e+09
C518_526	518	526	2.1135350451837604e-16
R518_527	518	527	2.1116379586018908e+09
C518_527	518	527	4.1930425530247294e-16
R518_594	518	594	1.6927349266675489e+09
C518_594	518	594	5.2306995487066896e-16
R519_520	519	520	1.9031137998708637e+09
C519_520	519	520	4.6524741807877195e-16
R519_522	519	522	2.1907510624896660e+09
C519_522	519	522	4.0416220576598556e-16
R519_592	519	592	3.3221790192217679e+09
C519_592	519	592	2.6651748041784108e-16
R519_594	519	594	4.1864480353805308e+09
C519_594	519	594	2.1149642231723512e-16
R519_595	519	595	6.3091459767748690e+09
C519_595	519	595	1.4033892779773842e-16
R520_522	520	522	1.7308912300811584e+09
C520_522	520	522	5.1153923846415493e-16
R520_523	520	523	2.3071526031788263e+09
C520_523	520	523	3.8377122539707954e-16
R520_564	520	564	2.1660323481425424e+09
C520_564	520	564	4.0877449612388364e-16
R520_589	520	589	1.4800944632204053e+09
C520_589	520	589	5.9821775143560536e-16
R520_591	520	591	1.3863800989715910e+09
C520_591	520	591	6.3865514396578461e-16
R520_592	520	592	2.9667299900528240e+09
C520_592	520	592	2.9844939872139655e-16
R520_595	520	595	1.6473215972590401e+09
C520_595	520	595	5.3748993710350095e-16
R521_527	521	527	1.5738843833301232e+09
C521_527	521	527	5.6256913854534566e-16
R521_528	521	528	9.7472255540126629e+09
C521_528	521	528	9.0838031478146904e-17
R521_585	521	585	3.7187115394400277e+09
C521_585	521	585	2.3809826933587016e-16
R521_535	521	535	6.2688202866704102e+09
C521_535	521	535	1.4124169161184825e-16
R521_594	521	594	2.5672468384572086e+09
C521_594	521	594	3.4489039715093940e-16
R521_597	521	597	6.3859283364246111e+09
C521_597	521	597	1.3865153742012292e-16
R521_598	521	598	1.7401068654064138e+09
C521_598	521	598	5.0883011802450682e-16
R522_523	522	523	2.2814155854509540e+09
C522_523	522	523	3.8810061057989335e-16
R522_524	522	524	8.3015903146781759e+09
C522_524	522	524	1.0665652581463538e-16
R522_526	522	526	5.3122526788569212e+09
C522_526	522	526	1.6667482426504652e-16
R522_527	522	527	6.6742104050052614e+09
C522_527	522	527	1.3266270134905971e-16
R522_589	522	589	5.1895915244650316e+09
C522_589	522	589	1.7061434941958620e-16
R522_594	522	594	3.1939818196313343e+09
C522_594	522	594	2.7721472184278111e-16
R522_595	522	595	3.3512536758843021e+09
C522_595	522	595	2.6420523998869249e-16
R522_599	522	599	3.4795227136479173e+09
C522_599	522	599	2.5446558466972344e-16
R523_524	523	524	5.6302128771903915e+09
C523_524	523	524	1.5726204337443184e-16
R523_546	523	546	9.0244809542431812e+09
C523_546	523	546	9.8112986906320525e-17
R523_564	523	564	5.3592968569908247e+09
C523_564	523	564	1.6521174425056038e-16
R523_561	523	561	4.6803780702691269e+09
C523_561	523	561	1.8917676486957126e-16
R523_589	523	589	3.7211520965864873e+09
C523_589	523	589	2.3794211005570521e-16
R523_599	523	599	7.2184823294705229e+09
C523_599	523	599	1.2265996386597040e-16
R524_526	524	526	3.4545173976063950e+00
C524_526	524	526	2.8193827003762908e-16
R524_525	524	525	1.3514125729447333e+00
C524_525	524	525	6.5518021618717742e-17
R524_529	524	529	3.8087320021554412e+00
C524_529	524	529	2.3247074910991978e-17
R524_599	524	599	5.9180873552545608e+00
C524_599	524	599	1.6457355230339371e-16
R524_561	524	561	1.6216950859119873e+01
C524_561	524	561	6.0058186483824513e-17
R525_529	525	529	6.0707000353798515e+00
C525_529	525	529	1.4585118298380858e-17
R525_599	525	599	8.8809047400218351e+00
C525_599	525	599	9.9699164400430537e-18
R525_561	525	561	1.1006503366632819e+01
C525_561	525	561	8.0445056182349873e-18
R525_600	525	600	9.6756991539985577e+00
C525_600	525	600	9.1509540303771624e-18
R525_565	525	565	2.6415608079918769e+01
C525_565	525	565	3.3518773409312437e-18
R526_527	526	527	1.5309427369439869e+09
C526_527	526	527	5.7834872613683855e-16
R526_528	526	528	3.3523498437508192e+00
C526_528	526	528	2.9053073345301899e-16
R526_529	526	529	1.0435729966983889e+00
C526_529	526	529	8.4844930302072764e-17
R526_530	526	530	3.8069865970889780e+00
C526_530	526	530	2.3257733094648607e-17
R526_599	526	599	8.1303997708829829e+00
C526_599	526	599	1.7424359053886240e-16
R526_601	526	601	5.0539461044893477e+00
C526_601	526	601	1.3431505826990629e-16
R527_528	527	528	1.9068525961314812e+09
C527_528	527	528	4.6433520005494361e-16
R527_594	527	594	1.5890438301095693e+09
C527_594	527	594	5.5720224006593196e-16
R527_597	527	597	6.3087205018748016e+09
C527_597	527	597	1.4034839258402315e-16
R527_598	527	598	2.2813777816035533e+09
C527_598	527	598	3.8810704164816127e-16
R527_599	527	599	8.8706670999729023e+09
C527_599	527	599	9.9814227241455711e-17
R527_601	527	601	1.6314280657814791e+09
C527_601	527	601	5.4272621654076480e-16
R528_530	528	530	1.6434044353673773e+00
C528_530	528	530	5.3877107950123530e-17
R528_597	528	597	1.9720853184966924e+01
C528_597	528	597	9.4284938912715700e-17
R528_601	528	601	7.9340210039697530e+00
C528_601	528	601	1.2275750951613592e-16
R529_530	529	530	2.0501040015680414e+00
C529_530	529	530	4.3188968999757042e-17
R529_599	529	599	2.0755950501334550e+00
C529_599	529	599	4.2658551418450826e-17
R529_600	529	600	4.9073715144858987e+00
C529_600	529	600	1.8042627893289986e-17
R529_601	529	601	2.8649018911443336e+00
C529_601	529	601	3.0905727851864953e-17
R529_603	529	603	2.4913144193600130e+00
C529_603	529	603	3.5540226268487334e-17
R530_597	530	597	9.3058569664247823e+00
C530_597	530	597	9.5146399186508137e-18
R530_601	530	601	2.6171361120321630e+00
C530_601	530	601	3.3831590861068632e-17
R530_602	530	602	7.4446855731398172e+00
C530_602	530	602	1.1893299898313532e-17
R530_603	530	603	5.9582751289638134e+00
C530_603	530	603	1.4860320521217367e-17
R531_582	531	582	2.6162806765553703e+09
C531_582	531	582	3.3842652649399763e-16
R531_536	531	536	1.9698065105762050e+09
C531_536	531	536	4.4949530674512723e-16
R531_585	531	585	3.1758920493762050e+09
C531_585	531	585	2.7879372722190292e-16
R531_535	531	535	3.8469292684498463e+09
C531_535	531	535	2.3016248023109278e-16
R531_586	531	586	2.6026315928986592e+09
C531_586	531	586	3.4020135009345383e-16
R531_604	531	604	3.5663491604081264e+09
C531_604	531	604	2.4827035768945138e-16
R532_534	532	534	5.8117261265602446e+09
C532_534	532	534	1.5235039683882149e-16
R532_582	532	582	7.8951836150959749e+09
C532_582	532	582	1.1214669916061690e-16
R532_536	532	536	5.1993454954039154e+09
C532_536	532	536	1.7029427693979696e-16
R532_538	532	538	2.0637724171495239e+10
C532_538	532	538	4.2902927393657964e-17
R532_605	532	605	4.7380615910437298e+09
C532_605	532	605	1.8687363274755461e-16
R533_534	533	534	2.7794803330695806e+09
C533_534	533	534	3.1855551239758841e-16
R533_568	533	568	2.9199152298659153e+09
C533_568	533	568	3.0323441332940993e-16
R533_581	533	581	2.1492525879096799e+09
C533_581	533	581	4.1196590232381237e-16
R533_582	533	582	4.0067157915895047e+09
C533_582	533	582	2.2098367534792012e-16
R533_584	533	584	3.8076776299762115e+09
C533_584	533	584	2.3253512186259622e-16
R533_593	533	593	2.1460804129529054e+09
C533_593	533	593	4.1257483939369525e-16
R533_606	533	606	3.0379650400492349e+09
C533_606	533	606	2.9145127413502112e-16
R534_582	534	582	1.4738962203178720e+09
C534_582	534	582	6.0073346379098790e-16
R534_605	534	605	5.4877113809066839e+09
C534_605	534	605	1.6134572688728222e-16
R534_606	534	606	4.3274325926400719e+09
C534_606	534	606	2.0460602510733174e-16
R535_585	535	585	1.7791831170207968e+09
C535_585	535	585	4.9765466703765401e-16
R535_598	535	598	4.1212045125751147e+09
C535_598	535	598	2.1484465985570571e-16
R535_597	535	597	6.0599721396113777e+09
C535_597	535	597	1.4610938157824294e-16
R535_596	535	596	1.4219878072120955e+09
C535_596	535	596	6.2266271005229226e-16
R535_604	535	604	4.1807887909409213e+09
C535_604	535	604	2.1178271038674719e-16
R535_536	535	536	4.5527716441935711e+09
C535_536	535	536	1.9447906701607340e-16
R535_607	535	607	5.6664256444373045e+09
C535_607	535	607	1.5625701937326406e-16
R535_537	535	537	6.6624056573151655e+09
C535_537	535	537	1.3289775904411211e-16
R535_608	535	608	3.2230754277013078e+09
C535_608	535	608	2.7471239862713338e-16
R536_582	536	582	8.4808080343910246e+09
C536_582	536	582	1.0440264395909991e-16
R536_604	536	604	6.7448345397550211e+09
C536_604	536	604	1.3127361041715921e-16
R536_538	536	538	8.0135427828856544e+09
C536_538	536	538	1.1049030443700496e-16
R536_605	536	605	5.2603165603847122e+09
C536_605	536	605	1.6832043690451305e-16
R536_537	536	537	6.3220257581066027e+09
C536_537	536	537	1.4005301711475088e-16
R536_608	536	608	6.8253749198357582e+09
C536_608	536	608	1.2972456342681116e-16
R536_609	536	609	1.1941516834361048e+10
C536_609	536	609	7.4146257463060050e-17
R537_608	537	608	4.4000209025020266e+09
C537_608	537	608	2.0123058533574602e-16
R537_607	537	607	1.6831192404125601e+10
C537_607	537	607	5.2605826161369856e-17
R537_538	537	538	1.1304093313459698e+10
C537_538	537	538	7.8327271117422464e-17
R537_609	537	609	1.0029108458857389e+10
C537_609	537	609	8.8284894448222496e-17
R537_610	537	610	1.4519243434532492e+10
C537_610	537	610	6.0982432431301814e-17
R538_605	538	605	8.8655249498070126e+09
C538_605	538	605	9.9872121133591096e-17
R538_609	538	609	3.4786398901804805e+09
C538_609	538	609	2.5453016398718477e-16
R538_610	538	610	1.9766159781796322e+10
C538_610	538	610	4.4794678960119911e-17
R539_540	539	540	1.8234640241572349e+09
C539_540	539	540	4.8556964654634268e-16
R539_556	539	556	2.3010148859609389e+09
C539_556	539	556	3.8479489511439459e-16
R539_557	539	557	1.8532911742957346e+09
C539_557	539	557	4.7775481477510753e-16
R539_558	539	558	1.4944583041810029e+09
C539_558	539	558	5.9246803957185669e-16
R539_612	539	612	3.4067511138936749e+09
C539_612	539	612	2.5990122321792665e-16
R540_541	540	541	4.0606150346957955e+09
C540_541	540	541	2.1805041210126238e-16
R540_558	540	558	3.7860727966397395e+09
C540_558	540	558	2.3386205951608683e-16
R540_560	540	560	2.7151479477110796e+09
C540_560	540	560	3.2610332797755076e-16
R540_612	540	612	4.7176758366322308e+09
C540_612	540	612	1.8768114053636775e-16
R540_613	540	613	7.7646889972136202e+09
C540_613	540	613	1.1403145470703785e-16
R541_543	541	543	4.6566380999356642e+09
C541_543	541	543	1.9014120545726608e-16
R541_560	541	560	6.3928429149709005e+09
C541_560	541	560	1.3850157018976749e-16
R541_613	541	613	3.8869696504756227e+09
C541_613	541	613	2.2779153461917495e-16
R541_547	541	547	1.7204931486850239e+10
C541_547	541	547	5.1463080941457236e-17
R542_544	542	544	1.0945301012705793e+09
C542_544	542	544	8.0894877232902651e-16
R542_545	542	545	1.3764017301557782e+09
C542_545	542	545	6.4328514146795668e-16
R542_559	542	559	1.9785399529849870e+09
C542_559	542	559	4.4751119650840769e-16
R542_560	542	560	3.6245102770897164e+09
C542_560	542	560	2.4428645913812747e-16
R542_562	542	562	1.0472836889676275e+09
C542_562	542	562	8.4544311252743009e-16
R542_563	542	563	1.3878166659421592e+09
C542_563	542	563	6.3799405456693242e-16
R542_616	542	616	3.9760896377864900e+09
C542_616	542	616	2.2268582007947822e-16
R542_617	542	617	5.1919875887412577e+09
C542_617	542	617	1.7053561214591816e-16
R543_544	543	544	7.7198354944355659e+09
C543_544	543	544	1.1469399604929497e-16
R543_560	543	560	5.0353854603008757e+09
C543_560	543	560	1.7583932524742493e-16
R543_613	543	613	8.0800384469849443e+09
C543_613	543	613	1.0958101097036151e-16
R543_547	543	547	8.6859717009686947e+09
C543_547	543	547	1.0193664130879614e-16
R543_614	543	614	5.2634386555226545e+09
C543_614	543	614	1.6822059487118295e-16
R543_615	543	615	1.0016752701866081e+10
C543_615	543	615	8.8393794681089617e-17
R543_616	543	616	9.7926019262940388e+09
C543_616	543	616	9.0417111648597598e-17
R543_617	543	617	1.1578574747781973e+10
C543_617	543	617	7.6470446578030989e-17
R544_545	544	545	5.8429309866587687e+09
C544_545	544	545	1.5153675162716913e-16
R544_560	544	560	3.1200292002358871e+09
C544_560	544	560	2.8378541509581348e-16
R544_616	544	616	5.8506929525940132e+09
C544_616	544	616	1.5133571166257038e-16
R544_617	544	617	4.8042488374166460e+09
C544_617	544	617	1.8429910932259495e-16
R545_562	545	562	1.4562771227371683e+09
C545_562	545	562	6.0800157324163509e-16
R545_546	545	546	6.0704033784622307e+09
C545_546	545	546	1.4585831064233105e-16
R545_617	545	617	6.2056230211652784e+09
C545_617	545	617	1.4268007880596943e-16
R546_562	546	562	1.8892760516117868e+09
C546_562	546	562	4.6865506019865550e-16
R546_564	546	564	5.9695542114595973e+08
C546_564	546	564	1.4832242916904659e-15
R546_561	546	561	4.8584727839594116e+09
C546_561	546	561	1.8224220265744251e-16
R546_617	546	617	4.4693944594015875e+09
C546_617	546	617	1.9810710147489414e-16
R546_619	546	619	5.6040292571174154e+09
C546_619	546	619	1.5799681641124034e-16
R547_613	547	613	2.6017833891501880e+09
C547_613	547	613	3.4031225865778235e-16
R547_614	547	614	2.4476545751679740e+09
C547_614	547	614	3.6174172233401718e-16
R547_615	547	615	1.7051032191522837e+09
C547_615	547	615	5.1927576685955637e-16
R547_618	547	618	1.5781207151086090e+09
C547_618	547	618	5.6105896920506760e-16
R547_622	547	622	9.2617042213944187e+09
C547_622	547	622	9.5599984682591577e-17
R548_575	548	575	4.3887015863956470e+09
C548_575	548	575	2.0174959820569088e-16
R548_567	548	567	6.6550780796128464e+09
C548_567	548	567	1.3304408620124084e-16
R548_625	548	625	1.3844676541505224e+10
C548_625	548	625	6.3953735505888205e-17
R549_550	549	550	4.0179271127996259e+09
C549_550	549	550	2.2036705914335386e-16
R549_552	549	552	1.3850041913962608e+10
C549_552	549	552	6.3928960446494028e-17
R549_551	549	551	9.1372165989877338e+09
C549_551	549	551	9.6902461718822706e-17
R549_554	549	554	4.2934945466728458e+09
C549_554	549	554	2.0622333907146500e-16
R549_555	549	555	3.5671438944431515e+09
C549_555	549	555	2.4821504483721374e-16
R549_556	549	556	6.9477463226227264e+09
C549_556	549	556	1.2743971074720541e-16
R549_571	549	571	8.1554715158053637e+09
C549_571	549	571	1.0856745437514583e-16
R549_572	549	572	3.5578353010002542e+09
C549_572	549	572	2.4886446583153310e-16
R549_626	549	626	7.9405935571465645e+09
C549_626	549	626	1.1150536484808741e-16
R550_554	550	554	2.1314132026714308e+09
C550_554	550	554	4.1541395192178148e-16
R550_571	550	571	3.3225024035238528e+09
C550_571	550	571	2.6649153985890975e-16
R550_569	550	569	4.5295599937790222e+09
C550_569	550	569	1.9547567156987650e-16
R550_572	550	572	2.4855958653599229e+09
C550_572	550	572	3.5621992860524344e-16
R550_577	550	577	1.5840136586464489e+09
C550_577	550	577	5.5897168365113520e-16
R550_578	550	578	1.3368759080534728e+09
C550_578	550	578	6.6230438918537601e-16
R550_580	550	580	1.5021929863998442e+09
C550_580	550	580	5.8941746481056007e-16
R550_626	550	626	2.4928214554289346e+09
C550_626	550	626	3.5518740412463589e-16
R551_552	551	552	8.7336978690809238e+08
C551_552	551	552	1.0137959830675655e-15
R551_555	551	555	4.4669109285366278e+09
C551_555	551	555	1.9821724584735908e-16
R551_567	551	567	4.2572442821990161e+09
C551_567	551	567	2.0797932254022545e-16
R551_571	551	571	2.5040404894556761e+09
C551_571	551	571	3.5359603226402724e-16
R551_572	551	572	2.4891374210735002e+09
C551_572	551	572	3.5571309731792218e-16
R551_573	551	573	3.7062949480057044e+09
C551_573	551	573	2.3889593087469443e-16
R551_574	551	574	1.1394345430418680e+09
C551_574	551	574	7.7706857941682164e-16
R551_575	551	575	2.7281713078492317e+09
C551_575	551	575	3.2454662181680384e-16
R551_627	551	627	2.6707106418607969e+09
C551_627	551	627	3.3152928206520010e-16
R551_629	551	629	3.7107052479415817e+09
C551_629	551	629	2.3861199490074378e-16
R552_553	552	553	8.6674241575274992e+08
C552_553	552	553	1.0215477696808342e-15
R552_555	552	555	1.7502760692400539e+09
C552_555	552	555	5.0587378600476255e-16
R552_567	552	567	2.2549479213737817e+09
C552_567	552	567	3.9265597813034038e-16
R552_629	552	629	3.3876083018094602e+09
C552_629	552	629	2.6136988188010459e-16
R552_630	552	630	4.7974612489119987e+09
C552_630	552	630	1.8455986109336505e-16
R553_555	553	555	4.2266765267638607e+09
C553_555	553	555	2.0948345019861683e-16
R553_557	553	557	5.8766349722427788e+09
C553_557	553	557	1.5066765008922889e-16
R553_567	553	567	7.7429785190852127e+09
C553_567	553	567	1.1435118662896758e-16
R553_630	553	630	5.9014737378384466e+09
C553_630	553	630	1.5003350366925560e-16
R554_556	554	556	2.1118777885103521e+09
C554_556	554	556	4.1925663810524983e-16
R554_555	554	555	5.2251894031192961e+09
C554_555	554	555	1.6945199750489987e-16
R554_558	554	558	2.3017010952400384e+09
C554_558	554	558	3.8468017568878211e-16
R554_559	554	559	1.5797168133990400e+09
C554_559	554	559	5.6049209212052712e-16
R554_566	554	566	2.3420052949418654e+09
C554_566	554	566	3.7806011097083303e-16
R554_577	554	577	1.7598981570919597e+09
C554_577	554	577	5.0310796572629997e-16
R554_590	554	590	4.9525109593389168e+09
C554_590	554	590	1.7878179149313577e-16
R554_626	554	626	1.7434753288350306e+09
C554_626	554	626	5.0784703807172684e-16
R554_631	554	631	3.2295760642840524e+09
C554_631	554	631	2.7415944510236634e-16
R555_556	555	556	8.8797975909101677e+08
C555_556	555	556	9.9711595071306760e-16
R555_557	555	557	1.3616704274316761e+09
C555_557	555	557	6.5024455540981271e-16
R555_572	555	572	1.5430283736670027e+09
C555_572	555	572	5.7381885959478802e-16
R555_626	555	626	1.3865510326767049e+09
C555_626	555	626	6.3857641070067175e-16
R555_628	555	628	1.6553440883998725e+09
C555_628	555	628	5.3488503562777956e-16
R555_629	555	629	6.9982741781073606e+08
C555_629	555	629	1.2651959028267968e-15
R555_630	555	630	9.9223570646526623e+08
C555_630	555	630	8.9234722750928795e-16
R555_631	555	631	6.9592300499274552e+08
C555_631	555	631	1.2722941695385251e-15
R556_557	556	557	1.7066113739060717e+09
C556_557	556	557	5.1881687608436839e-16
R556_558	556	558	1.5589162266411924e+09
C556_558	556	558	5.6797072643711229e-16
R556_631	556	631	3.4818698698418460e+09
C556_631	556	631	2.5429404739362575e-16
R557_558	557	558	2.7463914033378892e+09
C557_558	557	558	3.2239351631522229e-16
R557_612	557	612	2.8395757166351347e+09
C557_612	557	612	3.1181376024345337e-16
R557_630	557	630	1.9807309836293049e+09
C557_630	557	630	4.4701617181634742e-16
R557_631	557	631	1.5422973177010057e+09
C557_631	557	631	5.7409085235253564e-16
R557_632	557	632	5.1500913862974787e+09
C557_632	557	632	1.7192292627190611e-16
R558_559	558	559	9.5932300169907820e+08
C558_559	558	559	9.2296210987520923e-16
R558_560	558	560	1.0039742588935684e+09
C558_560	558	560	8.8191382782640014e-16
R558_566	558	566	2.6944329749575057e+09
C558_566	558	566	3.2861043118504889e-16
R558_612	558	612	1.3462010716760476e+09
C558_612	558	612	6.5771659251291167e-16
R558_631	558	631	1.3859838293894815e+09
C558_631	558	631	6.3883774321524535e-16
R558_633	558	633	2.0452324811314814e+09
C558_633	558	633	4.3291840407803463e-16
R559_560	559	560	1.3997854462201684e+09
C559_560	559	560	6.3253892522664153e-16
R559_563	559	563	1.2567836386169810e+09
C559_563	559	563	7.0451170312366039e-16
R559_566	559	566	1.0040882998326284e+09
C559_566	559	566	8.8181366304894755e-16
R559_577	559	577	2.1311995151581547e+09
C559_577	559	577	4.1545560394625642e-16
R559_590	559	590	1.5349962382208760e+09
C559_590	559	590	5.7682146682407302e-16
R559_633	559	633	2.2713909459639163e+09
C559_633	559	633	3.8981346794276868e-16
R560_563	560	563	3.3986284317584491e+09
C560_563	560	563	2.6052238409654118e-16
R560_612	560	612	2.1861907167873278e+09
C560_612	560	612	4.0500527922886313e-16
R560_613	560	613	1.5628925455813246e+09
C560_613	560	613	5.6652569250732767e-16
R560_614	560	614	3.1776647774593596e+09
C560_614	560	614	2.7863819619384756e-16
R560_616	560	616	1.2901409133553388e+09
C560_616	560	616	6.8629618093208435e-16
R560_633	560	633	1.4407696618639252e+09
C560_633	560	633	6.1454568702851015e-16
R560_634	560	634	2.0385895002518585e+09
C560_634	560	634	4.3432911902597891e-16
R561_564	561	564	2.9105475089856534e+09
C561_564	561	564	3.0421038617870719e-16
R561_589	561	589	3.0668791465987964e+09
C561_589	561	589	2.8870351239041800e-16
R561_599	561	599	4.3501581549106421e+00
C561_599	561	599	2.2389086194408619e-16
R561_600	561	600	3.8593188386295019e+00
C561_600	561	600	2.2942358968569294e-17
R561_565	561	565	9.8610193728128426e-01
C561_565	561	565	8.9789782194438121e-17
R561_619	561	619	1.1833223223708975e+01
C561_619	561	619	1.5713211884026658e-16
R561_636	561	636	3.7138404725179890e+00
C561_636	561	636	2.6225161422609321e-16
R562_563	562	563	1.0262302056174874e+09
C562_563	562	563	8.6278768336120013e-16
R562_564	562	564	4.6211711095968097e+08
C562_564	562	564	1.9160051872159559e-15
R562_591	562	591	1.7136106648704436e+09
C562_591	562	591	5.1669775395973130e-16
R562_616	562	616	3.5038870349565787e+09
C562_616	562	616	2.5269615511761852e-16
R562_617	562	617	1.5882583689298496e+09
C562_617	562	617	5.5747780022502587e-16
R562_637	562	637	1.0230725981947037e+09
C562_637	562	637	8.6545058802512625e-16
R563_590	563	590	1.5224047793102629e+09
C563_590	563	590	5.8159222417913436e-16
R563_566	563	566	3.2260041247886395e+09
C563_566	563	566	2.7446300359520170e-16
R563_591	563	591	3.0617587916848569e+09
C563_591	563	591	2.8918632784026804e-16
R563_616	563	616	1.8737951580020514e+09
C563_616	563	616	4.7252698776534605e-16
R563_633	563	633	3.2204546074049888e+09
C563_633	563	633	2.7493596080010018e-16
R563_635	563	635	1.3486534750896943e+09
C563_635	563	635	6.5652059484080132e-16
R563_637	563	637	2.7260496453422465e+09
C563_637	563	637	3.2479921384147741e-16
R564_589	564	589	1.0290095624743795e+09
C564_589	564	589	8.6045729212749227e-16
R564_591	564	591	2.0236555827342851e+09
C564_591	564	591	4.3753432612463456e-16
R564_617	564	617	4.2424406151480465e+09
C564_617	564	617	2.0870505023418036e-16
R564_619	564	619	3.2160411132326846e+09
C564_619	564	619	2.7531326575921762e-16
R564_636	564	636	2.0615402862050924e+09
C564_636	564	636	4.2949380500823946e-16
R564_637	564	637	1.0393482667776707e+09
C564_637	564	637	8.5189806920551891e-16
R564_638	564	638	2.1583471089463563e+09
C564_638	564	638	4.1023002186716682e-16
R565_600	565	600	4.1890505911316795e+00
C565_600	565	600	2.1136502470857066e-17
R565_636	565	636	3.5498658023115919e+00
C565_636	565	636	2.4942317005995983e-17
R565_619	565	619	4.9653509720792046e+00
C565_619	565	619	1.7831947563804080e-17
R565_620	565	620	1.1916842332990093e+01
C565_620	565	620	7.4299781515850322e-18
R565_639	565	639	3.5126730713418470e+00
C565_639	565	639	2.5206410153102254e-17
R566_590	566	590	6.2232500755195510e+08
C566_590	566	590	1.4227594439487158e-15
R566_626	566	626	1.9613186736341398e+09
C566_626	566	626	4.5144055048402809e-16
R566_631	566	631	1.9411661996088800e+09
C566_631	566	631	4.5612724035602957e-16
R566_633	566	633	7.7528878855835688e+08
C566_633	566	633	1.1420502847028509e-15
R566_635	566	635	2.7670866172192512e+09
C566_635	566	635	3.1998231504216176e-16
R566_640	566	640	1.0692984613167272e+09
C566_640	566	640	8.2803708574470528e-16
R567_575	567	575	2.1772336212725697e+09
C567_575	567	575	4.0667146283662582e-16
R567_625	567	625	1.5254376326408930e+09
C567_625	567	625	5.8043591081933053e-16
R567_627	567	627	2.5223209819966750e+09
C567_627	567	627	3.5103334905421134e-16
R567_629	567	629	8.4805423149367428e+08
C567_629	567	629	1.0440591519017782e-15
R567_630	567	630	2.9397069598821697e+09
C567_630	567	630	3.0119287186893272e-16
R567_641	567	641	4.6751968074404898e+09
C567_641	567	641	1.8938641904676021e-16
R568_570	568	570	2.1774253235179772e+09
C568_570	568	570	4.0663565915981228e-16
R568_569	568	569	2.2372763183138952e+09
C568_569	568	569	3.9575745492505310e-16
R568_576	568	576	7.4112351430291986e+08
C568_576	568	576	1.1946980019016133e-15
R568_584	568	584	6.2547820646591759e+08
C568_584	568	584	1.4155869421938789e-15
R568_593	568	593	1.0819419201121321e+09
C568_593	568	593	8.1836073197740205e-16
R568_642	568	642	1.5061448949026909e+09
C568_642	568	642	5.8787091779586411e-16
R568_643	568	643	1.9758395350088129e+09
C568_643	568	643	4.4812281868631137e-16
R569_570	569	570	7.3135524278531349e+08
C569_570	569	570	1.2106548636035570e-15
R569_571	569	571	1.3988892080782969e+09
C569_571	569	571	6.3294417927230325e-16
R569_576	569	576	2.9350271579218197e+09
C569_576	569	576	3.0167311375985057e-16
R569_578	569	578	2.4918749321766076e+09
C569_578	569	578	3.5532231985920849e-16
R569_580	569	580	1.7091185046669691e+09
C569_580	569	580	5.1805581607258335e-16
R569_581	569	581	1.8448461895239522e+09
C569_581	569	581	4.7994178958001661e-16
R569_583	569	583	1.3828077646214030e+09
C569_583	569	583	6.4030504047857849e-16
R569_584	569	584	7.8491095573228180e+08
C569_584	569	584	1.1280499720811634e-15
R569_644	569	644	2.4498331783898463e+09
C569_644	569	644	3.6142003035567580e-16
R570_571	570	571	1.4773338797764893e+09
C570_571	570	571	5.9933559625259397e-16
R570_573	570	573	2.7945804225539007e+09
C570_573	570	573	3.1683424622678667e-16
R570_574	570	574	4.3610128416763086e+09
C570_574	570	574	2.0303053759402785e-16
R570_576	570	576	1.7316536085394135e+09
C570_576	570	576	5.1131402800980420e-16
R570_644	570	644	5.1571229216400309e+09
C570_644	570	644	1.7168851608804114e-16
R571_572	571	572	1.2588198269110861e+09
C571_572	571	572	7.0337212901440866e-16
R571_574	571	574	2.5027964099943795e+09
C571_574	571	574	3.5377179628525538e-16
R571_580	571	580	5.6818128805266075e+09
C571_580	571	580	1.5583385097643991e-16
R571_644	571	644	2.6654719496528940e+09
C571_644	571	644	3.3218086643729342e-16
R572_574	572	574	2.7824705373918886e+09
C572_574	572	574	3.1821317415635085e-16
R572_580	572	580	1.7435697749695785e+09
C572_580	572	580	5.0781952888317808e-16
R572_626	572	626	1.4709509410545142e+09
C572_626	572	626	6.0193631003441203e-16
R572_627	572	627	2.7023502165273538e+09
C572_627	572	627	3.2764768100183721e-16
R572_628	572	628	1.5030280637618611e+09
C572_628	572	628	5.8908998643972438e-16
R572_629	572	629	4.7080508011729479e+09
C572_629	572	629	1.8806483173023748e-16
R572_644	572	644	1.5126751377395611e+09
C572_644	572	644	5.8533306961275896e-16
R573_574	573	574	1.7451368861034336e+09
C573_574	573	574	5.0736351328690087e-16
R573_575	573	575	4.8495662693036737e+09
C573_575	573	575	1.8257690121783471e-16
R573_576	573	576	6.0082614396223869e+09
C573_576	573	576	1.4736688651079198e-16
R573_649	573	649	8.3068461863430490e+09
C573_649	573	649	1.0658904256054258e-16
R574_575	574	575	1.4563084903487556e+09
C574_575	574	575	6.0798847741934176e-16
R574_576	574	576	4.3144653815771017e+09
C574_576	574	576	2.0522097256377697e-16
R574_627	574	627	7.4710393791628468e+08
C574_627	574	627	1.1851346737235561e-15
R574_644	574	644	1.5287190163034849e+09
C574_644	574	644	5.7919000958134506e-16
R574_649	574	649	1.0801487618250074e+09
C574_649	574	649	8.1971929514968494e-16
R575_625	575	625	2.9653838681724057e+09
C575_625	575	625	2.9858487840418855e-16
R575_627	575	627	1.0184775690228151e+09
C575_627	575	627	8.6935521078733334e-16
R575_648	575	648	4.4876739393304329e+09
C575_648	575	648	1.9730015898439039e-16
R575_649	575	649	2.9341014729034328e+09
C575_649	575	649	3.0176828916003233e-16
R576_584	576	584	4.8008547634884281e+09
C576_584	576	584	1.8442940378738543e-16
R576_642	576	642	3.0433984829906955e+09
C576_642	576	642	2.9093094008179778e-16
R576_643	576	643	5.9923997104816132e+09
C576_643	576	643	1.4775696289939886e-16
R576_644	576	644	2.1472697387989290e+09
C576_644	576	644	4.1234632319424262e-16
R576_649	576	649	5.2898376981436520e+09
C576_649	576	649	1.6738108657109045e-16
R576_650	576	650	3.5558506887957397e+09
C576_650	576	650	2.4900336352420502e-16
R577_578	577	578	3.1491189057362981e+09
C577_578	577	578	2.8116397259155879e-16
R577_579	577	579	3.3759186237627716e+09
C577_579	577	579	2.6227491843779091e-16
R577_580	577	580	6.9987315257920990e+09
C577_580	577	580	1.2651132257852836e-16
R577_590	577	590	1.5226131884817178e+09
C577_590	577	590	5.8151261817382554e-16
R577_626	577	626	7.7230264683364267e+09
C577_626	577	626	1.1464660717273483e-16
R577_651	577	651	9.0089659333847065e+09
C577_651	577	651	9.8281954693477714e-17
R578_579	578	579	1.5265109717942028e+09
C578_579	578	579	5.8002778758891762e-16
R578_580	578	580	2.5982632477786641e+09
C578_580	578	580	3.4077331558184946e-16
R578_583	578	583	1.9875757624498832e+09
C578_583	578	583	4.4547674530335083e-16
R578_587	578	587	2.6180685773707800e+09
C578_587	578	587	3.3819541220314024e-16
R578_651	578	651	2.0016143106509273e+09
C578_651	578	651	4.4235234379997054e-16
R579_587	579	587	3.3628271756363873e+09
C579_587	579	587	2.6329595172622621e-16
R579_590	579	590	7.2627495032822142e+09
C579_590	579	590	1.2191233930068187e-16
R579_591	579	591	2.9214268656767802e+09
C579_591	579	591	3.0307751054890198e-16
R579_592	579	592	5.4131207279047079e+09
C579_592	579	592	1.6356900690126024e-16
R579_651	579	651	2.0625892446198084e+09
C579_651	579	651	4.2927537996699237e-16
R580_583	580	583	2.4301238848270564e+09
C580_583	580	583	3.6435129386953556e-16
R580_584	580	584	7.6073468695330963e+09
C580_584	580	584	1.1638995787690996e-16
R580_626	580	626	2.8522420233847475e+09
C580_626	580	626	3.1042905000371467e-16
R580_590	580	590	1.0599548806358961e+10
C580_590	580	590	8.3533629390791872e-17
R580_628	580	628	9.3882437016250668e+09
C580_628	580	628	9.4311439907204132e-17
R580_642	580	642	6.2333160073565054e+09
C580_642	580	642	1.4204618868272306e-16
R580_644	580	644	2.3718596857911134e+09
C580_644	580	644	3.7330150135111234e-16
R580_645	580	645	4.8440363570643339e+09
C580_645	580	645	1.8278532951321539e-16
R580_646	580	646	2.4828508242189598e+09
C580_646	580	646	3.5661376554047696e-16
R580_651	580	651	4.7520590165161972e+09
C580_651	580	651	1.8632318719583437e-16
R580_652	580	652	3.4580707631170802e+09
C580_652	580	652	2.5604414783631838e-16
R580_655	580	655	4.9740162805708323e+09
C580_655	580	655	1.7800882260047344e-16
R581_582	581	582	3.2513482188922992e+09
C581_582	581	582	2.7232357843284252e-16
R581_583	581	583	2.7851323305302606e+09
C581_583	581	583	3.1790905300769870e-16
R581_584	581	584	2.2327191919072165e+09
C581_584	581	584	3.9656522186458400e-16
R581_586	581	586	7.5212585620027781e+09
C581_586	581	586	1.1772215705668130e-16
R581_588	581	588	4.4266291673004217e+09
C581_588	581	588	2.0002099752122954e-16
R581_593	581	593	7.2648342859167299e+09
C581_593	581	593	1.2187735423180010e-16
R581_606	581	606	9.6007375197729664e+09
C581_606	581	606	9.2224037984212917e-17
R581_656	581	656	4.5831019261523714e+09
C581_656	581	656	1.9319203368521437e-16
R582_586	582	586	3.9933937681998882e+09
C582_586	582	586	2.2172088030755914e-16
R582_588	582	588	1.1270655366394545e+10
C582_588	582	588	7.8559653624050383e-17
R582_604	582	604	5.1911239661380816e+09
C582_604	582	604	1.7056398334457507e-16
R582_605	582	605	8.2328876033467941e+09
C582_605	582	605	1.0754656499137240e-16
R582_606	582	606	5.7020467926729956e+09
C582_606	582	606	1.5528086911488413e-16
R582_656	582	656	9.6328874399418373e+09
C582_656	582	656	9.1916238741532130e-17
R583_584	583	584	1.9024358453575022e+09
C583_584	583	584	4.6541321425407316e-16
R583_587	583	587	6.4118360298546305e+09
C583_587	583	587	1.3809130139593952e-16
R583_588	583	588	2.2756014179718986e+09
C583_588	583	588	3.8909220863868080e-16
R583_642	583	642	4.7222634994122391e+09
C583_642	583	642	1.8749880895257214e-16
R583_646	583	646	6.6590614335598936e+09
C583_646	583	646	1.3296450115893594e-16
R583_651	583	651	3.5572627040994639e+09
C583_651	583	651	2.4890452444786406e-16
R583_654	583	654	3.3979322941622872e+09
C583_654	583	654	2.6057575756325877e-16
R583_655	583	655	2.0467690505685809e+09
C583_655	583	655	4.3259339956016801e-16
R583_656	583	656	4.6538273092008286e+09
C583_656	583	656	1.9025604580330831e-16
R584_593	584	593	1.9522239645480204e+09
C584_593	584	593	4.5354364959093855e-16
R584_642	584	642	7.5960232530894172e+08
C584_642	584	642	1.1656346382824551e-15
R584_644	584	644	6.6951397637570276e+09
C584_644	584	644	1.3224799077280810e-16
R584_654	584	654	2.9107017673998532e+09
C584_654	584	654	3.0419426394582150e-16
R584_656	584	656	6.8983049283166285e+09
C584_656	584	656	1.2835309411526202e-16
R585_586	585	586	1.7385218075744894e+09
C585_586	585	586	5.0929403234538553e-16
R585_587	585	587	4.3990781876191072e+09
C585_587	585	587	2.0127370870377984e-16
R585_592	585	592	5.8171651047327662e+09
C585_592	585	592	1.5220795108250159e-16
R585_594	585	594	3.7979836266074843e+09
C585_594	585	594	2.3312864634197827e-16
R585_598	585	598	3.1993399189114318e+09
C585_598	585	598	2.7675045607572133e-16
R585_596	585	596	2.2421105291878114e+09
C585_596	585	596	3.9490416291864824e-16
R585_604	585	604	3.7797850936679802e+09
C585_604	585	604	2.3425109093722884e-16
R585_657	585	657	1.4099505172422817e+09
C585_657	585	657	6.2797862114465438e-16
R586_587	586	587	2.7240288529898949e+09
C586_587	586	587	3.2504016274576688e-16
R586_588	586	588	1.5529119478206568e+09
C586_588	586	588	5.7016676505231957e-16
R586_604	586	604	3.7946860108946242e+09
C586_604	586	604	2.3333123719800374e-16
R586_657	586	657	6.2497791182828865e+09
C586_657	586	657	1.4167201191316134e-16
R587_588	587	588	1.1185217233397243e+09
C587_588	587	588	7.9159730492876219e-16
R587_592	587	592	1.1895697322487981e+09
C587_592	587	592	7.4431851929031362e-16
R587_651	587	651	1.3385467846850564e+09
C587_651	587	651	6.6147765011316237e-16
R587_657	587	657	3.8961803431460705e+09
C587_657	587	657	2.2725302827872857e-16
R587_658	587	658	3.5833573972877522e+09
C587_658	587	658	2.4709195414618003e-16
R588_604	588	604	2.4827630050348048e+09
C588_604	588	604	3.5662637952331980e-16
R588_651	588	651	2.0836697719678237e+09
C588_651	588	651	4.2493239265251136e-16
R588_655	588	655	2.5594624182638755e+09
C588_655	588	655	3.4593935639836193e-16
R588_656	588	656	8.8836383072919369e+08
C588_656	588	656	9.9668486162164417e-16
R588_657	588	657	3.1482523216636071e+09
C588_657	588	657	2.8124136544180329e-16
R588_658	588	658	8.2867825187572384e+08
C588_658	588	658	1.0684711221705691e-15
R589_591	589	591	3.0575745916509953e+09
C589_591	589	591	2.8958207074251669e-16
R589_595	589	595	5.8228803188066471e+08
C589_595	589	595	1.5205855748748408e-15
R589_599	589	599	1.1933901619098492e+09
C589_599	589	599	7.4193571386830849e-16
R589_636	589	636	1.5427676740984080e+09
C589_636	589	636	5.7391582450509798e-16
R589_638	589	638	1.2213611870335350e+09
C589_638	589	638	7.2494425981434851e-16
R589_659	589	659	2.7510041872775540e+09
C589_659	589	659	3.2185293857230638e-16
R590_591	590	591	1.8204770787941086e+09
C590_591	590	591	4.8636634430272804e-16
R590_626	590	626	3.1139456685768075e+09
C590_626	590	626	2.8433982989326538e-16
R590_635	590	635	1.7135717140445538e+09
C590_635	590	635	5.1670949890398265e-16
R590_640	590	640	2.5005103248102808e+09
C590_640	590	640	3.5409523124731693e-16
R590_651	590	651	4.0289601747219176e+09
C590_651	590	651	2.1976359738058533e-16
R590_652	590	652	1.3592801068619940e+09
C590_652	590	652	6.5138802313826211e-16
R590_653	590	653	3.9200144954402332e+09
C590_653	590	653	2.2587130295817034e-16
R590_660	590	660	5.5010637015186558e+09
C590_660	590	660	1.6095410446811698e-16
R591_592	591	592	2.2841947450881233e+09
C591_592	591	592	3.8762841198369048e-16
R591_595	591	595	3.2986128231689086e+09
C591_595	591	595	2.6842155450344632e-16
R591_635	591	635	4.0331083093810000e+09
C591_635	591	635	2.1953756601093953e-16
R591_637	591	637	4.2312561592915053e+09
C591_637	591	637	2.0925671913190366e-16
R591_638	591	638	1.5275301792008266e+09
C591_638	591	638	5.7964077813718440e-16
R591_651	591	651	2.9957949733814702e+09
C591_651	591	651	2.9555386452250879e-16
R591_652	591	652	7.2557541050665312e+09
C591_652	591	652	1.2202987709874734e-16
R591_660	591	660	2.7099839285631089e+09
C591_660	591	660	3.2672473529002358e-16
R591_661	591	661	4.1524328886351490e+09
C591_661	591	661	2.1322892035734399e-16
R592_594	592	594	2.4522733867864423e+09
C592_594	592	594	3.6106038848314889e-16
R592_595	592	595	1.2432445237301717e+09
C592_595	592	595	7.1218393871821102e-16
R592_651	592	651	1.9593772848197815e+09
C592_651	592	651	4.5188784649069697e-16
R592_657	592	657	1.5371010446625593e+09
C592_657	592	657	5.7603160493224229e-16
R592_658	592	658	3.0050744296186600e+09
C592_658	592	658	2.9464121519690902e-16
R592_661	592	661	1.4802063030143433e+09
C592_661	592	661	5.9817255195907675e-16
R593_606	593	606	3.0055520668600025e+09
C593_606	593	606	2.9459439131428045e-16
R593_642	593	642	3.1627270701335196e+09
C593_642	593	642	2.7995421737817569e-16
R593_643	593	643	2.1791825592122893e+09
C593_643	593	643	4.0630775882313095e-16
R593_654	593	654	2.8083544533505259e+09
C593_654	593	654	3.1528028117805620e-16
R593_656	593	656	4.2783109457265549e+09
C593_656	593	656	2.0695521969585028e-16
R593_663	593	663	3.1819044001946368e+09
C593_663	593	663	2.7826693399268659e-16
R594_595	594	595	4.3802277906109190e+09
C594_595	594	595	2.0213989409361498e-16
R594_598	594	598	1.8738323943687046e+09
C594_598	594	598	4.7251759781765247e-16
R594_599	594	599	9.6250185468177891e+09
C594_599	594	599	9.1991384472992661e-17
R594_601	594	601	6.6103778422398844e+09
C594_601	594	601	1.3394374766934376e-16
R594_657	594	657	7.2180209814827385e+09
C594_657	594	657	1.2266780381651316e-16
R594_665	594	665	1.0425348808449764e+10
C594_665	594	665	8.4929415597333946e-17
R595_599	595	599	4.7810622952774410e+09
C595_599	595	599	1.8519289794123461e-16
R595_638	595	638	5.8665343150076838e+09
C595_638	595	638	1.5092706087731120e-16
R595_657	595	657	1.2362714294457235e+10
C595_657	595	657	7.1620095766264972e-17
R595_659	595	659	6.1685930682152605e+09
C595_659	595	659	1.4353658474608627e-16
R595_661	595	661	4.8308079027724771e+09
C595_661	595	661	1.8328586015433242e-16
R595_665	595	665	8.1634299891750650e+09
C595_665	595	665	1.0846161268904001e-16
R596_598	596	598	2.1577976448283272e+09
C596_598	596	598	4.1033448332011852e-16
R596_597	596	597	9.0917965205004578e+09
C596_597	596	597	9.7386559378394709e-17
R596_604	596	604	7.1551952242688942e+09
C596_604	596	604	1.2374488101971678e-16
R596_607	596	607	1.2065078794406624e+10
C596_607	596	607	7.3386904204096919e-17
R596_608	596	608	6.4133883421809473e+09
C596_608	596	608	1.3805787743689057e-16
R596_657	596	657	2.6033128606125946e+09
C596_657	596	657	3.4011232191725479e-16
R596_664	596	664	7.0242698178369913e+09
C596_664	596	664	1.2605136258456687e-16
R596_665	596	665	1.0801440216102074e+10
C596_665	596	665	8.1972289248990722e-17
R596_666	596	666	2.9156659465999341e+09
C596_666	596	666	3.0367634630178394e-16
R597_598	597	598	2.8891943518016000e+09
C597_598	597	598	3.0645871266773179e-16
R597_601	597	601	6.0401964379410167e+00
C597_601	597	601	1.6124652052343575e-16
R597_602	597	602	2.2378674377564152e+00
C597_602	597	602	3.9565291793497866e-17
R597_607	597	607	2.6854409199368281e+01
C597_607	597	607	6.9239260638620980e-17
R597_666	597	666	9.9118077267514391e+00
C597_666	597	666	1.4292751510619783e-16
R598_601	598	601	1.5097037694589367e+09
C598_601	598	601	5.8648511026592026e-16
R598_657	598	657	4.6023420468153238e+09
C598_657	598	657	1.9238439314015829e-16
R598_665	598	665	4.9237167374936237e+09
C598_665	598	665	1.7982731926018859e-16
R598_666	598	666	4.3108496608258333e+09
C598_666	598	666	2.0539310144496653e-16
R599_600	599	600	6.5771673257944541e-01
C599_600	599	600	1.3462007849907492e-16
R599_601	599	601	4.8316536825963867e+00
C599_601	599	601	1.5576570949019622e-16
R599_603	599	603	5.5071631434674861e+00
C599_603	599	603	1.6077584023459894e-17
R599_636	599	636	8.7888309697234952e+00
C599_636	599	636	1.1081799869074979e-16
R599_659	599	659	4.9842552304383121e+00
C599_659	599	659	1.9540746086760689e-16
R599_665	599	665	1.0573061507475320e+01
C599_665	599	665	1.3398863210938358e-16
R599_667	599	667	4.6657115253757775e+00
C599_667	599	667	1.8977143719332030e-17
R600_603	600	603	7.9565027195054450e+00
C600_603	600	603	1.1128240797673416e-17
R600_636	600	636	3.0464017359792863e+00
C600_636	600	636	2.9064412984106187e-17
R600_639	600	639	8.7025317618493450e+00
C600_639	600	639	1.0174266591953727e-17
R600_659	600	659	4.1326896460881981e+00
C600_659	600	659	2.1424758632385916e-17
R600_662	600	662	4.4005348286346235e+00
C600_662	600	662	2.0120708417952082e-17
R600_667	600	667	5.5182708234660280e+00
C600_667	600	667	1.6045221592510898e-17
R601_602	601	602	2.7988074405929741e+00
C601_602	601	602	3.1635573382369214e-17
R601_603	601	603	6.3778236134823008e-01
C601_603	601	603	1.3882773111320964e-16
R601_665	601	665	3.7841110812923144e+00
C601_665	601	665	2.5738162489760246e-16
R601_666	601	666	4.0957493600413200e+00
C601_666	601	666	1.6573794093459964e-16
R601_667	601	667	3.8877713955956170e+00
C601_667	601	667	2.2774455892727494e-17
R601_668	601	668	2.8277065266986039e+00
C601_668	601	668	3.1312258656973914e-17
R602_603	602	603	5.6957847186627326e+00
C602_603	602	603	1.5545158839990008e-17
R602_607	602	607	9.3846146100806322e+00
C602_607	602	607	9.4347910754791511e-18
R602_666	602	666	2.9676057677920133e+00
C602_666	602	666	2.9836132255490857e-17
R602_611	602	611	7.5076916880645035e+00
C602_611	602	611	1.1793488844348942e-17
R602_668	602	668	3.4419117265156722e+00
C602_668	602	668	2.5724622013950661e-17
R603_667	603	667	6.4153937772129552e+00
C603_667	603	667	1.3801472091159047e-17
R603_668	603	668	9.5496745515185442e+00
C603_668	603	668	9.2717168205402877e-18
R604_605	604	605	2.6438985971896238e+09
C604_605	604	605	3.3489135424526902e-16
R604_606	604	606	5.0672784423535872e+09
C604_606	604	606	1.7473260879044012e-16
R604_608	604	608	1.1286082790281651e+09
C604_608	604	608	7.8452267110996791e-16
R604_656	604	656	1.5497126716907558e+09
C604_656	604	656	5.7134383545692838e-16
R604_657	604	657	2.2032488309913545e+09
C604_657	604	657	4.0186962509432250e-16
R604_658	604	658	4.8721039989369078e+09
C604_658	604	658	1.8173232383651874e-16
R604_664	604	664	1.1477712985516031e+09
C604_664	604	664	7.7142439684397826e-16
R604_669	604	669	3.4713204429983540e+09
C604_669	604	669	2.5506685315839623e-16
R605_606	605	606	3.0976855582451797e+09
C605_606	605	606	2.8583236259834731e-16
R605_608	605	608	4.6260496371504154e+09
C605_608	605	608	1.9139846113830422e-16
R605_609	605	609	3.1690752887780552e+09
C605_609	605	609	2.7939341953639844e-16
R605_669	605	669	5.1412528902536173e+09
C605_669	605	669	1.7221848459905700e-16
R606_656	606	656	1.9389891923500202e+09
C606_656	606	656	4.5663935889549157e-16
R606_663	606	663	5.3188375523920374e+09
C606_663	606	663	1.6646847604920763e-16
R606_669	606	669	5.8708783651291351e+09
C606_669	606	669	1.5081538513198685e-16
R607_608	607	608	1.3781258468253837e+09
C607_608	607	608	6.4248035383679134e-16
R607_610	607	610	9.7578626955033592e+00
C607_610	607	610	1.9055191652861486e-16
R607_666	607	666	2.6243310302314442e+00
C607_666	607	666	3.7112721210713434e-16
R607_611	607	611	8.1315522625158987e-01
C607_611	607	611	1.0888680944492286e-16
R607_670	607	670	2.5565277441808765e+00
C607_670	607	670	3.8097011116462616e-16
R608_609	608	609	1.1055419530892005e+09
C608_609	608	609	8.0089116403578051e-16
R608_610	608	610	3.2755647496569238e+09
C608_610	608	610	2.7031026689145347e-16
R608_664	608	664	8.3156759352313042e+08
C608_664	608	664	1.0647586421071514e-15
R608_666	608	666	3.3757068374260921e+09
C608_666	608	666	2.6229137313805182e-16
R608_669	608	669	3.3095813309658470e+09
C608_669	608	669	2.6753196043730556e-16
R608_670	608	670	1.0087865597550267e+09
C608_670	608	670	8.7770675881627004e-16
R608_671	608	671	2.7061061994828963e+09
C608_671	608	671	3.2719291721411110e-16
R609_610	609	610	3.1872306799001389e+09
C609_610	609	610	2.7780191351814594e-16
R609_669	609	669	4.5505780713893003e+09
C609_669	609	669	1.9457281422482658e-16
R609_671	609	671	3.4886980986208520e+09
C609_671	609	671	2.5379633223351221e-16
R610_611	610	611	7.5454032117294316e+00
C610_611	610	611	1.1734545614787089e-17
R610_670	610	670	3.6976295732634732e+00
C610_670	610	670	1.8358276622023427e-16
R610_671	610	671	1.2072645114621764e+01
C610_671	610	671	1.5401591119408099e-16
R610_673	610	673	1.5090806423458847e+00
C610_673	610	673	5.8672728073935507e-17
R611_666	611	666	3.4231283949999445e+00
C611_666	611	666	2.5865777719389759e-17
R611_668	611	668	7.3264104154792369e+00
C611_668	611	668	1.2085301416219974e-17
R611_670	611	670	2.5069918083309752e+00
C611_670	611	670	3.5317976658626005e-17
R611_672	611	672	2.6971317626235685e+00
C611_672	611	672	3.2828161900356344e-17
R611_673	611	673	8.0975879893327818e+00
C611_673	611	673	1.0934352091837607e-17
R612_613	612	613	3.7389760676156387e+09
C612_613	612	613	2.3680782270014244e-16
R612_631	612	631	3.4343961288294234e+09
C612_631	612	631	2.5780916018030372e-16
R612_632	612	632	1.9428319769392326e+09
C612_632	612	632	4.5573615845818150e-16
R612_633	612	633	3.1353175932486062e+09
C612_633	612	633	2.8240162451376676e-16
R612_634	612	634	2.4922985981016202e+09
C612_634	612	634	3.5526191860574892e-16
R612_675	612	675	7.9098022512975807e+09
C612_675	612	675	1.1193943332208458e-16
R613_614	613	614	2.3695870259786353e+09
C613_614	613	614	3.7365953307172736e-16
R613_618	613	618	6.7914425972840700e+09
C613_618	613	618	1.3037271080728610e-16
R613_634	613	634	4.5769934363127937e+09
C613_634	613	634	1.9344986922535106e-16
R613_675	613	675	7.3239135729203224e+09
C613_675	613	675	1.2089421494182790e-16
R614_615	614	615	2.9413441437426944e+09
C614_615	614	615	3.0102522466934279e-16
R614_616	614	616	1.4687738569766405e+09
C614_616	614	616	6.0282852768265329e-16
R614_617	614	617	8.9813041276002064e+09
C614_617	614	617	9.8584656428574040e-17
R614_618	614	618	1.4687738569766378e+09
C614_618	614	618	6.0282852768265438e-16
R614_634	614	634	1.8301978033917263e+09
C614_634	614	634	4.8378310806577319e-16
R614_674	614	674	3.4140140060831470e+09
C614_674	614	674	2.5934831553776473e-16
R614_675	614	675	5.1239696504232998e+09
C614_675	614	675	1.7279938057924568e-16
R614_676	614	676	1.9613441155580814e+09
C614_676	614	676	4.5143469454265697e-16
R614_677	614	677	3.1219858727282443e+09
C614_677	614	677	2.8360755550961207e-16
R615_617	615	617	4.9736212787741804e+09
C615_617	615	617	1.7802295994644450e-16
R615_618	615	618	3.3660344849141841e+09
C615_618	615	618	2.6304507148344727e-16
R615_622	615	622	4.9104621004650078e+09
C615_622	615	622	1.8031272079590092e-16
R615_677	615	677	3.2687008511796184e+09
C615_677	615	677	2.7087788758046412e-16
R615_621	615	621	5.1824690785053377e+09
C615_621	615	621	1.7084883060322304e-16
R616_617	616	617	1.9026957310832109e+09
C616_617	616	617	4.6534964431539892e-16
R616_633	616	633	1.7784022894142649e+09
C616_633	616	633	4.9787316793863434e-16
R616_634	616	634	1.8523563350243919e+09
C616_634	616	634	4.7799592603133823e-16
R616_635	616	635	3.0996506971902833e+09
C616_635	616	635	2.8565114853186488e-16
R616_637	616	637	2.0296917661358740e+09
C616_637	616	637	4.3623312488755860e-16
R616_674	616	674	8.2382061730946839e+08
C616_674	616	674	1.0747713313994330e-15
R616_677	616	677	4.5902919236953812e+09
C616_677	616	677	1.9288942760468270e-16
R616_678	616	678	4.8622998439911833e+09
C616_678	616	678	1.8209876192522314e-16
R617_619	617	619	4.3859754795501537e+09
C617_619	617	619	2.0187499584261534e-16
R617_637	617	637	3.8313423553491282e+09
C617_637	617	637	2.3109884201912228e-16
R617_621	617	621	5.8455360355539322e+09
C617_621	617	621	1.5146921964293332e-16
R617_677	617	677	6.2953724881888514e+09
C617_677	617	677	1.4064597184061633e-16
R617_678	617	678	4.6763204137854223e+09
C617_678	617	678	1.8934091408489795e-16
R618_622	618	622	5.0076919864888849e+09
C618_622	618	622	1.7681174962216604e-16
R618_675	618	675	5.6938534181098747e+09
C618_675	618	675	1.5550431609002022e-16
R618_676	618	676	3.4854010910323081e+09
C618_676	618	676	2.5403641032250787e-16
R618_677	618	677	3.9823171062639794e+09
C618_677	618	677	2.2233758841235473e-16
R618_679	618	679	3.8297329970577769e+09
C618_679	618	679	2.3119595605757112e-16
R619_636	619	636	6.9990624013758884e+00
C619_636	619	636	1.3915587589340204e-16
R619_637	619	637	6.6999142618614645e+09
C619_637	619	637	1.3215374810691990e-16
R619_620	619	620	1.7534195319852530e+00
C619_620	619	620	5.0496687503960500e-17
R619_639	619	639	4.2695586417308604e+00
C619_639	619	639	2.0737946378013798e-17
R619_678	619	678	5.3715348465291148e+00
C619_678	619	678	1.8131887565159828e-16
R619_621	619	621	1.0520517186651253e+01
C619_621	619	621	5.0496687503960550e-17
R619_680	619	680	5.3843414982586602e+00
C619_680	619	680	1.6444328094463397e-17
R620_639	620	639	7.4415020612902252e+00
C620_639	620	639	1.1898387911572844e-17
R620_623	620	623	1.9465617884707466e+01
C620_623	620	623	4.5486292135406637e-18
R620_621	620	621	1.2166011177942160e+01
C620_621	620	621	7.2778067416650660e-18
R620_680	620	680	5.0194609745276564e+00
C620_680	620	680	1.7639718411862344e-17
R621_622	621	622	8.0041154816226623e+00
C621_622	621	622	6.6372264365015726e-17
R621_677	621	677	2.6792870011149574e+00
C621_677	621	677	3.6351486738476909e-16
R621_678	621	678	6.8069929335689494e+00
C621_678	621	678	1.4308236667808404e-16
R621_623	621	623	1.3340192476041182e+00
C621_623	621	623	6.6372264365015800e-17
R621_680	621	680	2.7531649750797165e+00
C621_680	621	680	3.2160033623643035e-17
R621_681	621	681	2.4109495977964319e+00
C621_681	621	681	3.6724898044706460e-17
R621_624	621	624	1.0005144357030899e+01
C621_624	621	624	8.8496352486687630e-18
R622_677	622	677	7.6762106348670587e+00
C622_677	622	677	1.8455330578868749e-16
R622_679	622	679	7.4146644946658506e+00
C622_679	622	679	7.1648726538680134e-17
R622_681	622	681	4.0583632462332186e+00
C622_681	622	681	2.1817139767412491e-17
R622_624	622	624	1.8536661245932968e+00
C622_624	622	624	4.7765817692453383e-17
R623_680	623	680	6.3287848621701137e+00
C623_680	623	680	1.3990344133714064e-17
R623_681	623	681	4.0715842900906862e+00
C623_681	623	681	2.1746296247750751e-17
R623_624	623	624	1.6188096087685519e+01
C623_624	623	624	5.4695671245338662e-18
R624_679	624	679	1.4110036604415292e+01
C624_679	624	679	6.2750991122371431e-18
R624_681	624	681	4.7674179224558006e+00
C624_681	624	681	1.8572292089800710e-17
R624_682	624	682	2.2576058567064475e+01
C624_682	624	682	3.9219369451482136e-18
R625_627	625	627	4.4816816018390913e+09
C625_627	625	627	1.9756396378909691e-16
R625_629	625	629	8.1894122291864977e+09
C625_629	625	629	1.0811750061187894e-16
R625_641	625	641	4.5845921824987345e+09
C625_641	625	641	1.9312923515422071e-16
R625_648	625	648	5.7946267048380785e+09
C625_648	625	648	1.5279996914395568e-16
R625_683	625	683	1.7467951103005913e+10
C625_683	625	683	5.0688187554385584e-17
R626_628	626	628	1.4276315433226106e+09
C626_628	626	628	6.2020118975468485e-16
R626_631	626	631	1.5405589530027874e+09
C626_631	626	631	5.7473865571595437e-16
R626_640	626	640	1.6036828428682861e+09
C626_640	626	640	5.5211589101768642e-16
R626_645	626	645	2.6887864204910965e+09
C626_645	626	645	3.2930052567666635e-16
R626_652	626	652	5.0820351650328636e+09
C626_652	626	652	1.7422523712392978e-16
R626_684	626	684	2.6848848128706651e+09
C626_684	626	684	3.2977905698431623e-16
R627_628	627	628	2.0916442624541399e+09
C627_628	627	628	4.2331231825297685e-16
R627_629	627	629	1.2180404644692850e+09
C627_629	627	629	7.2692066275958066e-16
R627_641	627	641	5.9672243830771141e+09
C627_641	627	641	1.4838033981276512e-16
R627_644	627	644	3.8607505536538067e+09
C627_644	627	644	2.2933851058106860e-16
R627_647	627	647	3.2478327456818657e+09
C627_647	627	647	2.7261834307114573e-16
R627_648	627	648	1.5193577749594061e+09
C627_648	627	648	5.8275858148266396e-16
R627_649	627	649	2.4441267886624317e+09
C627_649	627	649	3.6226385055275818e-16
R627_685	627	685	4.5028641149447508e+09
C627_685	627	685	1.9663457725969238e-16
R628_629	628	629	1.1109560996411037e+09
C628_629	628	629	7.9698809159609113e-16
R628_631	628	631	3.1390969864202747e+09
C628_631	628	631	2.8206162011888114e-16
R628_644	628	644	2.4670973643705683e+09
C628_644	628	644	3.5889089522249051e-16
R628_645	628	645	1.3716361986029394e+09
C628_645	628	645	6.4552013325532728e-16
R628_647	628	647	1.4297623835310323e+09
C628_647	628	647	6.1927687558355911e-16
R628_684	628	684	8.1588316979603875e+08
C628_684	628	684	1.0852274130392280e-15
R628_685	628	685	1.6549717660589364e+09
C628_685	628	685	5.3500536979460994e-16
R629_630	629	630	6.6675330876036119e+08
C629_630	629	630	1.3279555872713786e-15
R629_631	629	631	3.5288596176430359e+09
C629_631	629	631	2.5090790726647859e-16
R629_641	629	641	9.7892418501438177e+08
C629_641	629	641	9.0448146572963894e-16
R629_684	629	684	2.5141432661758165e+09
C629_684	629	684	3.5217514992563746e-16
R629_685	629	685	1.6243887639358723e+09
C629_685	629	685	5.4507812498939122e-16
R629_686	629	686	2.8530096669670959e+09
C629_686	629	686	3.1034552457063639e-16
R630_631	630	631	2.4422951926588292e+09
C630_631	630	631	3.6253552984153395e-16
R630_632	630	632	6.5679949871578245e+09
C630_632	630	632	1.3480807817777405e-16
R630_641	630	641	5.5661924779986305e+09
C630_641	630	641	1.5907081639734447e-16
R630_684	630	684	7.5621407503531990e+09
C630_684	630	684	1.1708573153159645e-16
R630_686	630	686	2.5818912674458432e+09
C630_686	630	686	3.4293418660341473e-16
R631_632	631	632	2.8444412216329279e+09
C631_632	631	632	3.1128039312821582e-16
R631_633	631	633	3.4503520121950951e+09
C631_633	631	633	2.5661694185710102e-16
R631_640	631	640	5.0445488518092823e+09
C631_640	631	640	1.7551991421045215e-16
R631_684	631	684	2.2213839194136705e+09
C631_684	631	684	3.9858881391997492e-16
R631_686	631	686	7.7135297166736526e+09
C631_686	631	686	1.1478775790363118e-16
R631_687	631	687	6.9914956826296644e+09
C631_687	631	687	1.2664225537603043e-16
R632_633	632	633	5.4256832682186642e+09
C632_633	632	633	1.6319028183720291e-16
R632_634	632	634	5.1016777098113537e+09
C632_634	632	634	1.7355443288728255e-16
R632_675	632	675	6.3236298719371452e+09
C632_675	632	675	1.4001748989599953e-16
R632_686	632	686	2.5550850010630670e+09
C632_686	632	686	3.4653202587452594e-16
R632_687	632	687	2.7928681269992108e+09
C632_687	632	687	3.1702849595384793e-16
R632_688	632	688	7.6465615703447561e+09
C632_688	632	688	1.1579306248364905e-16
R633_634	633	634	1.2776029529739926e+09
C633_634	633	634	6.9303125798115142e-16
R633_635	633	635	4.0818315759380112e+09
C633_635	633	635	2.1691702982539873e-16
R633_640	633	640	4.0749133769193873e+09
C633_640	633	640	2.1728530150237739e-16
R633_674	633	674	7.3093735513979597e+09
C633_674	633	674	1.2113470128102272e-16
R633_687	633	687	5.1473883567987719e+09
C633_687	633	687	1.7201320753863877e-16
R633_689	633	689	5.0029995727549906e+09
C633_689	633	689	1.7697758491161100e-16
R634_674	634	674	2.5898913897755370e+09
C634_674	634	674	3.4187486980940093e-16
R634_675	634	675	1.0919503032178514e+09
C634_675	634	675	8.1085996229935849e-16
R634_676	634	676	2.4741044081993966e+09
C634_676	634	676	3.5787446106382801e-16
R634_687	634	687	4.7768851266699152e+09
C634_687	634	687	1.8535484070081617e-16
R634_689	634	689	3.4619041164182129e+09
C634_689	634	689	2.5576063112229700e-16
R635_637	635	637	1.5731482614371550e+09
C635_637	635	637	5.6283238103134845e-16
R635_638	635	638	3.5736573587851901e+09
C635_638	635	638	2.4776264000894161e-16
R635_640	635	640	2.6437555241669908e+09
C635_640	635	640	3.3490947767531679e-16
R635_653	635	653	1.5240199098081598e+09
C635_653	635	653	5.8097586258663417e-16
R635_660	635	660	1.5670282767036304e+09
C635_660	635	660	5.6503050701966244e-16
R635_674	635	674	2.6220656934729972e+09
C635_674	635	674	3.3767986206601825e-16
R635_689	635	689	1.8775761641360700e+09
C635_689	635	689	4.7157542719839984e-16
R635_690	635	690	2.5544592905442300e+09
C635_690	635	690	3.4661690831305469e-16
R635_691	635	691	2.7748260069085875e+09
C635_691	635	691	3.1908983824410617e-16
R636_637	636	637	4.2496716354660592e+09
C636_637	636	637	2.0834992857110398e-16
R636_638	636	638	2.9881253537387815e+09
C636_638	636	638	2.9631246245816042e-16
R636_639	636	639	1.1388172747235961e+00
C636_639	636	639	7.7748977061741636e-17
R636_659	636	659	4.6808998828894826e+00
C636_659	636	659	2.0807124340690264e-16
R636_662	636	662	5.0344645498291909e+00
C636_662	636	662	1.7587148999391412e-17
R636_678	636	678	1.2604493719589422e+01
C636_678	636	678	7.7270906754655836e-17
R636_691	636	691	7.7169761996025308e+00
C636_691	636	691	1.2621014160264018e-16
R637_638	637	638	2.6664154286712799e+09
C637_638	637	638	3.3206332823434767e-16
R637_674	637	674	5.8590819007617912e+09
C637_674	637	674	1.5111903139378864e-16
R637_678	637	678	2.4908305966103673e+09
C637_678	637	678	3.5547129656465482e-16
R637_691	637	691	4.8417051645432978e+09
C637_691	637	691	1.8287333730770834e-16
R638_659	638	659	1.9228656461047990e+09
C638_659	638	659	4.6046835539114067e-16
R638_660	638	660	1.8397942725016594e+09
C638_660	638	660	4.8125966850415950e-16
R638_661	638	661	5.5489272911265583e+09
C638_661	638	661	1.5956575663117759e-16
R638_691	638	691	3.5236859805626435e+09
C638_691	638	691	2.5127630174315964e-16
R639_662	639	662	6.4964244658102928e+00
C639_662	639	662	1.3629324659431142e-17
R639_678	639	678	5.6812351778921233e+00
C639_678	639	678	1.5584969711261138e-17
R639_680	639	680	7.8611275535688172e+00
C639_680	639	680	1.1263254229961391e-17
R639_691	639	691	8.2164984915872488e+00
C639_691	639	691	1.0776108370330347e-17
R639_693	639	693	9.2961646223452927e+00
C639_693	639	693	9.5245600489013416e-18
R640_645	640	645	4.4303063853438835e+09
C640_645	640	645	1.9985497721536777e-16
R640_652	640	652	4.0536156524071541e+09
C640_652	640	652	2.1842691997062252e-16
R640_653	640	653	2.1022020019716308e+09
C640_653	640	653	4.2118634692078880e-16
R640_684	640	684	3.2201994858475089e+09
C640_684	640	684	2.7495774270859213e-16
R640_687	640	687	4.8445956200559092e+09
C640_687	640	687	1.8276422866637154e-16
R640_689	640	689	5.8387151627273321e+09
C640_689	640	689	1.5164616821047506e-16
R640_694	640	694	9.6904460037314053e+09
C640_694	640	694	9.1370281755768572e-17
R640_695	640	695	2.3434089169106708e+09
C640_695	640	695	3.7783366586624264e-16
R641_648	641	648	1.0669242030086081e+10
C641_648	641	648	8.2987974141294867e-17
R641_683	641	683	7.2631519619407578e+09
C641_683	641	683	1.2190558401361202e-16
R641_685	641	685	2.4746314619194369e+09
C641_685	641	685	3.5779823999054347e-16
R641_686	641	686	5.0341259214168806e+09
C641_686	641	686	1.7588332026680701e-16
R641_697	641	697	1.1280706506153702e+10
C641_697	641	697	7.8489656761923403e-17
R642_643	642	643	1.4969018953115873e+09
C642_643	642	643	5.9150087555717609e-16
R642_644	642	644	5.3441749008451519e+09
C642_644	642	644	1.6567922983957281e-16
R642_646	642	646	2.7813948133919034e+09
C642_646	642	646	3.1833624533880338e-16
R642_650	642	650	3.8605647500906177e+09
C642_650	642	650	2.2934954832171051e-16
R642_654	642	654	1.4541252191513374e+09
C642_654	642	654	6.0890133121874607e-16
R642_699	642	699	7.2812797550573130e+09
C642_699	642	699	1.2160208253020634e-16
R643_650	643	650	2.9081931410129991e+09
C643_650	643	650	3.0445666390354870e-16
R643_654	643	654	1.9704450355136387e+09
C643_654	643	654	4.4934964728371471e-16
R643_663	643	663	4.6021031445841627e+09
C643_663	643	663	1.9239438010901102e-16
R643_699	643	699	3.0635766997432399e+09
C643_699	643	699	2.8901472640597109e-16
R644_645	644	645	5.7154143293895998e+09
C644_645	644	645	1.5491768936978569e-16
R644_646	644	646	3.4914365369479632e+09
C644_646	644	646	2.5359727216293277e-16
R644_647	644	647	7.6402824514717283e+09
C644_647	644	647	1.1588822629580192e-16
R644_649	644	649	2.8391362177976327e+09
C644_649	644	649	3.1186202907405221e-16
R644_650	644	650	3.1359158680372958e+09
C644_650	644	650	2.8234774750324060e-16
R644_701	644	701	5.7751084075370455e+09
C644_701	644	701	1.5331639152339501e-16
R645_646	645	646	1.3330295205586267e+09
C645_646	645	646	6.6421543412553359e-16
R645_647	645	647	1.5375482175588596e+09
C645_647	645	647	5.7586407475777583e-16
R645_652	645	652	3.9682564206425953e+09
C645_652	645	652	2.2312539509647432e-16
R645_684	645	684	1.6474236325428560e+09
C645_684	645	684	5.3745664697872848e-16
R645_694	645	694	1.4857836159555790e+09
C645_694	645	694	5.9592714052816143e-16
R645_695	645	695	4.0359222427679553e+09
C645_695	645	695	2.1938449961135866e-16
R645_696	645	696	2.0380648785160482e+09
C645_696	645	696	4.3444092042088949e-16
R645_698	645	698	1.4232710720317154e+09
C645_698	645	698	6.2210129826925195e-16
R645_701	645	701	4.0437298730431762e+09
C645_701	645	701	2.1896091220199719e-16
R646_650	646	650	2.1639416963649130e+09
C646_650	646	650	4.0916942595420502e-16
R646_652	646	652	3.8632314348640499e+09
C646_652	646	652	2.2919123449593657e-16
R646_654	646	654	9.6335429307424116e+08
C646_654	646	654	9.1909984526509504e-16
R646_655	646	655	1.1520536527106936e+09
C646_655	646	655	7.6855689803741137e-16
R646_694	646	694	1.0701668902573686e+09
C646_694	646	694	8.2736514254058291e-16
R646_698	646	698	2.4264919375046887e+09
C646_698	646	698	3.6489665101073058e-16
R646_699	646	699	1.2892883153797314e+09
C646_699	646	699	6.8675002413189443e-16
R646_701	646	701	2.3340854982065687e+09
C646_701	646	701	3.7934290855254677e-16
R647_649	647	649	4.7081233351904297e+09
C647_649	647	649	1.8806193437670159e-16
R647_648	647	648	1.3114890217407308e+09
C647_648	647	648	6.7512481387361483e-16
R647_684	647	684	3.6102593611197944e+09
C647_684	647	684	2.4525074049676297e-16
R647_685	647	685	1.0872102445274253e+09
C647_685	647	685	8.1439517899765801e-16
R647_683	647	683	7.0123722328647156e+09
C647_683	647	683	1.2626522841305103e-16
R647_696	647	696	2.3414074525925183e+09
C647_696	647	696	3.7815664280030458e-16
R647_698	647	698	2.4183402365603909e+09
C647_698	647	698	3.6612663855741510e-16
R647_700	647	700	1.2023878570433073e+09
C647_700	647	700	7.3638366897455229e-16
R647_701	647	701	1.2684119519486637e+09
C647_701	647	701	6.9805301056942053e-16
R648_649	648	649	4.1785873120920310e+09
C648_649	648	649	2.1189428760714604e-16
R648_683	648	683	4.7066456667341728e+09
C648_683	648	683	1.8812097710222799e-16
R648_685	648	685	5.9742478618869677e+09
C648_685	648	685	1.4820590008469121e-16
R648_700	648	700	8.3302569999892235e+09
C648_700	648	700	1.0628949163286865e-16
R648_701	648	701	7.8598892843458557e+09
C648_701	648	701	1.1265028674938767e-16
R649_650	649	650	1.0365914066689615e+10
C649_650	649	650	8.5416372931862546e-17
R649_701	649	701	8.4174205920892248e+09
C649_701	649	701	1.0518884877062283e-16
R650_699	650	699	2.6334904129476418e+09
C650_699	650	699	3.3621492500857787e-16
R650_701	650	701	2.5980935642114716e+09
C650_701	650	701	3.4079557175945169e-16
R651_652	651	652	8.5500845766635025e+08
C651_652	651	652	1.0355672786169291e-15
R651_655	651	655	1.1618472831659560e+09
C651_655	651	655	7.6207845431052968e-16
R651_658	651	658	7.8800353182033885e+08
C651_658	651	658	1.1236228594745328e-15
R651_660	651	660	3.7078763393414588e+09
C651_660	651	660	2.3879404291494137e-16
R651_661	651	661	1.9000096144195988e+09
C651_661	651	661	4.6600752700426275e-16
R651_703	651	703	2.0788081185909545e+09
C651_703	651	703	4.2592617076180623e-16
R652_653	652	653	1.9745624079460809e+09
C652_653	652	653	4.4841266000855523e-16
R652_655	652	655	3.2281660861793861e+09
C652_655	652	655	2.7427919074260357e-16
R652_660	652	660	4.0257821732883096e+09
C652_660	652	660	2.1993708143845718e-16
R652_694	652	694	3.7566145301433659e+09
C652_694	652	694	2.3569593701864571e-16
R652_703	652	703	3.3163098976607814e+09
C652_703	652	703	2.6698915632840773e-16
R653_660	653	660	1.7064345099974196e+09
C653_660	653	660	5.1887064901268257e-16
R653_689	653	689	3.7513517677174659e+09
C653_689	653	689	2.3602659428516860e-16
R653_690	653	690	7.2686816385730159e+08
C653_690	653	690	1.2181284388647747e-15
R653_694	653	694	2.9273052387542119e+09
C653_694	653	694	3.0246889527544189e-16
R653_695	653	695	1.5197740323256781e+09
C653_695	653	695	5.8259896725900923e-16
R653_702	653	702	1.7803306635884473e+09
C653_702	653	702	4.9733389409546184e-16
R653_703	653	703	2.5526032246608729e+09
C653_703	653	703	3.4686894271146772e-16
R654_655	654	655	1.3437951887423525e+09
C654_655	654	655	6.5889414482028061e-16
R654_656	654	656	2.0827501626893179e+09
C654_656	654	656	4.2512001562238122e-16
R654_663	654	663	1.5878288407719488e+09
C654_663	654	663	5.5762860515213913e-16
R654_694	654	694	5.0957435808669596e+09
C654_694	654	694	1.7375654164084924e-16
R654_699	654	699	1.7513929966387074e+09
C654_699	654	699	5.0555117178115088e-16
R654_704	654	704	2.6549330268171382e+09
C654_704	654	704	3.3349947917951163e-16
R655_656	655	656	2.9246327663925853e+09
C655_656	655	656	3.0274528545070217e-16
R655_658	655	658	1.9936790389960327e+09
C655_658	655	658	4.4411300133138529e-16
R655_694	655	694	2.5305748921622539e+09
C655_694	655	694	3.4988839272938985e-16
R655_703	655	703	2.6849247766033092e+09
C655_703	655	703	3.2977414839165094e-16
R655_704	655	704	1.9431896913243439e+09
C655_704	655	704	4.5565226372550361e-16
R656_658	656	658	1.5896453739868295e+09
C656_658	656	658	5.5699138700310899e-16
R656_663	656	663	1.9841036207028458e+09
C656_663	656	663	4.4625632071895052e-16
R656_664	656	664	3.8257099190694184e+09
C656_664	656	664	2.3143907939454357e-16
R656_669	656	669	2.3781635962318215e+09
C656_669	656	669	3.7231197344999222e-16
R656_704	656	704	1.3434863385592601e+09
C656_704	656	704	6.5904561608680985e-16
R656_705	656	705	3.7278061799453640e+09
C656_705	656	705	2.3751738662361921e-16
R657_658	657	658	1.7357674241409128e+09
C657_658	657	658	5.1010219997545030e-16
R657_661	657	661	2.1452333296989300e+09
C657_661	657	661	4.1273775185297115e-16
R657_664	657	664	3.1244902040038571e+09
C657_664	657	664	2.8338023929964188e-16
R657_665	657	665	2.8070311434121404e+09
C657_665	657	665	3.1542891277782989e-16
R657_705	657	705	4.6816829387609015e+09
C657_705	657	705	1.8912403793289414e-16
R658_661	658	661	1.3177871761883912e+09
C658_661	658	661	6.7189816208487700e-16
R658_664	658	664	4.8452646472247791e+09
C658_664	658	664	1.8273899284472336e-16
R658_703	658	703	1.3142026967820666e+09
C658_703	658	703	6.7373076000225897e-16
R658_704	658	704	2.4867427837539144e+09
C658_704	658	704	3.5605563530112986e-16
R658_705	658	705	1.8611420401085377e+09
C658_705	658	705	4.7573949898437867e-16
R659_660	659	660	3.9483528780035291e+09
C659_660	659	660	2.2425016432363787e-16
R659_661	659	661	3.8857134035242057e+09
C659_661	659	661	2.2786517937657375e-16
R659_662	659	662	8.9811439288001471e-01
C659_662	659	662	9.8586414906535114e-17
R659_665	659	665	6.6208954810629495e+00
C659_665	659	665	2.1396955330996349e-16
R659_667	659	667	2.5858735684712499e+00
C659_667	659	667	3.4240606056523227e-17
R659_691	659	691	4.1777016603754165e+00
C659_691	659	691	2.3313312870898434e-16
R659_692	659	692	1.7899789600794349e+00
C659_692	659	692	4.9465317830367537e-17
R659_706	659	706	3.6270641835569730e+00
C659_706	659	706	2.6852589576755175e-16
R660_661	660	661	1.8475032821697276e+09
C660_661	660	661	4.7925153381062196e-16
R660_690	660	690	1.3637361296790023e+09
C660_690	660	690	6.4925960560156964e-16
R660_691	660	691	2.6536069418178940e+09
C660_691	660	691	3.3366613862316414e-16
R660_703	660	703	1.8058490529370048e+09
C660_703	660	703	4.9030608635864043e-16
R660_706	660	706	3.0757514213948874e+09
C660_706	660	706	2.8787072178233862e-16
R661_665	661	665	2.7112584197161713e+09
C661_665	661	665	3.2657115059976112e-16
R661_703	661	703	1.3920102491099155e+09
C661_703	661	703	6.3607202767807049e-16
R661_705	661	705	2.7932935040978346e+09
C661_705	661	705	3.1698021722424355e-16
R661_706	661	706	2.4794471214276252e+09
C661_706	661	706	3.5710331309271500e-16
R662_667	662	667	2.9699290496713755e+00
C662_667	662	667	2.9812792389702787e-17
R662_691	662	691	2.4718450304148387e+00
C662_691	662	691	3.5820157445363967e-17
R662_692	662	692	1.0383454103904415e+00
C662_692	662	692	8.5272085073026170e-17
R662_693	662	693	3.3819054764676628e+00
C662_693	662	693	2.6181062358514038e-17
R662_708	662	708	3.6800558092977194e+00
C662_708	662	708	2.4059928098453709e-17
R663_669	663	669	6.9647276486946039e+09
C663_669	663	669	1.2712898857803199e-16
R663_699	663	699	4.0364127782761455e+09
C663_699	663	699	2.1935783834232657e-16
R663_704	663	704	3.9040317228999195e+09
C663_704	663	704	2.2679600078718368e-16
R663_709	663	709	8.6171053708153820e+09
C663_709	663	709	1.0275130030308756e-16
R664_665	664	665	4.8287706684194489e+09
C664_665	664	665	1.8336318754806697e-16
R664_666	664	666	2.9877255464533768e+09
C664_666	664	666	2.9635211398551964e-16
R664_669	664	669	2.0067255417586164e+09
C664_669	664	669	4.4122565008269803e-16
R664_670	664	670	2.4642641833857207e+09
C664_670	664	670	3.5930351448094284e-16
R664_671	664	671	3.9916418166570301e+09
C664_671	664	671	2.2181819471004831e-16
R664_705	664	705	7.2711281081004679e+08
C664_705	664	705	1.2177185830539707e-15
R664_711	664	711	1.0419500928632056e+09
C664_711	664	711	8.4977081701382784e-16
R665_666	665	666	4.3839375115614079e+00
C665_666	665	666	2.8948867284968596e-16
R665_667	665	667	7.4717298866178306e-01
C665_667	665	667	1.1850251483071150e-16
R665_668	665	668	4.0419441650908521e+00
C665_668	665	668	2.1905764788814151e-17
R665_705	665	705	5.3297516260420275e+09
C665_705	665	705	1.6612758789240773e-16
R665_706	665	706	4.4353900590294284e+00
C665_706	665	706	2.1958850201083907e-16
R665_711	665	711	1.1512373838581738e+01
C665_711	665	711	1.2305629303378505e-16
R665_712	665	712	5.1571680333466547e+00
C665_712	665	712	1.7168701426341209e-17
R666_668	666	668	7.5335068002057914e-01
C666_668	666	668	1.1753076026636268e-16
R666_670	666	670	4.1533152419820656e+00
C666_670	666	670	2.3450198266944959e-16
R666_672	666	672	3.0626810308125205e+00
C666_672	666	672	2.8909924761740562e-17
R666_711	666	711	6.4483295935856715e+00
C666_711	666	711	1.0527083885301000e-16
R666_712	666	712	5.9150252814365070e+00
C666_712	666	712	1.4968977131488601e-17
R667_668	667	668	6.3465223906502075e+00
C667_668	667	668	1.3951243329802357e-17
R667_692	667	692	6.3598574234203200e+00
C667_692	667	692	1.3921991056582891e-17
R667_706	667	706	4.6306290159719730e+00
C667_706	667	706	1.9120918100888936e-17
R667_708	667	708	6.0121377177070414e+00
C667_708	667	708	1.4727187288013229e-17
R667_712	667	712	1.0751705331636302e+01
C667_712	667	712	8.2351473965223364e-18
R668_672	668	672	5.4457124326059017e+00
C668_672	668	672	1.6259007295328415e-17
R668_712	668	712	5.7592133309442808e+00
C668_712	668	712	1.5373953538804347e-17
R669_671	669	671	3.3556144265594411e+09
C669_671	669	671	2.6386189506517067e-16
R669_704	669	704	2.8477035188574028e+09
C669_704	669	704	3.1092379379973540e-16
R669_705	669	705	3.0875893970997920e+09
C669_705	669	705	2.8676701070799248e-16
R669_709	669	709	6.3399049962667923e+09
C669_709	669	709	1.3965805200888223e-16
R669_711	669	711	5.1932655524386797e+09
C669_711	669	711	1.7049364658123840e-16
R669_713	669	713	3.5929283360096779e+09
C669_713	669	713	2.4643374398147611e-16
R670_671	670	671	3.4311036338909240e+00
C670_671	670	671	2.8386220960383912e-16
R670_672	670	672	8.6276649912783165e-01
C670_672	670	672	1.0262554035130798e-16
R670_673	670	673	3.9862571076348794e+00
C670_673	670	673	2.2211783078521385e-17
R670_711	670	711	4.4070050758590940e+00
C670_711	670	711	1.5403228583418966e-16
R670_714	670	714	3.6390853136215942e+00
C670_714	670	714	2.4330805831502670e-17
R671_673	671	673	9.0822773210724694e+00
C671_673	671	673	9.7488630923620212e-18
R671_711	671	711	7.3771503813358565e+00
C671_711	671	711	1.9203486107307250e-16
R671_713	671	713	1.4531643699184345e+01
C671_713	671	713	6.7023433759988730e-17
R671_714	671	714	1.2109703094763307e+00
C671_714	671	714	7.3116473192715068e-17
R672_673	672	673	8.9225328614279587e+00
C672_673	672	673	9.9234017453458603e-18
R672_711	672	711	4.4604612315814061e+00
C672_711	672	711	1.9850386220845704e-17
R672_712	672	712	4.8550967276156971e+00
C672_712	672	712	1.8236892720669291e-17
R672_714	672	714	4.0292995279002985e+00
C672_714	672	714	2.1974508858650156e-17
R673_714	673	714	7.4838683261441821e+00
C673_714	673	714	1.1831031000463675e-17
R674_676	674	676	7.3028700092166138e+08
C674_676	674	676	1.2124257731310487e-15
R674_677	674	677	1.7213808193826811e+09
C674_677	674	677	5.1436542787639961e-16
R674_678	674	678	2.1134082554845850e+09
C674_678	674	678	4.1895302500225248e-16
R674_689	674	689	1.0581653381958294e+09
C674_689	674	689	8.3674899350761008e-16
R674_691	674	691	3.7387344810917735e+09
C674_691	674	691	2.3682312455669306e-16
R674_715	674	715	1.0305093769651848e+09
C674_715	674	715	8.5920497327984396e-16
R675_676	675	676	1.0875960579562376e+09
C675_676	675	676	8.1410628074897591e-16
R675_679	675	679	7.3285912575740213e+09
C675_679	675	679	1.2081705072375666e-16
R675_687	675	687	3.0904424981398749e+09
C675_687	675	687	2.8650226698375084e-16
R675_688	675	688	7.1577190639106150e+09
C675_688	675	688	1.2370124809232902e-16
R675_689	675	689	4.6558756459117422e+09
C675_689	675	689	1.9017234330076527e-16
R675_716	675	716	3.7840297409722476e+09
C675_716	675	716	2.3398832522719696e-16
R676_677	676	677	1.3092969866898768e+09
C676_677	676	677	6.7625511301182159e-16
R676_679	676	679	1.0450050634576206e+09
C676_679	676	679	8.4728659473706717e-16
R676_689	676	689	1.5659299591473465e+09
C676_689	676	689	5.6542681013786417e-16
R676_715	676	715	1.0517861117447262e+09
C676_715	676	715	8.4182399046061540e-16
R676_716	676	716	2.5335867510328002e+09
C676_716	676	716	3.4947245494517406e-16
R677_678	677	678	2.4100624548908054e+00
C677_678	677	678	5.2658396860315664e-16
R677_679	677	679	2.7652889562113114e+00
C677_679	677	679	3.5220936195776489e-16
R677_680	677	680	2.3718438982325041e+00
C677_680	677	680	3.7330398613492794e-17
R677_681	677	681	6.2074545266972214e-01
C677_681	677	681	1.4263798113896162e-16
R677_715	677	715	5.0488240853550836e+00
C677_715	677	715	2.8059406005138339e-16
R677_717	677	717	2.3104609872733657e+00
C677_717	677	717	3.8322169756473822e-17
R678_680	678	680	5.5263027960173450e-01
C678_680	678	680	1.6021901339501291e-16
R678_691	678	691	4.4314298952000089e+00
C678_691	678	691	2.1978473809345471e-16
R678_693	678	693	3.2433630695769975e+00
C678_693	678	693	2.7299403819612378e-17
R678_715	678	715	4.7124093073264106e+00
C678_715	678	715	1.4404968270945514e-16
R678_717	678	717	4.2356314346359056e+00
C678_717	678	717	2.0904056345877758e-17
R679_681	679	681	2.6464142562480308e+00
C679_681	679	681	3.3457300935013385e-17
R679_682	679	682	1.3154984129109137e+00
C679_682	679	682	6.7306716071269106e-17
R679_715	679	715	9.3534684347230801e+00
C679_715	679	715	1.0412828841976784e-16
R679_716	679	716	7.8929904695724611e+00
C679_716	679	716	1.2339564613066052e-16
R679_717	679	717	4.0115694502794179e+00
C679_717	679	717	2.2071630384918996e-17
R680_681	680	681	4.7236684317378428e+00
C680_681	680	681	1.8744304230816930e-17
R680_693	680	693	1.0563955124430203e+01
C680_693	680	693	8.3815083580995210e-18
R680_717	680	717	6.8243650008899834e+00
C680_717	680	717	1.2974376100699924e-17
R681_682	681	682	5.0641626364031591e+00
C681_682	681	682	1.7484011578444726e-17
R681_717	681	717	4.7092016668557717e+00
C681_717	681	717	1.8801887120947495e-17
R682_717	682	717	7.4085071396985649e+00
C682_717	682	717	1.1951379205069183e-17
R682_716	682	716	1.3610421147441016e+01
C682_716	682	716	6.5054473488241282e-18
R682_718	682	718	2.1776673835905637e+01
C682_718	682	718	4.0659045930150787e-18
R683_685	683	685	3.2614873502473931e+09
C683_685	683	685	2.7147699396498912e-16
R683_697	683	697	3.8116412991328106e+09
C683_697	683	697	2.3229331204419535e-16
R683_700	683	700	2.8800420045363221e+09
C683_700	683	700	3.0743259310294323e-16
R683_719	683	719	1.3157431814613951e+10
C683_719	683	719	6.7294194959579114e-17
R684_685	684	685	9.0281936812056577e+08
C684_685	684	685	9.8072639219427767e-16
R684_686	684	686	1.9970017832636864e+09
C684_686	684	686	4.4337405660848532e-16
R684_687	684	687	1.7799310568313370e+09
C684_687	684	687	4.9744554897324906e-16
R684_695	684	695	3.1730142780026565e+09
C684_695	684	695	2.7904657972650280e-16
R684_696	684	696	1.6264468046711457e+09
C684_696	684	696	5.4438840493097107e-16
R684_721	684	721	3.7436741310235963e+09
C684_721	684	721	2.3651064454638004e-16
R685_686	685	686	1.2172364768087490e+09
C685_686	685	686	7.2740079562955479e-16
R685_696	685	696	2.7361281796771154e+09
C685_696	685	696	3.2360281520308244e-16
R685_697	685	697	1.4931371984976943e+09
C685_697	685	697	5.9299224652018297e-16
R685_700	685	700	2.8406902147054610e+09
C685_700	685	700	3.1169142524462323e-16
R685_721	685	721	2.1349063700180194e+09
C685_721	685	721	4.1473424508660160e-16
R686_687	686	687	3.7218490575687156e+09
C686_687	686	687	2.3789755253492112e-16
R686_688	686	688	4.3279819991653881e+09
C686_688	686	688	2.0458005182802176e-16
R686_697	686	697	2.4941259055523324e+09
C686_697	686	697	3.5500163794013493e-16
R686_721	686	721	3.0027209410166850e+09
C686_721	686	721	2.9487215065686658e-16
R687_688	687	688	1.2958857146997669e+09
C687_688	687	688	6.8325375583381239e-16
R687_689	687	689	1.0403947077740799e+09
C687_689	687	689	8.5104122030219634e-16
R687_695	687	695	1.7833833312915862e+09
C687_695	687	695	4.9648259359851145e-16
R687_696	687	696	4.2829575567881017e+09
C687_696	687	696	2.0673069250865936e-16
R687_716	687	716	7.5316742465329170e+09
C687_716	687	716	1.1755935701913665e-16
R687_720	687	720	1.8829135454596756e+09
C687_720	687	720	4.7023868081199816e-16
R687_721	687	721	2.5787432900747600e+09
C687_721	687	721	3.4335282038652669e-16
R687_723	687	723	5.4535192052596464e+09
C687_723	687	723	1.6235732347766523e-16
R688_716	688	716	8.0710430743325567e+09
C688_716	688	716	1.0970314165659695e-16
R688_721	688	721	2.1236352271220868e+09
C688_721	688	721	4.1693543711831533e-16
R688_720	688	720	5.9264094022053261e+09
C688_720	688	720	1.4940223018857243e-16
R688_697	688	697	1.0117805486849571e+10
C688_697	688	697	8.7510951149516222e-17
R688_722	688	722	6.2086259186290016e+09
C688_722	688	722	1.4261106939029749e-16
R688_723	688	723	7.6736153804333410e+09
C688_723	688	723	1.1538482681288611e-16
R688_724	688	724	1.0345813478063862e+10
C688_724	688	724	8.5582325988898395e-17
R689_690	689	690	2.3130719519323568e+09
C689_690	689	690	3.8278912204192998e-16
R689_691	689	691	4.1346950977581196e+09
C689_691	689	691	2.1414366979081109e-16
R689_695	689	695	1.2832994762461658e+09
C689_695	689	695	6.8995491550419434e-16
R689_715	689	715	1.3055714448900554e+09
C689_715	689	715	6.7818485550177058e-16
R689_716	689	716	4.2056358050150375e+09
C689_716	689	716	2.1053149220485920e-16
R689_720	689	720	3.1315319025921359e+09
C689_720	689	720	2.8274301819090256e-16
R689_723	689	723	2.5942940666273522e+09
C689_723	689	723	3.4129468709423018e-16
R689_725	689	725	1.7398658006365652e+09
C689_725	689	725	5.0890061829829167e-16
R690_691	690	691	2.8910509627821593e+09
C690_691	690	691	3.0626190720897247e-16
R690_695	690	695	4.9117164887073431e+09
C690_695	690	695	1.8026667128196216e-16
R690_702	690	702	1.7296880347728767e+09
C690_702	690	702	5.1189507234827078e-16
R690_703	690	703	4.6410349194106340e+09
C690_703	690	703	1.9078046105553532e-16
R690_706	690	706	7.2584518239597778e+09
C690_706	690	706	1.2198452275694357e-16
R690_707	690	707	2.2330300840276308e+09
C690_707	690	707	3.9651001033671882e-16
R690_725	690	725	2.6973068487801929e+09
C690_725	690	725	3.2826030976060963e-16
R691_692	691	692	1.5650605559995256e+00
C691_692	691	692	5.6574090906950736e-17
R691_693	691	693	7.7042185579449862e-01
C691_693	691	693	1.1492648800661435e-16
R691_706	691	706	1.0288781580930998e+01
C691_706	691	706	1.3769074962390303e-16
R691_707	691	707	5.5525756546237508e+00
C691_707	691	707	1.2225336631877925e-16
R691_715	691	715	1.2470181058084322e+01
C691_715	691	715	1.1360460942758960e-16
R691_725	691	725	5.5356110489689208e+00
C691_725	691	725	1.7594456154527919e-16
R691_726	691	726	5.1969733575550601e+00
C691_726	691	726	1.7037200708616859e-17
R692_693	692	693	2.0149090793650868e+00
C692_693	692	693	4.3943361552522374e-17
R692_706	692	706	6.7515895679623050e-01
C692_706	692	706	1.3114226994802766e-16
R692_707	692	707	2.3028188278288084e+00
C692_707	692	707	3.8449346123108126e-17
R692_708	692	708	4.4539391035673059e-01
C692_708	692	708	1.9879454144104465e-16
R692_726	692	726	2.3309263519299619e+00
C692_726	692	726	3.7985703879785410e-17
R693_708	693	708	1.1200190187399281e+01
C693_708	693	708	7.9053905950287888e-18
R693_715	693	715	6.4532718040727675e+00
C693_715	693	715	1.3720463178711882e-17
R693_717	693	717	9.7163349802541372e+00
C693_717	693	717	9.1126827502281252e-18
R693_725	693	725	5.9027305153685958e+00
C693_725	693	725	1.5000155934523637e-17
R693_726	693	726	4.3659875468848321e+00
C693_726	693	726	2.0279919999582994e-17
R693_727	693	727	5.7260844231919457e+00
C693_727	693	727	1.5462901282311737e-17
R694_695	694	695	4.2702591572185593e+09
C694_695	694	695	2.0734544417597344e-16
R694_696	694	696	6.1830704495494308e+09
C694_696	694	696	1.4320050028938642e-16
R694_698	694	698	1.6501635338635228e+09
C694_698	694	698	5.3656426380176506e-16
R694_699	694	699	5.2989643084825945e+09
C694_699	694	699	1.6709279967834838e-16
R694_702	694	702	3.2522946271141219e+09
C694_702	694	702	2.7224433306820795e-16
R694_703	694	703	3.4163718584682064e+09
C694_703	694	703	2.5916932300718407e-16
R694_704	694	704	3.4606430171012440e+09
C694_704	694	704	2.5585383332651802e-16
R694_709	694	709	6.5481599879888573e+09
C694_709	694	709	1.3521642466343275e-16
R694_710	694	710	2.2118964667837901e+09
C694_710	694	710	4.0029847463314773e-16
R694_728	694	728	1.7528308261043313e+09
C694_728	694	728	5.0513647324873017e-16
R695_696	695	696	1.4390868852896852e+09
C695_696	695	696	6.1526429762562056e-16
R695_702	695	702	1.2275841703904181e+09
C695_702	695	702	7.2126930523908886e-16
R695_720	695	720	1.2303837627634203e+09
C695_720	695	720	7.1962814245155936e-16
R695_725	695	725	5.0553318280038671e+09
C695_725	695	725	1.7514553185119281e-16
R695_728	695	728	4.3680097572877636e+09
C695_728	695	728	2.0270531223579155e-16
R696_698	696	698	9.8043402591553271e+08
C696_698	696	698	9.0308858964089188e-16
R696_700	696	700	2.5302511186123748e+09
C696_700	696	700	3.4993316480997196e-16
R696_720	696	720	1.1571531678950913e+09
C696_720	696	720	7.6516990685910039e-16
R696_721	696	721	9.0377541244851029e+08
C696_721	696	721	9.7968894650632452e-16
R696_728	696	728	1.5380061269791672e+09
C696_728	696	728	5.7569262317509179e-16
R696_729	696	729	2.9205300119225688e+09
C696_729	696	729	3.0317058139633153e-16
R697_700	697	700	3.5870043984366951e+09
C697_700	697	700	2.4684072929653708e-16
R697_719	697	719	3.7812626431479564e+09
C697_719	697	719	2.3415955601615552e-16
R697_721	697	721	1.1306512289088058e+09
C697_721	697	721	7.8310513362685665e-16
R697_724	697	724	2.5740788983907080e+09
C697_724	697	724	3.4397499713530786e-16
R697_729	697	729	5.8203499940785170e+09
C697_729	697	729	1.5212466305304730e-16
R698_699	698	699	2.1648586867895427e+09
C698_699	698	699	4.0899611004774852e-16
R698_700	698	700	2.2594504190407128e+09
C698_700	698	700	3.9187351678020855e-16
R698_701	698	701	1.1852573915312588e+09
C698_701	698	701	7.4702658513363842e-16
R698_709	698	709	4.9287547332753248e+09
C698_709	698	709	1.7964350624353529e-16
R698_728	698	728	8.9669347800374472e+08
C698_728	698	728	9.8742636521808476e-16
R698_729	698	729	4.3241178584224491e+09
C698_729	698	729	2.0476286972044374e-16
R698_730	698	730	8.7675823597490346e+08
C698_730	698	730	1.0098779177311825e-15
R699_701	699	701	2.5087820512064276e+09
C699_701	699	701	3.5292774088295881e-16
R699_704	699	704	3.8112011299873662e+09
C699_704	699	704	2.3232014042327261e-16
R699_709	699	709	2.2896467277714114e+09
C699_709	699	709	3.8670541221955552e-16
R699_730	699	730	6.5828284585800543e+09
C699_730	699	730	1.3450430727021998e-16
R700_701	700	701	5.4181618888537254e+09
C700_701	700	701	1.6341681918391714e-16
R700_719	700	719	8.5166104993590164e+09
C700_719	700	719	1.0396375198403629e-16
R700_721	700	721	6.0966156678454866e+09
C700_721	700	721	1.4523119545977590e-16
R700_729	700	729	2.2519313670575671e+09
C700_729	700	729	3.9318195689814089e-16
R700_730	700	730	1.0215938534711615e+10
C700_730	700	730	8.6670331726403098e-17
R701_730	701	730	8.5299408331169815e+09
C701_730	701	730	1.0380128057423505e-16
R702_703	702	703	2.7911221251611123e+09
C702_703	702	703	3.1722681487786610e-16
R702_707	702	707	1.5594697502943571e+09
C702_707	702	707	5.6776912891889908e-16
R702_710	702	710	1.4457243529919369e+09
C702_710	702	710	6.1243955659155905e-16
R702_725	702	725	1.8962291221892478e+09
C702_725	702	725	4.6693660135214060e-16
R702_720	702	720	2.8219002470887046e+09
C702_720	702	720	3.1376686068668384e-16
R702_728	702	728	1.3509971903058298e+09
C702_728	702	728	6.5538166034199152e-16
R702_731	702	731	1.8156324056587250e+09
C702_731	702	731	4.8766412129484089e-16
R703_704	703	704	1.9744720881653407e+09
C703_704	703	704	4.4843317209043061e-16
R703_705	703	705	2.8367286569469929e+09
C703_705	703	705	3.1212670959263514e-16
R703_706	703	706	3.0832832134015098e+09
C703_706	703	706	2.8716751605934927e-16
R703_707	703	707	4.6221584434172897e+09
C703_707	703	707	1.9155959116048502e-16
R703_710	703	710	2.2837805596971989e+09
C703_710	703	710	3.8769871209403571e-16
R703_732	703	732	4.8174823411167555e+09
C703_732	703	732	1.8379284427117349e-16
R704_705	704	705	6.9942254199953496e+08
C704_705	704	705	1.2659282887404975e-15
R704_709	704	709	8.7093371783676195e+08
C704_709	704	709	1.0166316489608606e-15
R704_710	704	710	1.4738232260799134e+09
C704_710	704	710	6.0076321639674789e-16
R704_713	704	713	3.9923123389077334e+09
C704_713	704	713	2.2178093960009254e-16
R704_732	704	732	2.4551012986364455e+09
C704_732	704	732	3.6064450057183325e-16
R705_706	705	706	2.5552362820388150e+09
C705_706	705	706	3.4651150968846114e-16
R705_711	705	711	7.8026034212169445e+08
C705_711	705	711	1.1347735286562913e-15
R705_713	705	713	3.7607297016004505e+09
C705_713	705	713	2.3543802717945751e-16
R705_732	705	732	2.1510003912197928e+09
C705_732	705	732	4.1163115790876044e-16
R706_707	706	707	2.0744029386056559e+00
C706_707	706	707	3.6280606331305250e-16
R706_708	706	708	7.7066291451905589e-01
C706_708	706	708	1.1489053969238409e-16
R706_711	706	711	9.5971193009838327e+00
C706_711	706	711	1.0148468809762484e-16
R706_712	706	712	3.5365628359006069e+00
C706_712	706	712	2.5036138838305778e-17
R706_732	706	732	4.4257653228075409e+00
C706_732	706	732	2.2006604233551976e-16
R706_733	706	733	4.0416091105336243e+00
C706_733	706	733	2.1907580804693306e-17
R707_708	707	708	4.7051201044580733e+00
C707_708	707	708	1.8818197241364166e-17
R707_710	707	710	4.9719802611045113e+09
C707_710	707	710	1.7808171698238136e-16
R707_725	707	725	4.9223169644929063e+00
C707_725	707	725	2.8780553117853507e-16
R707_726	707	726	1.0397628070799176e+00
C707_726	707	726	8.5155842820212110e-17
R707_731	707	731	5.6153019602142962e+00
C707_731	707	731	1.7344760189154108e-16
R707_732	707	732	7.8582932290384209e+00
C707_732	707	732	1.8027706619040809e-16
R707_733	707	733	4.0349470916739270e+00
C707_733	707	733	2.1943751964605753e-17
R708_712	708	712	8.9546192799631488e+00
C708_712	708	712	9.8878439609511117e-18
R708_726	708	726	2.5596562084794408e+00
C708_726	708	726	3.4591316551295052e-17
R708_733	708	733	4.0563197239753768e+00
C708_733	708	733	2.1828130964791148e-17
R709_710	709	710	3.4369030154393559e+09
C709_710	709	710	2.5762111346246782e-16
R709_713	709	713	5.7057243103646441e+09
C709_713	709	713	1.5518078574031460e-16
R709_728	709	728	5.0988042974608364e+09
C709_728	709	728	1.7365223884763171e-16
R709_730	709	730	6.7206066216366043e+09
C709_730	709	730	1.3174685434636891e-16
R709_732	709	732	6.6754777740256310e+09
C709_732	709	732	1.3263751474765984e-16
R709_734	709	734	5.0597861492862635e+09
C709_734	709	734	1.7499134460947482e-16
R710_728	710	728	1.8099588514316683e+09
C710_728	710	728	4.8919276866412644e-16
R710_731	710	731	4.1335815589932866e+09
C710_731	710	731	2.1420135760322081e-16
R710_732	710	732	1.5297087654055662e+09
C710_732	710	732	5.7881526322120028e-16
R710_734	710	734	6.1759111311008101e+09
C710_734	710	734	1.4336650299923936e-16
R711_712	711	712	6.9309008896896385e-01
C711_712	711	712	1.2774945072683746e-16
R711_713	711	713	6.2032237751347417e+00
C711_713	711	713	1.5700878997789884e-16
R711_714	711	714	4.0464119853082972e+00
C711_714	711	714	2.1881577677082230e-17
R711_732	711	732	6.5969275034318215e+00
C711_732	711	732	1.0289957941243401e-16
R711_735	711	735	5.8516416132366764e+00
C711_735	711	735	1.5131117731084949e-17
R712_714	712	714	1.0836240861104491e+01
C712_714	712	714	8.1709034807274787e-18
R712_732	712	732	5.9018049676926934e+00
C712_732	712	732	1.5002508326637468e-17
R712_733	712	733	6.4790631006126729e+00
C712_733	712	733	1.3665845940229740e-17
R712_735	712	735	6.5343710394977945e+00
C712_735	712	735	1.3550176081951568e-17
R713_714	713	714	1.4064034218167388e+01
C713_714	713	714	6.2956244841629396e-18
R713_732	713	732	1.0597048090119882e+01
C713_732	713	732	1.7546201753909435e-16
R713_734	713	734	2.2502454726565364e+01
C713_734	713	734	4.3282418328620222e-17
R713_735	713	735	1.8752045624223166e+00
C713_735	713	735	4.7217183631222103e-17
R714_735	714	735	7.2908251594920586e+00
C714_735	714	735	1.2144287681172236e-17
R715_716	715	716	4.0519906936650791e+00
C715_716	715	716	2.4036596639245471e-16
R715_717	715	717	4.3266285462217202e-01
C715_717	715	717	2.0464404841806968e-16
R715_723	715	723	5.8872958925789733e+00
C715_723	715	723	1.6543429728472319e-16
R715_725	715	725	2.3626076011924728e+00
C715_725	715	725	2.2485802064051485e-16
R715_727	715	727	2.9401782131765750e+00
C715_727	715	727	3.0114459651865510e-17
R715_736	715	736	2.4513090738954570e+00
C715_736	715	736	3.6120242491207019e-17
R716_717	716	717	7.8161101025489179e+00
C716_717	716	717	1.1328125756714397e-17
R716_718	716	718	2.6108360875497971e+00
C716_718	716	718	3.3913227487633777e-17
R716_722	716	722	1.5665016517466285e+01
C716_722	716	722	3.3913227487633746e-17
R716_723	716	723	1.2778169315530144e+01
C716_723	716	723	1.4551219286094574e-16
R716_736	716	736	5.6480474669080252e+00
C716_736	716	736	1.5676546397452903e-17
R717_718	717	718	7.6758787778785065e+00
C717_718	717	718	1.1535080312259909e-17
R717_727	717	727	6.9170948851734062e+00
C717_727	717	727	1.2800442908450912e-17
R717_736	717	736	5.3277443513604199e+00
C717_736	717	736	1.6619017792659511e-17
R717_737	717	737	1.1891066447412207e+01
C717_737	717	737	7.4460838783109247e-18
R718_736	718	736	4.3834066891907870e+00
C718_736	718	736	2.0199329984219547e-17
R718_722	718	722	1.5196875253261105e+01
C718_722	718	722	5.8263213124026759e-18
R718_737	718	737	9.2542807123906403e+00
C718_737	718	737	9.5676672149625269e-18
R718_738	718	738	1.2157500202608901e+01
C718_738	718	738	7.2829016405033364e-18
R719_724	719	724	4.2598094302449589e+09
C719_724	719	724	2.0785408272338709e-16
R719_729	719	729	3.4046241613127689e+09
C719_729	719	729	2.6006358991431134e-16
R719_739	719	739	1.6414149801129194e+10
C719_739	719	739	5.3942408984173439e-17
R720_721	720	721	1.0341854052624806e+09
C720_721	720	721	8.5615091568158159e-16
R720_722	720	722	4.3256059620399647e+09
C720_722	720	722	2.0469242678832330e-16
R720_723	720	723	9.4382648800561106e+08
C720_723	720	723	9.3811605517765075e-16
R720_725	720	725	2.8465146692007651e+09
C720_725	720	725	3.1105365142861007e-16
R720_728	720	728	2.3042948929225440e+09
C720_728	720	728	3.8424716576836265e-16
R720_729	720	729	5.4631777180239964e+09
C720_729	720	729	1.6207028718447978e-16
R720_731	720	731	2.3569902362585006e+09
C720_731	720	731	3.7565653352281975e-16
R720_740	720	740	1.4566699725089674e+09
C720_740	720	740	6.0783760111081000e-16
R721_722	721	722	4.2641181911854615e+09
C721_722	721	722	2.0764405253360155e-16
R721_724	721	724	1.1723930595335033e+09
C721_724	721	724	7.5522349309395353e-16
R721_729	721	729	2.5656174128972669e+09
C721_729	721	729	3.4510943730309579e-16
R721_740	721	740	3.8481129565749640e+09
C721_740	721	740	2.3009168173900807e-16
R722_723	722	723	7.3157485347594466e+00
C722_723	722	723	1.9364662985119639e-16
R722_724	722	724	4.0994991996764970e+09
C722_724	722	724	2.1598218186501195e-16
R722_736	722	736	3.3365100225640103e+00
C722_736	722	736	2.6537273249956603e-17
R722_738	722	738	1.7230665813725310e+00
C722_738	722	738	5.1386219851975093e-17
R722_740	722	740	3.5324350351232989e+00
C722_740	722	740	3.5927065592405687e-16
R722_739	722	739	2.0676798955793572e+01
C722_739	722	739	4.7104034864310505e-17
R723_725	723	725	5.2485854686514593e+00
C723_725	723	725	2.6991463834521228e-16
R723_731	723	731	8.3357201863809287e+00
C723_731	723	731	1.1684181295904298e-16
R723_736	723	736	1.9123531036979122e-01
C723_736	723	736	4.6299963118101362e-16
R723_740	723	740	4.9905669818355909e+00
C723_740	723	740	1.9516032195159617e-16
R724_729	724	729	2.6604554974012809e+09
C724_729	724	729	3.3280721386426964e-16
R724_739	724	739	4.3362454706765547e+09
C724_739	724	739	2.0419018888288499e-16
R724_740	724	740	3.5572966664694710e+09
C724_740	724	740	2.4890214809628356e-16
R725_726	725	726	2.5201675718833911e+00
C725_726	725	726	3.5133329687212117e-17
R725_727	725	727	1.2862661802979589e+00
C725_727	725	727	6.8836357144591652e-17
R725_731	725	731	4.3324462120219236e+00
C725_731	725	731	1.7371386211147196e-16
R725_736	725	736	3.1040207243041178e+00
C725_736	725	736	2.8524899166016354e-17
R725_741	725	741	6.0215471144011667e+00
C725_741	725	741	1.4704174274123460e-17
R726_727	726	727	4.1878383177052063e+00
C726_727	726	727	2.1142620954506654e-17
R726_731	726	731	5.2524564058046401e+00
C726_731	726	731	1.6857232374579985e-17
R726_733	726	733	4.8469871312768174e+00
C726_733	726	733	1.8267405250295326e-17
R726_741	726	741	5.4585953763344994e+00
C726_741	726	741	1.6220634076280764e-17
R727_736	727	736	4.8489501860210105e+00
C727_736	727	736	1.8260009852288542e-17
R727_737	727	737	1.1317486685787896e+01
C727_737	727	737	7.8234576835144672e-18
R727_741	727	741	9.9951990763822458e+00
C727_741	727	741	8.8584406867109317e-18
R728_729	728	729	1.1889703129104013e+10
C728_729	728	729	7.4469376744373219e-17
R728_730	728	730	4.5713431520756636e+09
C728_730	728	730	1.9368897766906146e-16
R728_731	728	731	5.3742327206987371e+09
C728_731	728	731	1.6475259403818323e-16
R728_734	728	734	1.1331068738428734e+10
C728_734	728	734	7.8140800496351062e-17
R728_740	728	740	2.0001012642123466e+10
C728_740	728	740	4.4268697667599542e-17
R728_742	728	742	1.4278711042087500e+10
C728_742	728	742	6.2009713558189283e-17
R729_730	729	730	1.1926005440058701e+10
C729_730	729	730	7.4242694769024197e-17
R729_739	729	739	1.3253747717501404e+10
C729_739	729	739	6.6805163382642024e-17
R729_740	729	740	6.9679617153181038e+09
C729_740	729	740	1.2706998371611730e-16
R729_742	729	742	8.1997465651736917e+09
C729_742	729	742	1.0798123754953453e-16
R730_734	730	734	7.4597320931732779e+09
C730_734	730	734	1.1869310729138450e-16
R730_742	730	742	8.4970749087823944e+09
C730_742	730	742	1.0420277462598928e-16
R731_732	731	732	7.5800731624399740e+00
C731_732	731	732	8.9553365906951824e-17
R731_733	731	733	5.5115084391004734e+00
C731_733	731	733	1.6064908390932413e-17
R731_734	731	734	1.1887779939342522e+01
C731_734	731	734	1.1917027870835122e-16
R731_736	731	736	5.5247808194510215e+00
C731_736	731	736	1.6026315081726285e-17
R731_740	731	740	5.3877543010842572e+00
C731_740	731	740	1.8077302795712766e-16
R731_741	731	741	8.3085097864139257e-01
C731_741	731	741	1.0656770040132068e-16
R731_742	731	742	7.5231548025495636e+00
C731_742	731	742	9.0230904897424563e-17
R731_743	731	743	5.9134300421253618e+00
C731_743	731	743	1.4973015244833597e-17
R732_733	732	733	6.5402237183858514e-01
C732_733	732	733	1.3538050376027876e-16
R732_734	732	734	4.5048089954297454e+00
C732_734	732	734	2.1620465149224964e-16
R732_735	732	735	3.0928242050085761e+00
C732_735	732	735	2.8628163872558182e-17
R732_743	732	743	4.3517176209369337e+00
C732_743	732	743	2.0346420857825964e-17
R733_735	733	735	1.0094929395243147e+01
C733_735	733	735	8.7709259474090051e-18
R733_741	733	741	9.7994375883689742e+00
C733_741	733	741	9.0354040598300276e-18
R733_743	733	743	5.9872578176683540e+00
C733_743	733	743	1.4788385746261600e-17
R734_735	734	735	1.6411566615477447e+01
C734_735	734	735	5.3950899536000283e-18
R734_742	734	742	2.6258506532246880e+01
C734_742	734	742	7.0810555641000450e-17
R734_743	734	743	2.1882088820636576e+00
C734_743	734	743	4.0463174652000252e-17
R735_743	735	743	1.1548121390053131e+01
C735_743	735	743	7.6672105513425535e-18
R736_737	736	737	3.1919074397040242e-01
C736_737	736	737	2.7739488015420088e-16
R736_738	736	738	4.7912966095734468e+00
C736_738	736	738	1.8479732186290715e-17
R736_740	736	740	3.0853334318064598e+00
C736_740	736	740	2.8697669191027699e-17
R736_741	736	741	4.5517839517093712e+00
C736_741	736	741	1.9452126706661705e-17
R736_744	736	744	5.1240012283644685e+00
C736_744	736	744	1.7279831565977533e-17
R737_738	737	738	5.7426906801203437e+00
C737_738	737	738	1.5418186892166814e-17
R737_741	737	741	7.3482599507499282e+00
C737_741	737	741	1.2049366620592110e-17
R737_744	737	744	5.3036330198961261e+00
C737_744	737	744	1.6694571030431916e-17
R738_740	738	740	2.8227090598091480e+00
C738_740	738	740	3.1367695463444813e-17
R738_739	738	739	1.1568152767448757e+01
C738_739	738	739	7.6539340333700529e-18
R738_744	738	744	3.3063389118817024e+00
C738_744	738	744	2.6779432033363178e-17
R738_745	738	745	9.2545222139590049e+00
C738_745	738	745	9.5674175417125676e-18
R739_740	739	740	3.4040513703493662e+00
C739_740	739	740	2.8611808487369548e-16
R739_742	739	742	1.0995655924048803e+01
C739_742	739	742	8.8576858499716425e-17
R739_745	739	745	1.3744569918805560e+00
C739_745	739	745	6.4419533454339251e-17
R740_741	740	741	1.2898320410833544e+00
C740_741	740	741	6.8646052625295307e-17
R740_742	740	742	1.1195241158594420e+00
C740_742	740	742	6.7225524954661784e-16
R740_744	740	744	3.6306787380422834e-01
C740_744	740	744	2.4387142063068655e-16
R740_745	740	745	1.6990632299662154e+00
C740_745	740	745	5.2112173701599428e-17
R740_746	740	746	1.5699671892051026e+00
C740_746	740	746	5.6397279369150410e-17
R741_742	741	742	2.5864017896132756e+00
C741_742	741	742	3.4233613093516678e-17
R741_743	741	743	3.0517889117485595e+00
C741_743	741	743	2.9013106977726346e-17
R741_744	741	744	1.9411293664077371e+00
C741_744	741	744	4.5613589543419256e-17
R741_746	741	746	2.7178328272054819e+00
C741_746	741	746	3.2578117860560301e-17
R742_743	742	743	3.0112921871411817e+00
C742_743	742	743	2.9403283596354912e-17
R742_745	742	745	4.5169382807117744e+00
C742_745	742	745	1.9602189064236601e-17
R742_746	742	746	6.0225843742823637e-01
C742_746	742	746	1.4701641798177456e-16
R743_746	743	746	8.7106339131003025e+00
C743_746	743	746	1.0164803050308199e-17
R744_745	744	745	6.2805583048466609e+00
C744_745	744	745	1.4097771865547827e-17
R744_746	744	746	4.0919160319850780e+00
C744_746	744	746	2.1638244156991270e-17
R745_746	745	746	5.7711524835015879e+00
C745_746	745	746	1.5342148457023289e-17
.control
quit 13

.endc
.end
.END
