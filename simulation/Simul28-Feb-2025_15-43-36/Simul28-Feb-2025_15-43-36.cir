Simul28-Feb-2025_15-43-36.cir
********************************************************************************
*
*                        Spice Netlist Generated by
*
*                              BIOCAD Program
*                               Release 1.0
*
*   Authors: Vincent Senez
*
*   Release 1.0 : January 2019
*
********************************************************************************
.CONTROL
  DESTROY ALL
  AC DEC 9.000000 1000.000000 100000000.000000
  WRITE Simul28-Feb-2025_15-43-36.spi vdb(30,616)-vdb(616)-66 vp(30,616)-vp(616)
  DESTROY ALL
  AC DEC 1 1000.000000 1000.000000
  WRITE Simul28-Feb-2025_15-43-36_1000Hz.spi_cou all
  DESTROY ALL
  AC DEC 1 5000000.000000 5000000.000000
  WRITE Simul28-Feb-2025_15-43-36_5000000Hz.spi_cou all
  DESTROY ALL
  AC DEC 1 100000000.000000 100000000.000000
  WRITE Simul28-Feb-2025_15-43-36_100000000Hz.spi_cou all
.ENDC
Vin	30	0	DC 0 AC 0.025000
Rg	616	0	50e-5
R1_2	1	2	1.3907001536864883e+05
C1_2	1	2	5.0933698646853198e-16
R1_3	1	3	3.8877780738217822e+04
C1_3	1	3	1.8219533417546370e-15
R1_5	1	5	4.0855903764959927e+04
C1_5	1	5	1.7337397048783530e-15
R1_9	1	9	1.3907001536864878e+05
C1_9	1	9	5.0933698646853208e-16
R1_11	1	11	4.0711577755050341e+04
C1_11	1	11	1.7398859597676244e-15
R1_12	1	12	1.3907001536864892e+05
C1_12	1	12	5.0933698646853159e-16
R2_3	2	3	3.3501232767498674e+04
C2_3	2	3	2.1143551053058370e-15
R2_5	2	5	4.7987927316338581e+04
C2_5	2	5	1.4760692219328911e-15
R2_7	2	7	3.9674742621401914e+04
C2_7	2	7	1.7853550610758090e-15
R2_13	2	13	8.9905880066346857e+04
C2_13	2	13	7.8786284594208711e-16
R2_6	2	6	1.7824542150644792e+05
C2_6	2	6	3.9739311078707085e-16
R3_5	3	5	2.3524343856670599e+04
C3_5	3	5	3.0110724008956520e-15
R3_7	3	7	5.2608053664643259e+04
C3_7	3	7	1.3464383797115401e-15
R3_9	3	9	2.3757455468134798e+04
C3_9	3	9	2.9815273201714292e-15
R3_11	3	11	3.0120815937560241e+04
C3_11	3	11	2.3516462064917578e-15
R3_13	3	13	3.5244764272298176e+04
C3_13	3	13	2.0097595770181963e-15
R3_16	3	16	1.6285697339052005e+04
C3_16	3	16	4.3494301202654715e-15
R3_8	3	8	5.4003752760096082e+04
C3_8	3	8	1.3116403752655429e-15
R4_17	4	17	1.0349154297010113e+04
C4_17	4	17	6.8443759270710582e-15
R4_13	4	13	6.7918154645339266e+04
C4_13	4	13	1.0429244272887620e-15
R4_8	4	8	3.1785815986839898e+04
C4_8	4	8	2.2284626125478987e-15
R4_23	4	23	2.7416055946034307e+04
C4_23	4	23	2.5836503498325394e-15
R4_25	4	25	7.1829776487118424e+03
C4_25	4	25	9.8613007028781347e-15
R4_24	4	24	4.8541579446697961e+03
C4_24	4	24	1.4592335754912989e-14
R4_26	4	26	4.4475495943717753e+04
C4_26	4	26	1.5926410944497938e-15
R4_29	4	29	9.0927646548817411e+03
C4_29	4	29	7.7900952267549112e-15
R4_30	4	30	1.5690186625966579e+04
C4_30	4	30	4.5145098796195088e-15
R4_31	4	31	3.9544602338829107e+04
C4_31	4	31	1.7912306192657835e-15
R4_33	4	33	2.4995602494071092e+04
C4_33	4	33	2.8338385743172856e-15
R5_7	5	7	2.0546145895594778e+04
C5_7	5	7	3.4475323447979197e-15
R5_11	5	11	2.4078118070852393e+04
C5_11	5	11	2.9418205495780439e-15
R5_12	5	12	2.6799310396546964e+04
C5_12	5	12	2.6431091504924234e-15
R5_14	5	14	2.2136414484376426e+04
C5_14	5	14	3.1998634009131571e-15
R5_16	5	16	2.9665509061704055e+04
C5_16	5	16	2.3877393234232664e-15
R5_18	5	18	2.7368284797199714e+04
C5_18	5	18	2.5881600933664503e-15
R5_37	5	37	3.0191423078340227e+04
C5_37	5	37	2.3461465314901641e-15
R6_7	6	7	3.6101009569336100e+04
C6_7	6	7	1.9620920129659035e-15
R6_13	6	13	4.6247672093998226e+04
C6_13	6	13	1.5316122807658550e-15
R6_15	6	15	1.4223083407381180e+04
C6_15	6	15	4.9801790868526017e-15
R6_21	6	21	3.4792834262102006e+04
C6_21	6	21	2.0358646841586919e-15
R6_39	6	39	5.0884338649846024e+04
C6_39	6	39	1.3920491926490698e-15
R6_19	6	19	1.3517586799783114e+05
C6_19	6	19	5.2400997001281703e-16
R7_13	7	13	2.0608440632647133e+04
C7_13	7	13	3.4371112205252529e-15
R7_15	7	15	1.0323520946633975e+04
C7_15	7	15	6.8613705442323496e-15
R7_16	7	16	3.3503484886331869e+04
C7_16	7	16	2.1142129774355902e-15
R7_18	7	18	7.3310172451215039e+03
C7_18	7	18	9.6621655859746934e-15
R7_37	7	37	4.6893133661919128e+04
C7_37	7	37	1.5105303698976793e-15
R7_39	7	39	5.4908435339490068e+04
C7_39	7	39	1.2900295209296677e-15
R7_40	7	40	1.9835725661046748e+04
C7_40	7	40	3.5710063622780539e-15
R8_16	8	16	1.8983150444420691e+04
C8_16	8	16	3.7313881456815084e-15
R8_13	8	13	5.4042423555558438e+04
C8_13	8	13	1.3107018130521009e-15
R8_9	8	9	4.1534522038641669e+04
C8_9	8	9	1.7054127279976887e-15
R8_17	8	17	4.0528327739570064e+04
C8_17	8	17	1.7477529048611924e-15
R8_25	8	25	2.3002338995614089e+04
C8_25	8	25	3.0794043401197589e-15
R8_26	8	26	4.6705052478590755e+04
C8_26	8	26	1.5166132736596226e-15
R8_10	8	10	3.6910582564351746e+04
C8_10	8	10	1.9190567478176580e-15
R8_41	8	41	3.5013621857064776e+04
C8_41	8	41	2.0230270043231122e-15
R8_44	8	44	5.0654360442906975e+04
C8_44	8	44	1.3983692996348682e-15
R9_11	9	11	3.6371140391566696e+04
C9_11	9	11	1.9475194281349512e-15
R9_16	9	16	5.6584805797531328e+04
C9_16	9	16	1.2518113570885549e-15
R9_10	9	10	1.7794682889485176e+05
C9_10	9	10	3.9805993158695347e-16
R9_44	9	44	6.2052132689497339e+04
C9_44	9	44	1.1415160038164002e-15
R10_26	10	26	2.3061831289494712e+04
C10_26	10	26	3.0714604424439869e-15
R10_41	10	41	2.7729517804179410e+04
C10_41	10	41	2.5544440778311676e-15
R10_27	10	27	8.3294824819260364e+04
C10_27	10	27	8.5039499980581142e-16
R10_42	10	42	2.2679850346388539e+04
C10_42	10	42	3.1231909141446026e-15
R10_44	10	44	2.9268662093403822e+04
C10_44	10	44	2.4201141244499697e-15
R11_12	11	12	2.6248105856733793e+04
C11_12	11	12	2.6986138703729774e-15
R11_14	11	14	2.4227398734043050e+04
C11_14	11	14	2.9236940917007542e-15
R11_16	11	16	2.2828207901496917e+04
C11_16	11	16	3.1028937024598954e-15
R11_44	11	44	4.1697927434817691e+04
C11_44	11	44	1.6987295746707584e-15
R11_45	11	45	4.6059236842507322e+04
C11_45	11	45	1.5378783365040236e-15
R11_46	11	46	3.5881472847629826e+04
C11_46	11	46	1.9740968503938921e-15
R12_14	12	14	1.8442107529592620e+04
C12_14	12	14	3.8408572568150896e-15
R12_37	12	37	4.6801418657858965e+04
C12_37	12	37	1.5134905002309272e-15
R12_43	12	43	5.4495557160201286e+04
C12_43	12	43	1.2998032541950137e-15
R12_46	12	46	4.1441544929507305e+04
C12_46	12	46	1.7092389450366504e-15
R13_15	13	15	1.0100779889228454e+04
C13_15	13	15	7.0126765767401167e-15
R13_16	13	16	1.8167212352802784e+04
C13_16	13	16	3.8989747662123864e-15
R13_17	13	17	1.0379189699200369e+04
C13_17	13	17	6.8245696040662147e-15
R13_18	13	18	3.8493280139621354e+04
C13_18	13	18	1.8401524182682130e-15
R13_21	13	21	3.8255515018577535e+04
C13_21	13	21	1.8515893068385578e-15
R13_23	13	23	3.3273265841858556e+04
C13_23	13	23	2.1288413007805738e-15
R13_28	13	28	2.8652898912181492e+04
C13_28	13	28	2.4721234229422372e-15
R13_48	13	48	2.0143892854417278e+04
C13_48	13	48	3.5163760573948441e-15
R14_16	14	16	1.4231331931075611e+04
C14_16	14	16	4.9772925597587675e-15
R14_18	14	18	1.2123373952799835e+04
C14_18	14	18	5.8427219033065737e-15
R14_37	14	37	1.1508600539544299e+04
C14_37	14	37	6.1548319704564857e-15
R14_43	14	43	4.2431181835114745e+04
C14_43	14	43	1.6693737829706260e-15
R14_45	14	45	1.0183745961117000e+04
C14_45	14	45	6.9555449248687534e-15
R14_46	14	46	1.2123373952799775e+04
C14_46	14	46	5.8427219033066028e-15
R14_49	14	49	1.1637409805133328e+04
C14_49	14	49	6.0867068980208068e-15
R14_50	14	50	2.6735563967637485e+04
C14_50	14	50	2.6494111970759849e-15
R15_18	15	18	2.3534292016894178e+04
C15_18	15	18	3.0097995930853551e-15
R15_21	15	21	1.2693865523107672e+04
C15_21	15	21	5.5801365161034711e-15
R15_28	15	28	1.9057070546972660e+04
C15_28	15	28	3.7169145363347770e-15
R15_39	15	39	1.3827412952466593e+04
C15_39	15	39	5.1226865632420726e-15
R15_40	15	40	2.7681479453931377e+04
C15_40	15	40	2.5588770518528079e-15
R15_48	15	48	7.5391287071097131e+03
C15_48	15	48	9.3954494329299700e-15
R15_51	15	51	2.7230787422299880e+04
C15_51	15	51	2.6012285813664326e-15
R15_53	15	53	2.2769845145754622e+04
C15_53	15	53	3.1108469154085016e-15
R16_17	16	17	1.7265240742276084e+04
C16_17	16	17	4.1026652100225497e-15
R16_18	16	18	9.7536757529684965e+03
C16_18	16	18	7.2622367536097439e-15
R16_25	16	25	4.3810147567691689e+04
C16_25	16	25	1.6168286679827806e-15
R16_41	16	41	2.4972420688301132e+04
C16_41	16	41	2.8364692161854969e-15
R16_44	16	44	2.5146621944018654e+04
C16_44	16	44	2.8168197976527167e-15
R16_45	16	45	1.3820182252121269e+04
C16_45	16	45	5.1253667458059544e-15
R16_48	16	48	3.2471641192429906e+04
C16_48	16	48	2.1813958252443791e-15
R16_50	16	50	1.5299230833445677e+04
C16_50	16	50	4.6298734431243915e-15
R16_52	16	52	2.9754711815559887e+04
C16_52	16	52	2.3805810311682615e-15
R16_55	16	55	3.2081420337883264e+04
C16_55	16	55	2.2079291312534701e-15
R17_23	17	23	2.1383707593494244e+04
C17_23	17	23	3.3124986500259815e-15
R17_25	17	25	1.5876238212090126e+04
C17_25	17	25	4.4616049211241146e-15
R17_24	17	24	1.6073665650202945e+04
C17_24	17	24	4.4068045259548914e-15
R17_28	17	28	2.3016357726160393e+04
C17_28	17	28	3.0775287462399256e-15
R17_29	17	29	9.6110248610278013e+03
C17_29	17	29	7.3700259400249954e-15
R17_48	17	48	1.1803224791316878e+04
C17_48	17	48	6.0011991458562382e-15
R17_52	17	52	8.0335722680647514e+03
C17_52	17	52	8.8171861996660017e-15
R17_54	17	54	2.0789667539864775e+04
C17_54	17	54	3.4071493639893361e-15
R17_55	17	55	2.6174601320877609e+04
C17_55	17	55	2.7061922230502588e-15
R18_37	18	37	1.0565119022699695e+04
C18_37	18	37	6.7044680125051716e-15
R18_40	18	40	1.1928725070218052e+04
C18_40	18	40	5.9380614540984817e-15
R18_47	18	47	9.2015581321265709e+03
C18_47	18	47	7.6979900054850480e-15
R18_48	18	48	1.0932183056731817e+04
C18_48	18	48	6.4793556939555793e-15
R18_49	18	49	2.5050562578460551e+04
C18_49	18	49	2.8276212286308256e-15
R18_50	18	50	2.0470853747234498e+04
C18_50	18	50	3.4602124274161861e-15
R18_55	18	55	2.8553630142576760e+04
C18_55	18	55	2.4807179396212416e-15
R19_22	19	22	3.6154554427648742e+04
C19_22	19	22	1.9591861566915332e-15
R19_38	19	38	3.7850208739678776e+04
C19_38	19	38	1.8714164305716100e-15
R19_20	19	20	2.1319351830094951e+05
C19_20	19	20	3.3224979399237457e-16
R19_21	19	21	4.1493630230498144e+04
C19_21	19	21	1.7070934054821949e-15
R19_39	19	39	8.7008860088832356e+04
C19_39	19	39	8.1409528252274544e-16
R19_53	19	53	9.0547741432333351e+04
C19_53	19	53	7.8227796094653708e-16
R19_60	19	60	5.6173577457596351e+04
C19_60	19	60	1.2609754575355286e-15
R20_22	20	22	4.9750189639747230e+04
C20_22	20	22	1.4237835684430952e-15
R20_38	20	38	5.6758897178857878e+04
C20_38	20	38	1.2479717904453012e-15
R20_62	20	62	5.8318917582288130e+04
C20_62	20	62	1.2145887727777831e-15
R20_61	20	61	1.7068861871821238e+05
C20_61	20	61	4.1498667613532060e-16
R20_63	20	63	1.7068861871821232e+05
C20_63	20	63	4.1498667613532070e-16
R21_23	21	23	5.3597086433176846e+04
C21_23	21	23	1.3215924082797482e-15
R21_28	21	28	1.1984175792734371e+04
C21_28	21	28	5.9105860729232743e-15
R21_39	21	39	6.3723566082068624e+04
C21_39	21	39	1.1115746793701815e-15
R21_53	21	53	3.9639093166815481e+04
C21_53	21	53	1.7869607217780511e-15
R21_60	21	60	2.3012557083016833e+04
C21_60	21	60	3.0780370160721862e-15
R21_22	21	22	5.9722921759441728e+04
C21_22	21	22	1.1860354525404943e-15
R21_64	21	64	5.6546870062850205e+04
C21_64	21	64	1.2526511627835568e-15
R22_38	22	38	5.0891805784364078e+04
C22_38	22	38	1.3918449432926741e-15
R22_60	22	60	1.3627550805527802e+04
C22_60	22	60	5.1978160673792909e-15
R22_62	22	62	5.3891061322010559e+04
C22_62	22	62	1.3143831425541010e-15
R22_61	22	61	4.0776314259579420e+04
C22_61	22	61	1.7371237156227128e-15
R22_64	22	64	7.9794233496393921e+04
C22_64	22	64	8.8770202347016879e-16
R23_28	23	28	1.2967685339378468e+04
C23_28	23	28	5.4623088610041036e-15
R23_29	23	29	1.7123172870457984e+04
C23_29	23	29	4.1367042820788555e-15
R23_31	23	31	2.6654629178615793e+04
C23_31	23	31	2.6574559361278821e-15
R23_64	23	64	4.2684911149682528e+04
C23_64	23	64	1.6594506261851932e-15
R23_65	23	65	2.5823533725556274e+04
C23_65	23	65	2.7429825557103982e-15
R24_25	24	25	6.7444809306093221e+03
C24_25	24	25	1.0502439441192198e-14
R24_29	24	29	4.1302740346301171e+03
C24_29	24	29	1.7149831207832537e-14
R24_30	24	30	1.6829392679241857e+04
C24_30	24	30	4.2089161436805312e-15
R24_33	24	33	2.2034403000000093e+04
C24_33	24	33	3.2146776355138688e-15
R24_52	24	52	9.8942507972065378e+03
C24_52	24	52	7.1590567075577425e-15
R24_67	24	67	7.9392734667033510e+03
C24_67	24	67	8.9219124184435500e-15
R24_68	24	68	2.3254919157415501e+04
C24_68	24	68	3.0459578060245669e-15
R25_26	25	26	1.5246500112377427e+04
C25_26	25	26	4.6458860731254568e-15
R25_33	25	33	2.5934231808053086e+04
C25_33	25	33	2.7312743658751760e-15
R25_41	25	41	1.0933884612469226e+04
C25_41	25	41	6.4783473620363645e-15
R25_52	25	52	9.7932665872140769e+03
C25_52	25	52	7.2328780091087296e-15
R25_68	25	68	1.4422906385762073e+04
C25_68	25	68	4.9111809119086459e-15
R25_70	25	70	3.0651110743355126e+04
C25_70	25	70	2.3109603801668440e-15
R26_33	26	33	4.8922417357811479e+04
C26_33	26	33	1.4478741313605581e-15
R26_41	26	41	3.6815202769672287e+04
C26_41	26	41	1.9240285862108957e-15
R26_27	26	27	4.7965241242200187e+04
C26_27	26	27	1.4767673569768300e-15
R26_42	26	42	4.8862338400677538e+04
C26_42	26	42	1.4496543729683193e-15
R26_70	26	70	1.7585041579419209e+04
C26_70	26	70	4.0280543105966025e-15
R26_34	26	34	9.3453863172597528e+04
C26_34	26	34	7.5795157237298406e-16
R27_42	27	42	1.0518995836960012e+05
C27_42	27	42	6.7338654405695526e-16
R27_58	27	58	9.3048065592500920e+04
C27_58	27	58	7.6125712109063708e-16
R27_34	27	34	1.4625014836016065e+05
C27_34	27	34	4.8433114995249787e-16
R27_32	27	32	3.9945063918904919e+05
C27_32	27	32	1.7732729801059708e-16
R27_70	27	70	1.1465146659616911e+05
C27_70	27	70	6.1781593065436465e-16
R28_29	28	29	4.0010510406583780e+04
C28_29	28	29	1.7703723800620214e-15
R28_48	28	48	1.8772296754528717e+04
C28_48	28	48	3.7732997438851905e-15
R28_53	28	53	1.2908438263760450e+04
C28_53	28	53	5.4873797347631268e-15
R28_54	28	54	1.5799816575615534e+04
C28_54	28	54	4.4831851178146000e-15
R28_60	28	60	1.4128863059408874e+04
C28_60	28	60	5.0133901247510260e-15
R28_64	28	64	3.4718646210190556e+04
C28_64	28	64	2.0402149930376339e-15
R28_65	28	65	1.1654406821115859e+04
C28_65	28	65	6.0778299250427227e-15
R28_74	28	74	3.1468788173097772e+04
C28_74	28	74	2.2509129409868595e-15
R29_30	29	30	2.1283425021704184e+04
C29_30	29	30	3.3281063768527000e-15
R29_31	29	31	1.1086967095303071e+04
C29_31	29	31	6.3888980572521234e-15
R29_52	29	52	1.9495818286367903e+04
C29_52	29	52	3.6332664520949627e-15
R29_54	29	54	1.3698215165056834e+04
C29_54	29	54	5.1710023300474352e-15
R29_65	29	65	1.4562607536171177e+04
C29_65	29	65	4.8640672599368594e-15
R29_67	29	67	8.4258375844655966e+03
C29_67	29	67	8.4067016276925515e-15
R29_75	29	75	3.1473708550114115e+04
C29_75	29	75	2.2505610491758583e-15
R30_31	30	31	1.5651910031831654e+04
C30_31	30	31	4.5255500697323375e-15
R30_33	30	33	1.4073554308500445e+04
C30_33	30	33	5.0330926348304559e-15
R30_67	30	67	1.6925866884343253e+04
C30_67	30	67	4.1849261263848373e-15
R30_76	30	76	1.3963944192469135e+04
C30_76	30	76	5.0725999445200504e-15
R31_65	31	65	2.1699648600925651e+04
C31_65	31	65	3.2642695666960452e-15
R31_64	31	64	7.8420658255272792e+04
C31_64	31	64	9.0325054790313961e-16
R31_67	31	67	3.5599342952426261e+04
C31_67	31	67	1.9897418508723456e-15
R31_75	31	75	2.5606519291040546e+04
C31_75	31	75	2.7662292454087622e-15
R31_76	31	76	2.7681572915349843e+04
C31_76	31	76	2.5588684123047715e-15
R31_77	31	77	3.4338531826974373e+04
C31_77	31	77	2.0627993908684617e-15
R32_58	32	58	5.9310936299067274e+04
C32_58	32	58	1.1942738886945197e-15
R32_34	32	34	5.6225418785912276e+04
C32_34	32	34	1.2598128046980045e-15
R32_59	32	59	3.5479585630902890e+04
C32_59	32	59	1.9964579990557639e-15
R32_71	32	71	6.0191245730799586e+04
C32_71	32	71	1.1768073857915659e-15
R32_35	32	35	7.6101915744913073e+04
C32_35	32	35	9.3077160860743197e-16
R32_80	32	80	4.5640040314412938e+04
C32_80	32	80	1.5520035049932037e-15
R32_36	32	36	1.0832275822963542e+05
C32_36	32	36	6.5391154817013372e-16
R33_67	33	67	3.4327030989601299e+04
C33_67	33	67	2.0634905057025657e-15
R33_68	33	68	4.7506779739271667e+04
C33_68	33	68	1.4910188172035837e-15
R33_70	33	70	3.1223521177884246e+04
C33_70	33	70	2.2685943117194510e-15
R33_34	33	34	6.6477123921518956e+04
C33_34	33	34	1.0655319959332791e-15
R33_72	33	72	2.0647958506685874e+04
C33_72	33	72	3.4305329755996889e-15
R33_76	33	76	3.0942105507390279e+04
C33_76	33	76	2.2892269732285021e-15
R33_79	33	79	5.0542079248908143e+04
C33_79	33	79	1.4014758313990460e-15
R33_82	33	82	4.3860100742702467e+04
C33_82	33	82	1.6149872284045181e-15
R34_58	34	58	1.8157062390291912e+05
C34_58	34	58	3.9011543284596940e-16
R34_70	34	70	5.9746389930002595e+04
C34_70	34	70	1.1855695820113450e-15
R34_71	34	71	1.2292308896268305e+05
C34_71	34	71	5.7624245480443154e-16
R34_79	34	79	3.7196463200249840e+04
C34_79	34	79	1.9043074647894002e-15
R34_35	34	35	1.2657054123473809e+05
C34_35	34	35	5.5963656191239623e-16
R34_80	34	80	1.5687234611076332e+05
C34_80	34	80	4.5153594175219632e-16
R34_82	34	82	3.1308268556056981e+05
C34_82	34	82	2.2624535243516799e-16
R34_83	34	83	2.7459505624166882e+05
C34_83	34	83	2.5795621926150056e-16
R35_80	35	80	3.4512142256400650e+04
C35_80	35	80	2.0524226519975929e-15
R35_36	35	36	2.7884101334785129e+05
C35_36	35	36	2.5402827828500231e-16
R35_79	35	79	1.8968259787157923e+05
C35_79	35	79	3.7343173981598658e-16
R35_83	35	83	1.2115424844884004e+05
C35_83	35	83	5.8465553988320060e-16
R35_84	35	84	1.3324246683240170e+05
C35_84	35	84	5.3161356300238372e-16
R36_80	36	80	4.9080556051391497e+04
C36_80	36	80	1.4432090472208858e-15
R36_59	36	59	1.0529767690815957e+05
C36_59	36	59	6.7269767592100683e-16
R36_73	36	73	1.1697041855288665e+05
C36_73	36	73	6.0556765900579863e-16
R36_81	36	81	1.1264494479248831e+05
C36_81	36	81	6.2882096188593012e-16
R36_84	36	84	1.1697041855288658e+05
C36_84	36	84	6.0556765900579902e-16
R37_40	37	40	8.2369765055136741e+04
C37_40	37	40	8.5994542401068415e-16
R37_43	37	43	1.1438267718622209e+05
C37_43	37	43	6.1926774471871006e-16
R37_47	37	47	9.1311648714094583e+04
C37_47	37	47	7.7573347468280224e-16
R37_49	37	49	4.2875919862278497e+04
C37_49	37	49	1.6520579095101377e-15
R37_85	37	85	8.5798969887956555e+04
C37_85	37	85	8.2557520945181846e-16
R37_86	37	86	1.7064717477681095e+05
C37_86	37	86	4.1508746118207333e-16
R38_39	38	39	1.4272663242074256e+05
C38_39	38	39	4.9628791301675596e-16
R38_53	38	53	6.8240349276841313e+04
C38_53	38	53	1.0380002928859382e-15
R38_60	38	60	5.8778858471014020e+04
C38_60	38	60	1.2050846916486230e-15
R38_62	38	62	5.7009124536987692e+04
C38_62	38	62	1.2424941289888253e-15
R38_63	38	63	5.2265327279928017e+04
C38_63	38	63	1.3552675592486515e-15
R38_66	38	66	5.3805547748798439e+04
C38_66	38	66	1.3164721018490480e-15
R38_87	38	87	6.6143367746560762e+04
C38_87	38	87	1.0709086178891022e-15
R39_40	39	40	5.4237048470155969e+04
C39_40	39	40	1.3059984739946954e-15
R39_51	39	51	1.5968359031709473e+04
C39_51	39	51	4.4358661021674828e-15
R39_53	39	53	1.9098080884909952e+04
C39_53	39	53	3.7089330055130305e-15
R39_87	39	87	6.3078959323577343e+04
C39_87	39	87	1.1229339116494304e-15
R39_88	39	88	1.1739592210125799e+05
C39_88	39	88	6.0337276856093595e-16
R40_47	40	47	2.4646329603308342e+04
C40_47	40	47	2.8739980222650205e-15
R40_48	40	48	1.1795007282153414e+05
C40_48	40	48	6.0053801444595592e-16
R40_51	40	51	5.4771971982882540e+04
C40_51	40	51	1.2932436056554080e-15
R40_85	40	85	8.0184522218437414e+04
C40_85	40	85	8.8338123837710855e-16
R40_88	40	88	1.0140249186647659e+05
C40_88	40	88	6.9853808552625311e-16
R41_42	41	42	2.3196634256829511e+04
C41_42	41	42	3.0536112158230597e-15
R41_44	41	44	2.1936054375046369e+04
C41_44	41	44	3.2290903972492678e-15
R41_45	41	45	4.7015156982434193e+04
C41_45	41	45	1.5066099335255827e-15
R41_50	41	50	3.7595708792633268e+04
C41_50	41	50	1.8840847748528037e-15
R41_52	41	52	2.9290884004552168e+04
C41_52	41	52	2.4182780733074357e-15
R41_56	41	56	1.3069455127796211e+04
C41_56	41	56	5.4197747223104048e-15
R41_57	41	57	1.7166062234856392e+04
C41_57	41	57	4.1263687365742905e-15
R41_68	41	68	2.8033122388295000e+04
C41_68	41	68	2.5267789137030257e-15
R41_69	41	69	2.2756460894279397e+04
C41_69	41	69	3.1126765653532008e-15
R41_70	41	70	4.0325914490484887e+04
C41_70	41	70	1.7565256344704485e-15
R41_92	41	92	4.0535847667208756e+04
C41_92	41	92	1.7474286739364367e-15
R42_44	42	44	1.0606815576806203e+05
C42_44	42	44	6.6781120142119542e-16
R42_70	42	70	4.1344256416029668e+04
C42_70	42	70	1.7132610107491737e-15
R42_58	42	58	5.7303733289551783e+04
C42_58	42	58	1.2361062442141987e-15
R42_69	42	69	3.2250791976509619e+04
C42_69	42	69	2.1963337392642240e-15
R42_92	42	92	4.2079359757160135e+04
C42_92	42	92	1.6833312803421900e-15
R42_93	42	93	8.6536910131389726e+04
C42_93	42	93	8.1853514793228569e-16
R43_46	43	46	4.2266447679074350e+04
C43_46	43	46	1.6758801939976823e-15
R43_49	43	49	4.3867455449496374e+04
C43_49	43	49	1.6147164637244358e-15
R43_86	43	86	4.2429110281537440e+04
C43_86	43	86	1.6694552882675559e-15
R43_94	43	94	5.0516744008607588e+04
C43_94	43	94	1.4021787018563712e-15
R43_91	43	91	1.7168727057259282e+05
C43_91	43	91	4.1257282674343748e-16
R44_45	44	45	1.3699886530052419e+04
C44_45	44	45	5.1703714757503883e-15
R44_46	44	46	6.1675197095641088e+04
C44_46	44	46	1.1484925200345436e-15
R44_56	44	56	2.2573307818589979e+04
C44_56	44	56	3.1379318930682332e-15
R44_92	44	92	3.8957395466847076e+04
C44_92	44	92	1.8182299326524442e-15
R44_96	44	96	4.7131730158843078e+04
C44_96	44	96	1.5028835626716299e-15
R45_46	45	46	8.5502939286974361e+03
C45_46	45	46	8.2843353838703513e-15
R45_49	45	49	1.5074677512436285e+04
C45_49	45	49	4.6988403219613744e-15
R45_50	45	50	3.7640735692369908e+03
C45_50	45	50	1.8818309800028311e-14
R45_56	45	56	6.4287160485747399e+03
C45_56	45	56	1.1018296966422082e-14
R45_95	45	95	5.8582936647923852e+03
C45_95	45	95	1.2091149162033393e-14
R45_96	45	96	1.6963682139369463e+04
C45_96	45	96	4.1755971347523063e-15
R46_49	46	49	3.0279555295778715e+04
C46_49	46	49	2.3393177952608486e-15
R46_94	46	94	4.5339092214389246e+04
C46_94	46	94	1.5623052663043752e-15
R46_95	46	95	2.1593293544491240e+04
C46_95	46	95	3.2803473166357554e-15
R46_96	46	96	4.7255541087736790e+04
C46_96	46	96	1.4989459628551771e-15
R47_48	47	48	2.3457854448511745e+04
C47_48	47	48	3.0196070442620529e-15
R47_49	47	49	1.4170523788108881e+04
C47_49	47	49	4.9986509740338291e-15
R47_50	47	50	3.4395534680506556e+04
C47_50	47	50	2.0593807653801187e-15
R47_51	47	51	2.1349073653842617e+04
C47_51	47	51	3.3178724137874095e-15
R47_55	47	55	2.0622961903608761e+04
C47_55	47	55	3.4346910432688641e-15
R47_85	47	85	1.1628292670967456e+04
C47_85	47	85	6.0914791655400229e-15
R47_88	47	88	2.5550964386951309e+04
C47_88	47	88	2.7722437972702959e-15
R47_89	47	89	2.7166344246658584e+04
C47_89	47	89	2.6073991366987996e-15
R47_90	47	90	1.4015522656081821e+04
C47_90	47	90	5.0539322916554152e-15
R47_99	47	99	2.6895418802369099e+04
C47_99	47	99	2.6336642331726987e-15
R47_100	47	100	1.2400505131875392e+04
C47_100	47	100	5.7121465442502896e-15
R48_51	48	51	2.5005488746631920e+04
C48_51	48	51	2.8327181785455333e-15
R48_53	48	53	3.1651970109385267e+04
C48_53	48	53	2.2378860554716892e-15
R48_54	48	54	2.6261392890366205e+04
C48_54	48	54	2.6972484982692882e-15
R48_55	48	55	1.4158665188719582e+04
C48_55	48	55	5.0028375974618080e-15
R48_100	48	100	3.4700037983727576e+04
C48_100	48	100	2.0413090777945853e-15
R49_50	49	50	1.8291670277835106e+04
C49_50	49	50	3.8724458433865578e-15
R49_85	49	85	3.3438929152309895e+04
C49_85	49	85	2.1182945845353715e-15
R49_86	49	86	2.1340281990807842e+04
C49_86	49	86	3.3192392943313019e-15
R49_89	49	89	1.0945480430028625e+04
C49_89	49	89	6.4714840969127542e-15
R49_94	49	94	3.9836724262293988e+04
C49_94	49	94	1.7780955600067979e-15
R49_95	49	95	1.2280515857209199e+04
C49_95	49	95	5.7679582323423042e-15
R49_97	49	97	2.0833491289912356e+04
C49_97	49	97	3.3999823433481758e-15
R49_99	49	99	4.6686446969383054e+04
C49_99	49	99	1.5172176752377961e-15
R49_101	49	101	4.1401009368204839e+04
C49_101	49	101	1.7109124539943883e-15
R50_52	50	52	3.5768592208798633e+04
C50_52	50	52	1.9803268219926155e-15
R50_55	50	55	1.1488352135299176e+04
C50_55	50	55	6.1656799601708393e-15
R50_56	50	56	1.8547922851322055e+04
C50_56	50	56	3.8189452858841895e-15
R50_57	50	57	1.0520249922740146e+04
C50_57	50	57	6.7330627177296600e-15
R50_95	50	95	3.0730683434331342e+04
C50_95	50	95	2.3049764801802966e-15
R50_98	50	98	2.7646088609825736e+04
C50_98	50	98	2.5621527708923345e-15
R50_99	50	99	5.4229878784382454e+04
C50_99	50	99	1.3061711389330856e-15
R50_101	50	101	2.1745043057262348e+04
C50_101	50	101	3.2574551519383278e-15
R51_53	51	53	4.7778744495189230e+03
C51_53	51	53	1.4825316840029594e-14
R51_87	51	87	2.7365282224167186e+04
C51_87	51	87	2.5884440714243609e-15
R51_88	51	88	1.1451151223425657e+04
C51_88	51	88	6.1857101660744554e-15
R51_100	51	100	7.8332805918642325e+03
C51_100	51	100	9.0426356754753279e-15
R51_104	51	104	1.9956246877399488e+04
C51_104	51	104	3.5494400811516907e-15
R52_54	52	54	1.8467185412293609e+04
C52_54	52	54	3.8356414881092880e-15
R52_55	52	55	1.0836771428168719e+04
C52_55	52	55	6.5364027473974317e-15
R52_57	52	57	1.0714806367477293e+04
C52_57	52	57	6.6108056559007252e-15
R52_67	52	67	1.6754827193134741e+04
C52_67	52	67	4.2276474546406483e-15
R52_68	52	68	1.3278272637324002e+04
C52_68	52	68	5.3345419596893613e-15
R52_106	52	106	1.8974423658922875e+04
C52_106	52	106	3.7331042992017302e-15
R53_54	53	54	2.3862539342598302e+04
C53_54	53	54	2.9683975170886918e-15
R53_60	53	60	8.2334655394661786e+03
C53_60	53	60	8.6031212733529655e-15
R53_66	53	66	1.1497621333523397e+04
C53_66	53	66	6.1607092877091124e-15
R53_74	53	74	1.2550185007548855e+04
C53_74	53	74	5.6440205856243657e-15
R53_87	53	87	2.6990742558279464e+04
C53_87	53	87	2.6243628674925695e-15
R53_100	53	100	2.1287916997932487e+04
C53_100	53	100	3.3274041111152151e-15
R53_104	53	104	1.7086344542765204e+04
C53_104	53	104	4.1456206363339863e-15
R53_107	53	107	3.5172243618440451e+04
C53_107	53	107	2.0139034434204457e-15
R54_55	54	55	9.5462316268026461e+03
C54_55	54	55	7.4200485914382234e-15
R54_65	54	65	6.6824345211518003e+03
C54_65	54	65	1.0599954599149741e-14
R54_67	54	67	2.2261902501223391e+04
C54_67	54	67	3.1818261054780649e-15
R54_74	54	74	1.0788285138102368e+04
C54_74	54	74	6.5657796053080068e-15
R54_75	54	75	1.3619063249997902e+04
C54_75	54	75	5.2010554056286450e-15
R54_100	54	100	2.5028823864632908e+04
C54_100	54	100	2.8300771510119422e-15
R54_106	54	106	7.7008301776047956e+03
C54_106	54	106	9.1981644708897455e-15
R54_107	54	107	7.4838938273128579e+03
C54_107	54	107	9.4647925492327902e-15
R55_57	55	57	1.6827324016634153e+04
C55_57	55	57	4.2094335656685308e-15
R55_98	55	98	9.1394720300500721e+03
C55_98	55	98	7.7502838569999914e-15
R55_99	55	99	2.5289275414593827e+04
C55_99	55	99	2.8009304883098283e-15
R55_100	55	100	9.0412862227780060e+03
C55_100	55	100	7.8344497442794018e-15
R55_106	55	106	1.0129267805017020e+04
C55_106	55	106	6.9929538738146744e-15
R55_107	55	107	2.4069319483023952e+04
C55_107	55	107	2.9428959379578128e-15
R55_108	55	108	1.9772599481439829e+04
C55_108	55	108	3.5824071894284871e-15
R56_57	56	57	8.8957877438884407e+03
C56_57	56	57	7.9625891011916115e-15
R56_69	56	69	3.4240717562578844e+04
C56_69	56	69	2.0686921179891645e-15
R56_92	56	92	9.9060544679727645e+03
C56_92	56	92	7.1505262529104374e-15
R56_95	56	95	1.6932228358353106e+04
C56_95	56	95	4.1833538407870589e-15
R56_96	56	96	1.3676789471455733e+04
C56_96	56	96	5.1791030843776380e-15
R56_101	56	101	2.1973781656655381e+04
C56_101	56	101	3.2235462990752925e-15
R56_102	56	102	1.8972353871730000e+04
C56_102	56	102	3.7335115618703686e-15
R56_110	56	110	2.0734771567636195e+04
C56_110	56	110	3.4161699011220486e-15
R57_68	57	68	9.9996063724834730e+03
C57_68	57	68	7.0836290847324646e-15
R57_69	57	69	2.4451339949813573e+04
C57_69	57	69	2.8969170066501845e-15
R57_98	57	98	6.7703455019085113e+03
C57_98	57	98	1.0462317250431691e-14
R57_101	57	101	2.1487789870378634e+04
C57_101	57	101	3.2964536121811893e-15
R57_106	57	106	1.9046437222627337e+04
C57_106	57	106	3.7189896308717096e-15
R57_110	57	110	7.9685372264570724e+03
C57_110	57	110	8.8891474712346456e-15
R57_111	57	111	2.4699219933648910e+04
C57_111	57	111	2.8678437102987292e-15
R58_70	58	70	1.8628625554564744e+04
C58_70	58	70	3.8024008979365105e-15
R58_69	58	69	2.0605531542490353e+04
C58_69	58	69	3.4375964720898033e-15
R58_71	58	71	6.5726307447966965e+03
C58_71	58	71	1.0777039710024212e-14
R58_59	58	59	3.4255584712551041e+04
C58_59	58	59	2.0677942919493369e-15
R58_93	58	93	2.4764722442010403e+04
C58_93	58	93	2.8602582848188680e-15
R58_112	58	112	2.9173353986687809e+04
C58_112	58	112	2.4280205343657876e-15
R58_114	58	114	3.3181098450606471e+04
C58_114	58	114	2.1347545995634552e-15
R59_71	59	71	1.0613828321005438e+04
C59_71	59	71	6.6736996674249983e-15
R59_73	59	73	2.2079506182041823e+04
C59_73	59	73	3.2081108133483448e-15
R59_80	59	80	1.1357200709378629e+04
C59_80	59	80	6.2368804028889471e-15
R59_113	59	113	2.1958419517676739e+04
C59_113	59	113	3.2258014962770138e-15
R59_114	59	114	2.7717113513464235e+04
C59_114	59	114	2.5555872728807408e-15
R60_62	60	62	1.9861111081301959e+04
C60_62	60	62	3.5664420910814739e-15
R60_61	60	61	3.0528023521575149e+04
C60_61	60	61	2.3202780385025470e-15
R60_64	60	64	1.0377043637053903e+04
C60_64	60	64	6.8259809839356148e-15
R60_65	60	65	3.3999104920217207e+04
C60_65	60	65	2.0833931570321904e-15
R60_66	60	66	1.3618498035685923e+04
C60_66	60	66	5.2012712672416468e-15
R60_74	60	74	1.2436029726712906e+04
C60_74	60	74	5.6958293034510726e-15
R60_117	60	117	3.1192386818079347e+04
C60_117	60	117	2.2708586857785554e-15
R61_62	61	62	2.0722433643056826e+04
C61_62	61	62	3.4182038536643207e-15
R61_64	61	64	3.0996493513933743e+04
C61_64	61	64	2.2852101804405223e-15
R61_78	61	78	8.9105855127657138e+04
C61_78	61	78	7.9493656656479729e-16
R61_117	61	117	3.4574305914676188e+04
C61_117	61	117	2.0487324520933450e-15
R62_63	62	63	1.4539350131275874e+04
C62_63	62	63	4.8718479090498486e-15
R62_66	62	66	1.1982814688022663e+04
C62_66	62	66	5.9112574449474826e-15
R62_117	62	117	2.4430723885585638e+04
C62_117	62	117	2.8993615935298776e-15
R62_118	62	118	2.5197582094732265e+04
C62_118	62	118	2.8111229986153417e-15
R63_66	63	66	3.2050659985033199e+04
C63_66	63	66	2.2100481727701506e-15
R63_87	63	87	3.3041403337401331e+04
C63_87	63	87	2.1437800874462189e-15
R63_105	63	105	1.2435864417985590e+05
C63_105	63	105	5.6959050175519595e-16
R63_118	63	118	3.3707186565320604e+04
C63_118	63	118	2.1014362144622457e-15
R64_65	64	65	1.4037152639212320e+04
C64_65	64	65	5.0461446389155138e-15
R64_74	64	74	4.3596737768531784e+04
C64_74	64	74	1.6247431840445588e-15
R64_77	64	77	4.5222631062378270e+04
C64_77	64	77	1.5663286472274277e-15
R64_78	64	78	4.8349012932325444e+04
C64_78	64	78	1.4650454733201342e-15
R64_117	64	117	4.5473026506201342e+04
C64_117	64	117	1.5577037197280053e-15
R64_119	64	119	3.7154718515797373e+04
C64_119	64	119	1.9064470238385240e-15
R65_74	65	74	1.3216554090051583e+04
C65_74	65	74	5.3594531565015180e-15
R65_75	65	75	1.2709753668571837e+04
C65_75	65	75	5.5731609268835954e-15
R65_77	65	77	5.6485724109030816e+04
C65_77	65	77	1.2540071611594214e-15
R65_119	65	119	4.5031846039248114e+04
C65_119	65	119	1.5729646631467008e-15
R66_74	66	74	1.9122985334158857e+04
C66_74	66	74	3.7041027485113476e-15
R66_87	66	87	1.6625185556801945e+04
C66_87	66	87	4.2606142526342831e-15
R66_104	66	104	1.2221881275950340e+04
C66_104	66	104	5.7956300619105949e-15
R66_117	66	117	3.3292744186392461e+04
C66_117	66	117	2.1275957950306584e-15
R66_118	66	118	1.0625760718183144e+04
C66_118	66	118	6.6662053112853778e-15
R66_120	66	120	4.1364851448887341e+04
C66_120	66	120	1.7124079999060491e-15
R67_68	67	68	1.4694801838626541e+04
C67_68	67	68	4.8203101555141839e-15
R67_72	67	72	1.9960819830895492e+04
C67_72	67	72	3.5486269169347161e-15
R67_75	67	75	1.4888009717409603e+04
C67_75	67	75	4.7577549907943304e-15
R67_76	67	76	2.2962353309307236e+04
C67_76	67	76	3.0847666866657508e-15
R67_106	67	106	2.1966850085280403e+04
C67_106	67	106	3.2245634791063786e-15
R67_111	67	111	3.9379396998946453e+04
C67_111	67	111	1.7987452306061232e-15
R67_121	67	121	4.1179000193620857e+04
C67_121	67	121	1.7201365308275019e-15
R67_122	67	122	2.2283407229211192e+04
C67_122	67	122	3.1787554662262232e-15
R68_69	68	69	1.3919711365538735e+04
C68_69	68	69	5.0887192037159409e-15
R68_70	68	70	1.3219875545645858e+04
C68_70	68	70	5.3581066093568461e-15
R68_72	68	72	1.1036291282383942e+04
C68_72	68	72	6.4182342349974025e-15
R68_106	68	106	4.3436818955439732e+04
C68_106	68	106	1.6307249066434987e-15
R68_110	68	110	3.7071088898717040e+04
C68_110	68	110	1.9107478264133596e-15
R68_111	68	111	1.1298374686192730e+04
C68_111	68	111	6.2693532922538547e-15
R68_115	68	115	3.1753986325035188e+04
C68_115	68	115	2.2306963859889969e-15
R68_124	68	124	2.8624403854031883e+04
C68_124	68	124	2.4745843755283231e-15
R69_70	69	70	1.6022153735112872e+04
C69_70	69	70	4.4209725925152602e-15
R69_71	69	71	6.2552615388806786e+04
C69_71	69	71	1.1323827484386050e-15
R69_92	69	92	2.8024277335784445e+04
C69_92	69	92	2.5275764183775078e-15
R69_93	69	93	2.2951037381923790e+04
C69_93	69	93	3.0862876199133550e-15
R69_109	69	109	2.9403425424890596e+04
C69_109	69	109	2.4090221296474532e-15
R69_110	69	110	2.8552005889566990e+04
C69_110	69	110	2.4808590615303444e-15
R69_112	69	112	2.1368082261728618e+04
C69_112	69	112	3.3149209025119963e-15
R69_115	69	115	1.6632688303539559e+04
C69_115	69	115	4.2586923558788819e-15
R69_124	69	124	2.1236892625008539e+04
C69_124	69	124	3.3353986285444869e-15
R70_71	70	71	4.7012263698359100e+04
C70_71	70	71	1.5067026550876846e-15
R70_72	70	72	2.7812174164703621e+04
C70_72	70	72	2.5468524005539515e-15
R70_79	70	79	3.6359597476129151e+04
C70_79	70	79	1.9481376982378233e-15
R70_124	70	124	2.7336894906955506e+04
C70_124	70	124	2.5911319766597701e-15
R71_79	71	79	3.4963184946621979e+04
C71_79	71	79	2.0259453663658205e-15
R71_80	71	80	1.1254082594484025e+04
C71_80	71	80	6.2940272511166475e-15
R71_112	71	112	2.7122391843455585e+04
C71_112	71	112	2.6116244815293291e-15
R71_113	71	113	1.1910348551727197e+04
C71_113	71	113	5.9472233099112774e-15
R71_114	71	114	2.6772281121951983e+04
C71_114	71	114	2.6457776314742171e-15
R71_124	71	124	1.3870108065492435e+04
C71_124	71	124	5.1069178554006587e-15
R71_126	71	126	2.8025901820373332e+04
C71_126	71	126	2.5274299107302171e-15
R72_76	72	76	3.2129806301906228e+04
C72_76	72	76	2.2046040947280012e-15
R72_79	72	79	1.2594991546845995e+04
C72_79	72	79	5.6239420465302285e-15
R72_82	72	82	3.4129529806041268e+04
C72_82	72	82	2.0754315379833260e-15
R72_111	72	111	2.5016024435061339e+04
C72_111	72	111	2.8315251577993717e-15
R72_122	72	122	1.1838301879550630e+04
C72_122	72	122	5.9834174915202251e-15
R72_123	72	123	3.2257298540047919e+04
C72_123	72	123	2.1958907206088308e-15
R72_124	72	124	1.6332734461212656e+04
C72_124	72	124	4.3369040685879626e-15
R72_125	72	125	3.6415219455126469e+04
C72_125	72	125	1.9451620392755364e-15
R72_127	72	127	2.2852495270537460e+04
C72_127	72	127	3.0995959827337526e-15
R73_80	73	80	4.2638559521502837e+04
C73_80	73	80	1.6612545857764804e-15
R73_81	73	81	3.3728355061079863e+04
C73_81	73	81	2.1001173169496449e-15
R73_113	73	113	2.2709679077439880e+04
C73_113	73	113	3.1190886623478096e-15
R73_114	73	114	8.5644342356279056e+04
C73_114	73	114	8.2706575340766585e-16
R73_116	73	116	8.1490490575830539e+04
C73_116	73	116	8.6922415162154727e-16
R73_128	73	128	8.4055196527917360e+04
C73_128	73	128	8.4270224164515488e-16
R74_75	74	75	2.7087300015574587e+04
C74_75	74	75	2.6150078632891554e-15
R74_104	74	104	4.1234616788724416e+04
C74_104	74	104	1.7178164380411896e-15
R74_107	74	107	9.6394294155765856e+03
C74_107	74	107	7.3483086479723008e-15
R74_117	74	117	3.1063628422931633e+04
C74_117	74	117	2.2802713698348796e-15
R74_119	74	119	1.4168494409819403e+04
C74_119	74	119	4.9993669395746963e-15
R74_120	74	120	1.1580642551956249e+04
C74_120	74	120	6.1165433798865105e-15
R74_131	74	131	4.7808952836787445e+04
C74_131	74	131	1.4815949384588052e-15
R75_76	75	76	4.2405907284546083e+04
C75_76	75	76	1.6703687545393884e-15
R75_77	75	77	3.0835260554254623e+04
C75_77	75	77	2.2971592022505703e-15
R75_106	75	106	4.1575403443162315e+04
C75_106	75	106	1.7037357829332053e-15
R75_107	75	107	6.3588109425227245e+04
C75_107	75	107	1.1139425778854548e-15
R75_119	75	119	3.0350378093358519e+04
C75_119	75	119	2.3338589825179247e-15
R75_121	75	121	5.1386607780931248e+04
C75_121	75	121	1.3784428588470712e-15
R75_122	75	122	3.8333866501749020e+04
C75_122	75	122	1.8478048003002299e-15
R75_129	75	129	5.7082505178849417e+04
C75_129	75	129	1.2408968792463878e-15
R75_131	75	131	2.2212378936720150e+04
C75_131	75	131	3.1889201394319102e-15
R75_132	75	132	2.0529100975367652e+04
C75_132	75	132	3.4503947650211939e-15
R76_77	76	77	4.2799485519419788e+04
C76_77	76	77	1.6550082711592435e-15
R76_82	76	82	3.9331795969647588e+04
C76_82	76	82	1.8009221493638978e-15
R76_122	76	122	3.1799577525227087e+04
C76_122	76	122	2.2274982263461426e-15
R76_123	76	123	3.5802384448028271e+04
C76_123	76	123	1.9784576817453002e-15
R76_130	76	130	6.4448424274366371e+04
C76_130	76	130	1.0990726822808178e-15
R76_132	76	132	4.3516689256163758e+04
C76_132	76	132	1.6277318827963699e-15
R77_119	77	119	3.7358657248724972e+04
C77_119	77	119	1.8960398406293773e-15
R77_78	77	78	6.1987917231289910e+04
C77_78	77	78	1.1426985402930278e-15
R77_132	77	132	2.4727735573734619e+04
C77_132	77	132	2.8645365575341309e-15
R77_130	77	130	8.6349365844949498e+04
C77_130	77	130	8.2031294431495809e-16
R77_133	77	133	6.4321828020309506e+04
C77_133	77	133	1.1012358435092119e-15
R77_134	77	134	6.3430400759936572e+04
C77_134	77	134	1.1167122024671066e-15
R78_117	78	117	7.6347558370328581e+04
C78_117	78	117	9.2777691975973488e-16
R78_119	78	119	6.5170600068982982e+04
C78_119	78	119	1.0868935142690547e-15
R78_133	78	133	7.2164629806331708e+04
C78_133	78	133	9.8155429780622393e-16
R78_134	78	134	2.2068938897621768e+05
C78_134	78	134	3.2096469551435159e-16
R79_80	79	80	3.1200539834870448e+04
C79_80	79	80	2.2702652874241248e-15
R79_82	79	82	1.4907141754043123e+04
C79_82	79	82	4.7516488207263816e-15
R79_83	79	83	1.5094582567076211e+04
C79_83	79	83	4.6926440145817362e-15
R79_123	79	123	3.8286548289148479e+04
C79_123	79	123	1.8500884958615157e-15
R79_124	79	124	2.5618470749723365e+04
C79_124	79	124	2.7649387517311073e-15
R79_126	79	126	1.6538787595833179e+04
C79_126	79	126	4.2828715300658413e-15
R79_127	79	127	1.5641458629256149e+04
C79_127	79	127	4.5285739786129264e-15
R79_135	79	135	2.7527019661114715e+04
C79_135	79	135	2.5732354395074960e-15
R80_81	80	81	1.0212025632643852e+04
C80_81	80	81	6.9362832687741214e-15
R80_83	80	83	3.0046190126982208e+04
C80_83	80	83	2.3574869970748739e-15
R80_84	80	84	2.2373892335503009e+04
C80_84	80	84	3.1658998565752926e-15
R80_113	80	113	8.5794860286670828e+03
C80_113	80	113	8.2561475476876281e-15
R80_126	80	126	1.2441907314802345e+04
C80_126	80	126	5.6931385794626677e-15
R80_136	80	136	2.6882905272621632e+04
C80_136	80	136	2.6348901585476701e-15
R81_84	81	84	5.6186450604586367e+04
C81_84	81	84	1.2606865494048141e-15
R81_113	81	113	3.1979326499485203e+04
C81_113	81	113	2.2149779338579968e-15
R81_128	81	128	7.6736812901594909e+04
C81_128	81	128	9.2307068612342382e-16
R81_136	81	136	4.2372617824217894e+04
C81_136	81	136	1.6716810566166012e-15
R82_83	82	83	4.3441561624008027e+04
C82_83	82	83	1.6305468746513432e-15
R82_123	82	123	1.1828750722191442e+04
C82_123	82	123	5.9882488184582452e-15
R82_130	82	130	1.1838473753496374e+05
C82_130	82	130	5.9833306227570125e-16
R82_135	82	135	4.6151324441195939e+04
C82_135	82	135	1.5348097458449551e-15
R82_137	82	137	4.7412666171470220e+04
C82_137	82	137	1.4939784714874964e-15
R83_84	83	84	8.5042841999288954e+04
C83_84	83	84	8.3291551494236597e-16
R83_126	83	126	8.4425728315933113e+04
C83_126	83	126	8.3900374860766301e-16
R83_135	83	135	1.9048542207525472e+04
C83_135	83	135	3.7185786588968443e-15
R83_136	83	136	7.0526369877442470e+04
C83_136	83	136	1.0043548627143473e-15
R83_137	83	137	1.2802462087748181e+05
C83_137	83	137	5.5328031475904099e-16
R83_138	83	138	7.1821128301504737e+04
C83_138	83	138	9.8624881300445921e-16
R84_136	84	136	5.0969910636503082e+04
C84_136	84	136	1.3897121193944420e-15
R84_138	84	138	1.7778193314469152e+05
C84_138	84	138	3.9842913890665531e-16
R85_86	85	86	3.4775841092059854e+04
C85_86	85	86	2.0368595068193182e-15
R85_88	85	88	4.2389109928858372e+04
C85_88	85	88	1.6710306645947473e-15
R85_89	85	89	1.4267467260419564e+04
C85_89	85	89	4.9646865307695130e-15
R85_90	85	90	3.4157128405921496e+04
C85_90	85	90	2.0737546111669116e-15
R85_143	85	143	3.5560220393398682e+04
C85_143	85	143	1.9919309203479901e-15
R86_89	86	89	1.1502662893970120e+04
C86_89	86	89	6.1580090791960942e-15
R86_94	86	94	5.1566294397671409e+04
C86_94	86	94	1.3736395714173843e-15
R86_91	86	91	4.9725876180954474e+04
C86_91	86	91	1.4244797271793469e-15
R86_97	86	97	3.0362656183676070e+04
C86_97	86	97	2.3329152135932813e-15
R86_143	86	143	7.4531556173203411e+04
C86_143	86	143	9.5038271267797627e-16
R86_144	86	144	4.9494922875104356e+04
C86_144	86	144	1.4311266372662401e-15
R87_88	87	88	6.4479918474631530e+04
C87_88	87	88	1.0985358575456043e-15
R87_104	87	104	1.4562056634028530e+04
C87_104	87	104	4.8642512741281808e-15
R87_105	87	105	3.6309229557516948e+04
C87_105	87	105	1.9508401417274259e-15
R87_118	87	118	3.9320517987808496e+04
C87_118	87	118	1.8014386931006925e-15
R87_146	87	146	7.7558751325299832e+04
C87_146	87	146	9.1328833078948706e-16
R88_90	88	90	2.5063619124751745e+04
C88_90	88	90	2.8261482183970748e-15
R88_100	88	100	9.1750448370110782e+04
C88_100	88	100	7.7202350282001654e-16
R88_104	88	104	6.5787297554022749e+04
C88_104	88	104	1.0767048529061928e-15
R88_143	88	143	1.6205888489049187e+05
C88_143	88	143	4.3708496812047281e-16
R88_146	88	146	1.1498931252660738e+05
C88_146	88	146	6.1600074806612861e-16
R88_147	88	147	1.1353898211786694e+05
C88_147	88	147	6.2386945183695957e-16
R88_150	88	150	8.0551814768285083e+04
C88_150	88	150	8.7935328011863263e-16
R89_90	89	90	2.7883527030389570e+04
C89_90	89	90	2.5403351039056250e-15
R89_97	89	97	1.1953713259993005e+04
C89_97	89	97	5.9256484571256518e-15
R89_99	89	99	3.5883421990821378e+04
C89_99	89	99	1.9739896198896112e-15
R89_143	89	143	1.4916269345031096e+04
C89_143	89	143	4.7487411830355586e-15
R89_144	89	144	5.5069841282270827e+04
C89_144	89	144	1.2862485325303477e-15
R89_148	89	148	4.1755340281410601e+04
C89_148	89	148	1.6963938518670137e-15
R89_149	89	149	7.2885426314732802e+04
C89_149	89	149	9.7184726930357516e-16
R89_151	89	151	3.0030231097381737e+04
C89_151	89	151	2.3587398414052099e-15
R90_99	90	99	1.4937465597545766e+04
C90_99	90	99	4.7420027228473071e-15
R90_100	90	100	1.2392243234664847e+04
C90_100	90	100	5.7159548271177658e-15
R90_104	90	104	6.2508067165280605e+04
C90_104	90	104	1.1331897745087158e-15
R90_143	90	143	2.3336421232981025e+04
C90_143	90	143	3.0353198474105375e-15
R90_147	90	147	4.1351833162924675e+04
C90_147	90	147	1.7129470961279674e-15
R90_150	90	150	1.2213305114160290e+04
C90_150	90	150	5.7996997433458518e-15
R90_151	90	151	1.4515130244022175e+04
C90_151	90	151	4.8799770546441817e-15
R91_94	91	94	3.1538919311101239e+04
C91_94	91	94	2.2459077255404769e-15
R91_97	91	97	5.0962043055137561e+04
C91_97	91	97	1.3899266648192036e-15
R91_144	91	144	3.2637391620839557e+04
C91_144	91	144	2.1703175106300942e-15
R91_155	91	155	3.0328773245676304e+04
C91_155	91	155	2.3355215182037770e-15
R91_145	91	145	6.5476492911324807e+04
C91_145	91	145	1.0818157690872391e-15
R91_156	91	156	6.5476492911324778e+04
C91_156	91	156	1.0818157690872397e-15
R92_93	92	93	2.1368999622010357e+04
C92_93	92	93	3.3147785946442041e-15
R92_96	92	96	2.4918723740718040e+04
C92_96	92	96	2.8425814770062108e-15
R92_102	92	102	2.1502867146599448e+04
C92_102	92	102	3.2941422208062110e-15
R92_109	92	109	2.2665971973183663e+04
C92_109	92	109	3.1251032437436984e-15
R92_110	92	110	3.7466773891545105e+04
C92_110	92	110	1.8905685005344049e-15
R92_157	92	157	3.1359646626537080e+04
C92_157	92	157	2.2587468340940891e-15
R93_109	93	109	2.3754051717567385e+04
C93_109	93	109	2.9819545473000244e-15
R93_112	93	112	1.7339323621202158e+04
C93_112	93	112	4.0851364265089495e-15
R93_103	93	103	4.1097399473883641e+04
C93_103	93	103	1.7235519386333168e-15
R93_114	93	114	1.0612982665773945e+05
C93_114	93	114	6.6742314358462688e-16
R93_157	93	157	9.6257056217423451e+04
C93_157	93	157	7.3587854563101073e-16
R94_95	94	95	4.9318946271105895e+04
C94_95	94	95	1.4362330887328522e-15
R94_96	94	96	2.1902541760755435e+05
C94_96	94	96	3.2340311599322299e-16
R94_97	94	97	7.1596692727816233e+04
C94_97	94	97	9.8934042673287176e-16
R94_154	94	154	1.1743065241184586e+05
C94_154	94	154	6.0319432006199644e-16
R94_155	94	155	1.9759677466134451e+05
C94_155	94	155	3.5847499361970628e-16
R94_156	94	156	1.9563305882328935e+05
C94_156	94	156	3.6207327617354398e-16
R94_158	94	158	1.7093746131052644e+05
C94_158	94	158	4.1438255835169602e-16
R95_96	95	96	9.7659867372688004e+03
C95_96	95	96	7.2530819917752253e-15
R95_97	95	97	3.0172872512384114e+04
C95_97	95	97	2.3475889644556447e-15
R95_101	95	101	1.4369372639563395e+04
C95_101	95	101	4.9294777380171171e-15
R95_102	95	102	2.8982171443030307e+04
C95_102	95	102	2.4440371100293869e-15
R95_154	95	154	4.1110842772895208e+04
C95_154	95	154	1.7229883349095740e-15
R95_158	95	158	5.2879544826789301e+04
C95_158	95	158	1.3395255720906860e-15
R96_102	96	102	4.9810092826892913e+04
C96_102	96	102	1.4220712814603782e-15
R96_157	96	157	2.2311856044909649e+05
C96_157	96	157	3.1747023821516790e-16
R96_158	96	158	1.2958199709722494e+05
C96_158	96	158	5.4663073669758206e-16
R97_99	97	99	3.7872911830729085e+04
C97_99	97	99	1.8702946013917938e-15
R97_101	97	101	2.2660874263865073e+04
C97_101	97	101	3.1258062558050019e-15
R97_144	97	144	4.5400200198869636e+04
C97_144	97	144	1.5602024269876149e-15
R97_148	97	148	3.0668704615143200e+04
C97_148	97	148	2.3096346397697133e-15
R97_151	97	151	4.2074752779251634e+04
C97_151	97	151	1.6835155968148717e-15
R97_152	97	152	1.3706672054508786e+04
C97_152	97	152	5.1678118695996266e-15
R97_154	97	154	1.6002161033422715e+04
C97_154	97	154	4.4264960456312429e-15
R97_153	97	153	4.3963011739681533e+04
C97_153	97	153	1.6112067789037498e-15
R97_155	97	155	1.9660322759980154e+04
C97_155	97	155	3.6028657006682592e-15
R97_165	97	165	4.0659616129899921e+04
C97_165	97	165	1.7421094756453215e-15
R98_99	98	99	1.3908117454842975e+04
C98_99	98	99	5.0929611980904663e-15
R98_101	98	101	9.3369261956151422e+03
C98_101	98	101	7.5863834683908312e-15
R98_106	98	106	1.1204311434738158e+04
C98_106	98	106	6.3219862236590326e-15
R98_108	98	108	1.0127973804289833e+04
C98_108	98	108	6.9938473286727482e-15
R98_110	98	110	1.2332554175034658e+04
C98_110	98	110	5.7436198155440861e-15
R98_111	98	111	2.8568901482089390e+04
C98_111	98	111	2.4793918863281261e-15
R98_165	98	165	1.6734791695543692e+04
C98_165	98	165	4.2327089470054338e-15
R98_166	98	166	1.0378144188604903e+04
C98_166	98	166	6.8252571219596722e-15
R98_167	98	167	2.0426286392468803e+04
C98_167	98	167	3.4677621362499069e-15
R99_100	99	100	1.4752227516926738e+04
C99_100	99	100	4.8015462379986678e-15
R99_101	99	101	1.3823362266584945e+04
C99_101	99	101	5.1241876737344160e-15
R99_108	99	108	1.5559777137611365e+04
C99_108	99	108	4.5523468562271391e-15
R99_150	99	150	3.0011999596668586e+04
C99_150	99	150	2.3601727138455219e-15
R99_151	99	151	6.4289842488836193e+03
C99_151	99	151	1.1017837312060626e-14
R99_165	99	165	6.5899991915899600e+03
C99_165	99	165	1.0748635997770147e-14
R99_168	99	168	1.1673787689583705e+04
C99_168	99	168	6.0677394877759656e-15
R100_104	100	104	2.3760489624743477e+04
C100_104	100	104	2.9811465864001423e-15
R100_107	100	107	1.9582207534520221e+04
C100_107	100	107	3.6172378630515561e-15
R100_108	100	108	2.9685405915450523e+04
C100_108	100	108	2.3861389242157176e-15
R100_150	100	150	4.0220772543909581e+04
C100_150	100	150	1.7611174041639824e-15
R100_162	100	162	3.2996848652240267e+04
C100_162	100	162	2.1466747713555026e-15
R100_168	100	168	6.1535855702930858e+04
C100_168	100	168	1.1510931590511109e-15
R101_102	101	102	1.6889683771769061e+04
C101_102	101	102	4.1938915786213548e-15
R101_110	101	110	2.7930798335900352e+04
C101_110	101	110	2.5360357295965809e-15
R101_154	101	154	4.7427678937466109e+04
C101_154	101	154	1.4935055672742224e-15
R101_153	101	153	2.8914817451581610e+04
C101_153	101	153	2.4497302344935083e-15
R101_165	101	165	1.5214319841007296e+04
C101_165	101	165	4.6557127282865337e-15
R101_167	101	167	5.7230067619414178e+04
C101_167	101	167	1.2376973413180300e-15
R101_169	101	169	5.3775372222845173e+04
C101_169	101	169	1.3172108273368326e-15
R102_110	102	110	1.6865758663591612e+04
C102_110	102	110	4.1998408698275430e-15
R102_109	102	109	2.1887119079872860e+04
C102_109	102	109	3.2363100085263241e-15
R102_153	102	153	2.7341725334630963e+04
C102_153	102	153	2.5906742046846055e-15
R102_154	102	154	2.6630699691729373e+04
C102_154	102	154	2.6598438402276972e-15
R102_157	102	157	1.0865195198939267e+04
C102_157	102	157	6.5193032650637749e-15
R102_158	102	158	2.0385414772725173e+04
C102_158	102	158	3.4747148059392079e-15
R102_164	102	164	2.0733551436000980e+04
C102_164	102	164	3.4163709364815969e-15
R102_169	102	169	1.6776840756081427e+04
C102_169	102	169	4.2221001895320261e-15
R102_171	102	171	3.0939896580544450e+04
C102_171	102	171	2.2893904105853204e-15
R103_112	103	112	2.6794182248476038e+04
C103_112	103	112	2.6436150160928605e-15
R103_109	103	109	2.4274396295327373e+04
C103_109	103	109	2.9180335392989732e-15
R103_114	103	114	6.7610702167144904e+04
C103_114	103	114	1.0476670152143639e-15
R103_157	103	157	5.7829870034311833e+04
C103_157	103	157	1.2248601370532706e-15
R103_170	103	170	1.7089168667652393e+04
C103_170	103	170	4.1449355386186082e-15
R103_163	103	163	6.3735406559701871e+04
C103_163	103	163	1.1113681760176622e-15
R103_171	103	171	3.9831633602243943e+04
C103_171	103	171	1.7783228085330038e-15
R103_172	103	172	4.4540784106384650e+04
C103_172	103	172	1.5903065910742793e-15
R104_107	104	107	4.0196424014581011e+04
C104_107	104	107	1.7621841811178423e-15
R104_118	104	118	2.9065594115010103e+04
C104_118	104	118	2.4370223521225067e-15
R104_105	104	105	6.0916766366638803e+04
C104_105	104	105	1.1627915721868013e-15
R104_120	104	120	3.1235126853330585e+04
C104_120	104	120	2.2677513963240742e-15
R104_146	104	146	2.8184481969670916e+04
C104_146	104	146	2.5132093118554866e-15
R104_150	104	150	2.3843313343047939e+04
C104_150	104	150	2.9707910774344260e-15
R104_162	104	162	2.3944489050794200e+04
C104_162	104	162	2.9582382144692529e-15
R104_174	104	174	1.5866117325635232e+04
C104_174	104	174	4.4644509480307942e-15
R104_176	104	176	5.5262089223991206e+04
C104_176	104	176	1.2817738802616372e-15
R105_118	105	118	6.3724106230916535e+04
C105_118	105	118	1.1115652572563549e-15
R105_146	105	146	8.0768082651045683e+04
C105_146	105	146	8.7699868823223774e-16
R105_161	105	161	2.4586464304668529e+05
C105_161	105	161	2.8809958869340156e-16
R105_176	105	176	8.0289174805299874e+04
C105_176	105	176	8.8222979882120197e-16
R106_107	106	107	1.1555194099260209e+04
C106_107	106	107	6.1300140809002027e-15
R106_108	106	108	1.5364009577399258e+04
C106_108	106	108	4.6103526673269850e-15
R106_111	106	111	2.9067289747204162e+04
C106_111	106	111	2.4368801891071777e-15
R106_121	106	121	1.8020554977029853e+04
C106_121	106	121	3.9307059425355594e-15
R106_131	106	131	5.4394509743836563e+04
C106_131	106	131	1.3022178684867389e-15
R106_166	106	166	2.2349123527557309e+04
C106_166	106	166	3.1694085205918542e-15
R106_177	106	177	3.8251241770033892e+04
C106_177	106	177	1.8517961576737917e-15
R107_108	107	108	1.5353936775855327e+04
C107_108	107	108	4.6133772445506291e-15
R107_120	107	120	1.4792541301385632e+04
C107_120	107	120	4.7884606906160850e-15
R107_131	107	131	3.9323537486458175e+04
C107_131	107	131	1.8013003677604770e-15
R107_162	107	162	1.9535889615203487e+04
C107_162	107	162	3.6258140238914435e-15
R107_177	107	177	4.5988756511561536e+04
C107_177	107	177	1.5402352207151442e-15
R108_162	108	162	3.1102598438440586e+04
C108_162	108	162	2.2774143027373194e-15
R108_165	108	165	5.9644995155207660e+04
C108_165	108	165	1.1875850161724001e-15
R108_166	108	166	1.0648014500069186e+04
C108_166	108	166	6.6522732980444159e-15
R108_168	108	168	1.5173166632476792e+04
C108_168	108	168	4.6683401198789505e-15
R108_177	108	177	2.8108595965338493e+04
C108_177	108	177	2.5199943328135925e-15
R109_110	109	110	1.7105405553928704e+04
C109_110	109	110	4.1410010603186933e-15
R109_112	109	112	1.2662777394238161e+04
C109_112	109	112	5.5938361964912067e-15
R109_115	109	115	2.0331048997663154e+04
C109_115	109	115	3.4840062873362611e-15
R109_157	109	157	1.8721707959437215e+04
C109_157	109	157	3.7834957520686221e-15
R109_169	109	169	3.2836765348400171e+04
C109_169	109	169	2.1571400771194126e-15
R109_170	109	170	3.9973657445908160e+04
C109_170	109	170	1.7720045415371609e-15
R109_171	109	171	1.1755928225528698e+04
C109_171	109	171	6.0253432291446661e-15
R109_178	109	178	2.0007701668025129e+04
C109_178	109	178	3.5403118114861254e-15
R110_111	110	111	1.7299293783328412e+04
C110_111	110	111	4.0945892603005160e-15
R110_115	110	115	2.0932721004888201e+04
C110_115	110	115	3.3838650273635705e-15
R110_166	110	166	5.1583370276175912e+04
C110_166	110	166	1.3731848492403544e-15
R110_167	110	167	1.6241010120485795e+04
C110_167	110	167	4.3613975984568412e-15
R110_169	110	169	2.7787523182451503e+04
C110_169	110	169	2.5491117747670685e-15
R110_178	110	178	5.1678846141410904e+04
C110_178	110	178	1.3706479115686029e-15
R110_179	110	179	4.1757999572991554e+04
C110_179	110	179	1.6962858197310305e-15
R111_115	111	115	1.2400595660699175e+04
C111_115	111	115	5.7121048435189631e-15
R111_121	111	121	9.0077498308905615e+03
C111_121	111	121	7.8636178697024221e-15
R111_122	111	122	4.4445973186521158e+04
C111_122	111	122	1.5936989890792002e-15
R111_124	111	124	3.8038249737434468e+04
C111_124	111	124	1.8621651370644120e-15
R111_125	111	125	1.3231064926153542e+04
C111_125	111	125	5.3535753116882560e-15
R111_166	111	166	2.4919844703143419e+04
C111_166	111	166	2.8424536099562837e-15
R111_179	111	179	1.6622155357659805e+04
C111_179	111	179	4.2613909575426133e-15
R112_114	112	114	1.8119864217322058e+04
C112_114	112	114	3.9091629874513782e-15
R112_113	112	113	5.5129252863522335e+04
C112_113	112	113	1.2848623708243430e-15
R112_115	112	115	1.3931495153104928e+04
C112_115	112	115	5.0844149717995826e-15
R112_124	112	124	1.8065757706052744e+04
C112_124	112	124	3.9208708368909422e-15
R112_170	112	170	2.3829672070159995e+04
C112_170	112	170	2.9724917039332313e-15
R112_178	112	178	3.6823723346515966e+04
C112_178	112	178	1.9235833886065149e-15
R112_180	112	180	2.5336022178998366e+04
C112_180	112	180	2.7957625721813422e-15
R113_114	113	114	1.8618349267882215e+04
C113_114	113	114	3.8044996104027398e-15
R113_116	113	116	5.8196382181213608e+04
C113_116	113	116	1.2171461503472256e-15
R113_124	113	124	4.2858039375179949e+04
C113_124	113	124	1.6527471524285661e-15
R113_126	113	126	1.0858023778053373e+04
C113_126	113	126	6.5236090824530360e-15
R113_128	113	128	1.1896713189085416e+04
C113_128	113	128	5.9540396923232436e-15
R113_136	113	136	4.5732792712672061e+04
C113_136	113	136	1.5488558282681222e-15
R113_180	113	180	1.9182324533118579e+04
C113_180	113	180	3.6926443619335541e-15
R114_116	114	116	7.4020705051772558e+04
C114_116	114	116	9.5694174334676606e-16
R114_163	114	163	7.6284769880510881e+04
C114_163	114	163	9.2854055464741506e-16
R114_170	114	170	7.1881721780133870e+04
C114_170	114	170	9.8541744384838083e-16
R114_180	114	180	5.1535874570899585e+04
C114_180	114	180	1.3744503828794453e-15
R115_124	115	124	1.0101770439105678e+04
C115_124	115	124	7.0119889343150612e-15
R115_125	115	125	1.6999301259920994e+04
C115_125	115	125	4.1668478870365768e-15
R115_178	115	178	1.7640142620354640e+04
C115_178	115	178	4.0154722136014089e-15
R115_179	115	179	4.4340268033264518e+04
C115_179	115	179	1.5974982939403974e-15
R115_180	115	180	5.4082041954722976e+04
C115_180	115	180	1.3097416439139116e-15
R116_128	116	128	5.6858379120533820e+04
C116_128	116	128	1.2457882836554379e-15
R116_180	116	180	5.4490538030019321e+04
C116_180	116	180	1.2999229792331506e-15
R116_163	116	163	5.6599775787921833e+04
C116_163	116	163	1.2514802673673415e-15
R116_185	116	185	4.4513412579564778e+04
C116_185	116	185	1.5912844787936627e-15
R116_173	116	173	1.6755584592673313e+05
C116_173	116	173	4.2274563530879883e-16
R117_118	117	118	8.1621247055797590e+04
C117_118	117	118	8.6783166260100263e-16
R117_119	117	119	1.8634389457326190e+04
C117_119	117	119	3.8012247569587809e-15
R117_120	117	120	5.1290404837653106e+04
C117_120	117	120	1.3810283377603602e-15
R117_133	117	133	1.2394223975251194e+05
C117_133	117	133	5.7150413513133584e-16
R117_188	117	188	7.3106539060429219e+04
C117_188	117	188	9.6890789040703545e-16
R117_189	117	189	1.3447278120051025e+05
C117_189	117	189	5.2674974001155876e-16
R118_120	118	120	1.0852926716238796e+05
C118_120	118	120	6.5266728863113662e-16
R118_174	118	174	9.9082617746842079e+04
C118_174	118	174	7.1489332989748926e-16
R118_176	118	176	1.0665448828262182e+05
C118_176	118	176	6.6413991268983987e-16
R118_189	118	189	1.0600488466230752e+05
C118_189	118	189	6.6820979770554373e-16
R119_120	119	120	6.7699392004727415e+04
C119_120	119	120	1.0462945151863955e-15
R119_131	119	131	4.7089883459161509e+04
C119_131	119	131	1.5042191089181609e-15
R119_132	119	132	8.7247807208982689e+04
C119_132	119	132	8.1186570530459428e-16
R119_133	119	133	3.5992350447667523e+04
C119_133	119	133	1.9680154714816725e-15
R119_188	119	188	4.8494529175363939e+04
C119_188	119	188	1.4606493503598061e-15
R119_191	119	191	1.0105807042070238e+05
C119_191	119	191	7.0091881075031221e-16
R120_131	120	131	4.7000665617671271e+04
C120_131	120	131	1.5070744553321410e-15
R120_162	120	162	3.7052746551522352e+04
C120_162	120	162	1.9116937104110500e-15
R120_174	120	174	6.3912415159183649e+04
C120_174	120	174	1.1082901868060896e-15
R120_177	120	177	1.0662540266613961e+05
C120_177	120	177	6.6432107888765023e-16
R120_187	120	187	3.1721993946159870e+04
C120_187	120	187	2.2329460958923997e-15
R120_188	120	188	6.5142792785541729e+04
C120_188	120	188	1.0873574728242436e-15
R120_189	120	189	5.6361649311438108e+04
C120_189	120	189	1.2567677383710799e-15
R120_193	120	193	8.6895331316695592e+04
C120_193	120	193	8.1515889821333183e-16
R121_122	121	122	3.0952491505862909e+04
C121_122	121	122	2.2884588312570241e-15
R121_125	121	125	5.8263345201272634e+04
C121_125	121	125	1.2157472642757355e-15
R121_129	121	129	2.5956950279214394e+04
C121_129	121	129	2.7288838547693911e-15
R121_131	121	131	4.3692226761351361e+04
C121_131	121	131	1.6211923215288466e-15
R121_166	121	166	3.7876392565291288e+04
C121_166	121	166	1.8701227265478697e-15
R121_177	121	177	2.3469322156420953e+04
C121_177	121	177	3.0181315874357592e-15
R121_179	121	179	2.8972211471780185e+04
C121_179	121	179	2.4448773130416363e-15
R121_190	121	190	2.5930240175759394e+04
C121_190	121	190	2.7316948109959250e-15
R121_192	121	192	5.7296856495901062e+04
C121_192	121	192	1.2362546022235501e-15
R121_195	121	195	4.9987852317235694e+04
C121_195	121	195	1.4170143195285220e-15
R122_123	122	123	8.0912852339964302e+03
C122_123	122	123	8.7542955769727686e-15
R122_125	122	125	2.0762660340492559e+04
C122_125	122	125	3.4115812412466415e-15
R122_127	122	127	1.2620526947683182e+04
C122_127	122	127	5.6125629959534537e-15
R122_129	122	129	6.2698708969552690e+03
C122_129	122	129	1.1297441956962415e-14
R122_132	122	132	1.6174193125250837e+04
C122_132	122	132	4.3794149103744855e-15
R122_190	122	190	1.6924132391667579e+04
C122_190	122	190	4.1853550242182080e-15
R122_196	122	196	3.3561979763737028e+04
C122_196	122	196	2.1105281343543989e-15
R123_127	123	127	1.8406113677852711e+04
C123_127	123	127	3.8483681985095485e-15
R123_130	123	130	3.1314665034628935e+04
C123_130	123	130	2.2619913851120443e-15
R123_129	123	129	6.3370795036725722e+04
C123_129	123	129	1.1177625670460561e-15
R123_132	123	132	4.4303724409860566e+04
C123_132	123	132	1.5988159794582586e-15
R123_135	123	135	2.4358198424844781e+04
C123_135	123	135	2.9079943147089042e-15
R123_137	123	137	2.6659924892480645e+04
C123_137	123	137	2.6569280604379495e-15
R123_139	123	139	1.1637129747800429e+04
C123_139	123	139	6.0868533797510048e-15
R123_196	123	196	4.6916852323349041e+04
C123_196	123	196	1.5097667262035906e-15
R124_125	124	125	1.3717204526870586e+04
C124_125	124	125	5.1638438719233557e-15
R124_126	124	126	1.5830984096307720e+04
C124_126	124	126	4.4743587704393307e-15
R124_127	124	127	2.9758953320493354e+04
C124_127	124	127	2.3802417300483776e-15
R124_180	124	180	2.5819113217514056e+04
C124_180	124	180	2.7434521836308085e-15
R124_197	124	197	4.2647460778761924e+04
C124_197	124	197	1.6609078534231160e-15
R125_127	125	127	3.2314777213068999e+04
C125_127	125	127	2.1919848640439630e-15
R125_179	125	179	2.5534331245987196e+04
C125_179	125	179	2.7740496453037803e-15
R125_178	125	178	4.2024046980583596e+04
C125_178	125	178	1.6855469100519344e-15
R125_180	125	180	3.9218785540690791e+04
C125_180	125	180	1.8061115753446243e-15
R125_181	125	181	2.0881827835758519e+04
C125_181	125	181	3.3921121796964102e-15
R125_190	125	190	1.2834598278364916e+04
C125_190	125	190	5.5189497169851404e-15
R125_197	125	197	2.0712335582365700e+04
C125_197	125	197	3.4198703595893372e-15
R126_127	126	127	1.6088694733182134e+04
C126_127	126	127	4.4026879564014249e-15
R126_135	126	135	2.4385773882673850e+04
C126_135	126	135	2.9047059517896775e-15
R126_136	126	136	1.6337588210776654e+04
C126_136	126	136	4.3356156136483216e-15
R126_128	126	128	2.8188182527822788e+04
C126_128	126	128	2.5128793765289655e-15
R126_180	126	180	3.5288715164556095e+04
C126_180	126	180	2.0072564899485206e-15
R126_197	126	197	1.7978512708310736e+04
C126_197	126	197	3.9398977927276802e-15
R126_198	126	198	2.8916181742472792e+04
C126_198	126	198	2.4496146540661018e-15
R127_135	127	135	3.0371661093778384e+04
C127_135	127	135	2.3322235263092086e-15
R127_190	127	190	7.9127980974218037e+04
C127_190	127	190	8.9517641754412290e-16
R127_196	127	196	2.7879214145676975e+04
C127_196	127	196	2.5407280910385221e-15
R127_197	127	197	3.8268519175177193e+04
C127_197	127	197	1.8509601119331013e-15
R127_198	127	198	1.2142226982240805e+05
C127_198	127	198	5.8336500083222731e-16
R128_136	128	136	5.6411415601321212e+04
C128_136	128	136	1.2556590147746802e-15
R128_180	128	180	2.7187420378789146e+04
C128_180	128	180	2.6053778383204869e-15
R128_185	128	185	9.0311984078345646e+04
C128_185	128	185	7.8432007954284296e-16
R128_197	128	197	6.0390789859150944e+04
C128_197	128	197	1.1729189616695617e-15
R128_198	128	198	4.1821532962416764e+04
C128_198	128	198	1.6937088987066800e-15
R128_199	128	199	4.1308534915985663e+04
C128_199	128	199	1.7147425509053509e-15
R129_131	129	131	1.0329435538693951e+04
C129_131	129	131	6.8574417518419556e-15
R129_132	129	132	7.1673416467763718e+03
C129_132	129	132	9.8828137441806657e-15
R129_139	129	139	3.1716133481314406e+04
C129_139	129	139	2.2333586966939600e-15
R129_190	129	190	8.4017192996663089e+03
C129_190	129	190	8.4308342149461372e-15
R129_191	129	191	1.8058823892356842e+04
C129_191	129	191	3.9223762830966722e-15
R129_192	129	192	7.3278415497262713e+03
C129_192	129	192	9.6663529165209609e-15
R129_196	129	196	2.2912602831605032e+04
C129_196	129	196	3.0914646867746593e-15
R129_201	129	201	1.0708551617833875e+04
C129_201	129	201	6.6146669562702455e-15
R130_132	130	132	1.5378605203083011e+04
C130_132	130	132	4.6059770441209925e-15
R130_134	130	134	4.1022502331359363e+04
C130_134	130	134	1.7266987265633433e-15
R130_137	130	137	3.7817809408278037e+04
C130_137	130	137	1.8730197133125081e-15
R130_139	130	139	1.8341652562562787e+04
C130_139	130	139	3.8618931579032585e-15
R130_140	130	140	2.8712545656447353e+04
C130_140	130	140	2.4669878938475265e-15
R130_202	130	202	1.4753782929644136e+04
C130_202	130	202	4.8010400365642713e-15
R130_142	130	142	6.2760843806414916e+04
C130_142	130	142	1.1286257201143615e-15
R131_132	131	132	2.5733857069690410e+04
C131_132	131	132	2.7525412278530292e-15
R131_177	131	177	1.6450618614407937e+04
C131_177	131	177	4.3058260723376030e-15
R131_188	131	188	2.4155737670919061e+04
C131_188	131	188	2.9323676014778059e-15
R131_191	131	191	1.3022831130064425e+04
C131_191	131	191	5.4391784573228645e-15
R131_192	131	192	1.1391324990296685e+04
C131_192	131	192	6.2181969697411957e-15
R131_193	131	193	9.2337350590883925e+03
C131_193	131	193	7.6711647109997429e-15
R131_203	131	203	3.8071096119243011e+04
C131_203	131	203	1.8605585275018458e-15
R132_133	132	133	2.9512080670712250e+04
C132_133	132	133	2.4001527823924353e-15
R132_134	132	134	4.0418702614476417e+04
C132_134	132	134	1.7524932260104308e-15
R132_139	132	139	3.4126644446933984e+04
C132_139	132	139	2.0756070127593183e-15
R132_191	132	191	7.7419961199825093e+03
C132_191	132	191	9.1492557524247414e-15
R132_201	132	201	3.3228990289991751e+04
C132_201	132	201	2.1316778487047310e-15
R132_202	132	202	1.6485448619447838e+04
C132_202	132	202	4.2967288407570494e-15
R132_204	132	204	3.8301400632330733e+04
C132_204	132	204	1.8493710769472094e-15
R133_134	133	134	4.5952498283528526e+04
C133_134	133	134	1.5414505235157142e-15
R133_188	133	188	3.4052318195616252e+04
C133_188	133	188	2.0801374558140599e-15
R133_191	133	191	1.9477595462546014e+04
C133_191	133	191	3.6366656588698345e-15
R133_203	133	203	7.3912429071581675e+04
C133_203	133	203	9.5834358883537926e-16
R133_204	133	204	4.7624689747783996e+04
C133_204	133	204	1.4873273277186219e-15
R134_202	134	202	5.8436125847516429e+04
C134_202	134	202	1.2121526112260310e-15
R134_142	134	142	8.1246829591442933e+04
C134_142	134	142	8.7183097349389160e-16
R134_204	134	204	4.3433834327957862e+04
C134_204	134	204	1.6308369645920319e-15
R135_136	135	136	2.3016275290001839e+04
C135_136	135	136	3.0775397688595493e-15
R135_137	135	137	1.4931580048758444e+04
C135_137	135	137	4.7438718678596776e-15
R135_138	135	138	2.2461420418874139e+04
C135_138	135	138	3.1535629187760194e-15
R135_139	135	139	3.1399437002574105e+04
C135_139	135	139	2.2558844774889795e-15
R135_196	135	196	3.1100363971916191e+04
C135_196	135	196	2.2775779280256360e-15
R135_198	135	198	5.1176012358024374e+04
C135_198	135	198	1.3841153163801233e-15
R135_205	135	205	6.6165883187126063e+04
C135_205	135	205	1.0705442007880905e-15
R135_206	135	206	2.1063543785968242e+04
C135_206	135	206	3.3628483058575684e-15
R136_138	136	138	5.6101294785684244e+04
C136_138	136	138	1.2626001379575125e-15
R136_198	136	198	3.1608917749282195e+04
C136_198	136	198	2.2409341280787304e-15
R136_206	136	206	9.1275794719519734e+04
C136_206	136	206	7.7603819012108740e-16
R137_138	137	138	7.8391160207263791e+04
C137_138	137	138	9.0359043479798522e-16
R137_139	137	139	2.6580229512968104e+04
C137_139	137	139	2.6648943155829933e-15
R137_140	137	140	9.2576230510265217e+04
C137_140	137	140	7.6513703512853343e-16
R137_141	137	141	8.3331447155364585e+04
C137_141	137	141	8.5002126992870780e-16
R137_206	137	206	1.1333407315252982e+05
C137_206	137	206	6.2499741309631807e-16
R138_141	138	141	2.9881201809280500e+05
C138_141	138	141	2.3705038032975151e-16
R138_206	138	206	1.1289396911789298e+05
C138_206	138	206	6.2743389296579644e-16
R139_140	139	140	2.0948939508888525e+04
C139_140	139	140	3.3812452657064442e-15
R139_141	139	141	4.1365709257766655e+04
C139_141	139	141	1.7123724893632908e-15
R139_196	139	196	2.6486218651363099e+04
C139_196	139	196	2.6743531595951163e-15
R139_201	139	201	1.3931490507855015e+04
C139_201	139	201	5.0844166671227203e-15
R139_202	139	202	1.4614805835575617e+04
C139_202	139	202	4.8466947377142596e-15
R139_205	139	205	9.9002942743006552e+03
C139_205	139	205	7.1546865753143068e-15
R139_206	139	206	4.4835577165190589e+04
C139_206	139	206	1.5798503557793756e-15
R139_207	139	207	1.5114759642481426e+04
C139_207	139	207	4.6863796852525470e-15
R140_141	140	141	2.8139010270291194e+04
C140_141	140	141	2.5172705740395254e-15
R140_202	140	202	3.5809885618993118e+04
C140_202	140	202	1.9780432501138960e-15
R140_142	140	142	5.2050875274582686e+04
C140_142	140	142	1.3608513240619645e-15
R140_207	140	207	4.3120188449207235e+04
C140_207	140	207	1.6426992803947797e-15
R140_208	140	208	5.5073239458992532e+04
C140_208	140	208	1.2861691673093346e-15
R140_209	140	209	4.6284925572448956e+04
C140_209	140	209	1.5303795276742017e-15
R140_210	140	210	7.6211301615168006e+04
C140_210	140	210	9.2943567469397893e-16
R141_206	141	206	5.8002772433404869e+04
C141_206	141	206	1.2212089106141708e-15
R141_205	141	205	7.3344714397024494e+04
C141_205	141	205	9.6576151558200941e-16
R141_207	141	207	6.2126545802278844e+04
C141_207	141	207	1.1401487338670258e-15
R141_208	141	208	3.1077375010720003e+04
C141_208	141	208	2.2792627276778142e-15
R141_210	141	210	1.8903429356216337e+05
C141_210	141	210	3.7471244609225694e-16
R142_202	142	202	4.2414629408448287e+04
C142_202	142	202	1.6700252607156141e-15
R142_204	142	204	9.8316889043918738e+04
C142_204	142	204	7.2046118652471052e-16
R142_209	142	209	4.1121540535568893e+04
C142_209	142	209	1.7225400997496962e-15
R142_210	142	210	2.4544277790251098e+05
C142_210	142	210	2.8859477203332024e-16
R143_144	143	144	4.1549028313180861e+04
C143_144	143	144	1.7048173064863000e-15
R143_147	143	147	1.8400260225083959e+04
C143_147	143	147	3.8495924334503157e-15
R143_148	143	148	2.8183657678081257e+04
C143_148	143	148	2.5132828160586127e-15
R143_149	143	149	1.2343301849521640e+04
C143_149	143	149	5.7386186775255062e-15
R143_151	143	151	2.7306459455793211e+04
C143_151	143	151	2.5940200211848520e-15
R143_211	143	211	3.6103080655691490e+04
C143_211	143	211	1.9619794557568711e-15
R144_148	144	148	1.6747312003211075e+04
C144_148	144	148	4.2295445694460458e-15
R144_155	144	155	1.9534528793445879e+04
C144_155	144	155	3.6260666067238685e-15
R144_145	144	145	8.8230127395514530e+04
C144_145	144	145	8.0282670587644485e-16
R144_211	144	211	7.2259381202224511e+04
C144_211	144	211	9.8026721731488330e-16
R144_213	144	213	5.5461135919320972e+04
C144_213	144	213	1.2771736705689031e-15
R145_155	145	155	4.2953840122690752e+04
C145_155	145	155	1.6490609997540492e-15
R145_156	145	156	9.0582089017822043e+04
C145_156	145	156	7.8198133101195658e-16
R145_213	145	213	4.4192319895392960e+04
C145_213	145	213	1.6028464381066445e-15
R145_214	145	214	6.0388059345214635e+04
C145_214	145	214	1.1729719965179359e-15
R145_215	145	215	1.8116417803564380e+05
C145_215	145	215	3.9099066550597888e-16
R146_150	146	150	4.2310813771469628e+04
C146_150	146	150	1.6741229067015331e-15
R146_147	146	147	1.6810105776275808e+05
C146_147	146	147	4.2137452005785531e-16
R146_159	146	159	1.0899985222179776e+05
C146_159	146	159	6.4984952816142199e-16
R146_174	146	174	1.2131564893059975e+05
C146_174	146	174	5.8387770382798063e-16
R146_175	146	175	8.5197101700733110e+04
C146_175	146	175	8.3140742022906756e-16
R146_161	146	161	7.6536753147413474e+04
C146_161	146	161	9.2548350463170644e-16
R146_176	146	176	9.7342048644827169e+04
C146_176	146	176	7.2767630764019419e-16
R146_220	146	220	1.3753732044768662e+05
C146_220	146	220	5.1501296015827254e-16
R147_150	147	150	5.3198926284140907e+04
C147_150	147	150	1.3314836874276563e-15
R147_151	147	151	8.8228630778294391e+04
C147_151	147	151	8.0284032417996162e-16
R147_149	147	149	5.2221933810477633e+04
C147_149	147	149	1.3563937098359274e-15
R147_159	147	159	1.1904836226401788e+05
C147_159	147	159	5.9499770672115588e-16
R147_211	147	211	2.0064302233589665e+05
C147_211	147	211	3.5303247385008780e-16
R147_212	147	212	1.3973028571451092e+05
C147_212	147	212	5.0693020610236981e-16
R147_222	147	222	5.2726176432474742e+04
C147_222	147	222	1.3434219457713747e-15
R148_149	148	149	2.4879522114186198e+04
C148_149	148	149	2.8470604142195737e-15
R148_151	148	151	8.5349354781099930e+04
C148_151	148	151	8.2992428844565362e-16
R148_152	148	152	4.7512984128219068e+04
C148_152	148	152	1.4908241154638475e-15
R148_155	148	155	4.6681327271568320e+04
C148_155	148	155	1.5173840735917072e-15
R148_211	148	211	4.9815036626469453e+04
C148_211	148	211	1.4219301506718616e-15
R148_213	148	213	1.4831344305177571e+05
C148_213	148	213	4.7759327191448371e-16
R148_217	148	217	5.2854341396203701e+04
C148_217	148	217	1.3401643207512877e-15
R148_218	148	218	1.0482289319398745e+05
C148_218	148	218	6.7574458572626911e-16
R148_221	148	221	6.9129718794232962e+04
C148_221	148	221	1.0246461836021409e-15
R148_223	148	223	6.4570582124049433e+04
C148_223	148	223	1.0969934017308159e-15
R149_151	149	151	3.1700241646342085e+04
C149_151	149	151	2.2344783149050076e-15
R149_211	149	211	3.8040289975610976e+04
C149_211	149	211	1.8620652624208165e-15
R149_212	149	212	1.3925988828536947e+05
C149_212	149	212	5.0864253453118505e-16
R149_221	149	221	4.6376084952970647e+04
C149_221	149	221	1.5273713295943649e-15
R149_222	149	222	5.8606807378370118e+04
C149_222	149	222	1.2086224400297630e-15
R149_223	149	223	7.0942863970197082e+04
C149_223	149	223	9.9845845758013085e-16
R150_151	150	151	2.5866751841178502e+04
C150_151	150	151	2.7383995861141250e-15
R150_159	150	159	9.5293650674509583e+04
C150_159	150	159	7.4331817528895970e-16
R150_162	150	162	3.0823801274639041e+04
C150_162	150	162	2.2980132107936933e-15
R150_168	150	168	4.4144551785301672e+04
C150_168	150	168	1.6045808524798448e-15
R150_174	150	174	5.7958913903203713e+04
C150_174	150	174	1.2221330208895553e-15
R150_175	150	175	3.0855604518730241e+04
C150_175	150	175	2.2956446208338590e-15
R150_220	150	220	5.9191818359458113e+04
C150_220	150	220	1.1966772520121726e-15
R150_222	150	222	4.3105441780461006e+04
C150_222	150	222	1.6432612591412456e-15
R150_224	150	224	2.5244148085474637e+04
C150_224	150	224	2.8059375303996595e-15
R151_152	151	152	3.2851266637333967e+04
C151_152	151	152	2.1561878669086375e-15
R151_165	151	165	3.7792009453167535e+04
C151_165	151	165	1.8742983916686948e-15
R151_168	151	168	3.2969327245473469e+04
C151_168	151	168	2.1484667251050780e-15
R151_222	151	222	3.5272925768963942e+04
C151_222	151	222	2.0081550081769858e-15
R151_223	151	223	1.7536011700731899e+04
C151_223	151	223	4.0393165643841144e-15
R151_224	151	224	2.9872920131973868e+04
C151_224	151	224	2.3711609786746232e-15
R151_226	151	226	4.4417588560194701e+04
C151_226	151	226	1.5947174268591029e-15
R152_154	152	154	1.6986970741468285e+04
C152_154	152	154	4.1698725225376728e-15
R152_153	152	153	1.8681140784493367e+04
C152_153	152	153	3.7917118313672079e-15
R152_155	152	155	2.5705616234425663e+04
C152_155	152	155	2.7555652387410131e-15
R152_165	152	165	3.0105032326682558e+04
C152_165	152	165	2.3528791388547742e-15
R152_217	152	217	1.7731968572066271e+04
C152_217	152	217	3.9946778750547896e-15
R152_223	152	223	2.2253272338710158e+04
C152_223	152	223	3.1830600667562608e-15
R152_225	152	225	4.1003942962679568e+04
C152_225	152	225	1.7274802718477660e-15
R152_226	152	226	4.7922968241677612e+04
C152_226	152	226	1.4780700180920255e-15
R152_228	152	228	5.1376865584890125e+04
C152_228	152	228	1.3787042422617555e-15
R152_229	152	229	4.6036305455581343e+04
C152_229	152	229	1.5386443771936586e-15
R153_154	153	154	9.8846276314511142e+03
C153_154	153	154	7.1660263974558290e-15
R153_164	153	164	1.7373263395087281e+04
C153_164	153	164	4.0771558529429712e-15
R153_165	153	165	1.5514609841692589e+04
C153_165	153	165	4.5655999898655725e-15
R153_169	153	169	3.4553393074423402e+04
C153_169	153	169	2.0499724117812124e-15
R153_225	153	225	1.1602371387668927e+04
C153_225	153	225	6.1050883624775434e-15
R153_229	153	229	4.7876937916798197e+04
C153_229	153	229	1.4794910789636613e-15
R154_155	154	155	2.1246478134874178e+04
C154_155	154	155	3.3338938381384357e-15
R154_156	154	156	3.8061924161482813e+04
C154_156	154	156	1.8610068748883892e-15
R154_158	154	158	1.2839953392865376e+04
C154_158	154	158	5.5166479479091579e-15
R154_164	154	164	3.6440983726432692e+04
C154_164	154	164	1.9437867832481286e-15
R154_217	154	217	4.7039486489768693e+04
C154_217	154	217	1.5058306929308554e-15
R154_229	154	229	3.7694205627489042e+04
C154_229	154	229	1.8791615675896790e-15
R154_232	154	232	3.6405937154545667e+04
C154_232	154	232	1.9456579907641712e-15
R155_156	155	156	2.3770267151919859e+04
C155_156	155	156	2.9799203384333432e-15
R155_213	155	213	8.7661856533527447e+04
C155_213	155	213	8.0803105634557015e-16
R155_214	155	214	9.8665429382270377e+04
C155_214	155	214	7.1791612299746806e-16
R155_217	155	217	2.2038234630321589e+04
C155_217	155	217	3.2141187224925363e-15
R155_232	155	232	1.3482810974177538e+05
C155_232	155	232	5.2536153382007140e-16
R156_158	156	158	1.5880294722347625e+05
C156_158	156	158	4.4604652353409533e-16
R156_214	156	214	1.6624853363599113e+05
C156_214	156	214	4.2606993870450151e-16
R156_232	156	232	1.0099800345130824e+05
C156_232	156	232	7.0133567115660150e-16
R157_158	157	158	7.3439664903323879e+04
C157_158	157	158	9.6451287773773728e-16
R157_164	157	164	6.4565223441286311e+04
C157_164	157	164	1.0970844482620570e-15
R157_171	157	171	1.8936081311718499e+04
C157_171	157	171	3.7406632011114708e-15
R157_172	157	172	1.1163394674053254e+05
C157_172	157	172	6.3451579563549971e-16
R157_235	157	235	7.5949287434008002e+04
C157_235	157	235	9.3264209486556323e-16
R158_164	158	164	4.0801058408280071e+04
C158_164	158	164	1.7360702221789723e-15
R158_232	158	232	6.5876391891758714e+04
C158_232	158	232	1.0752486665084256e-15
R158_235	158	235	9.1524562551128605e+04
C158_235	158	235	7.7392888380570082e-16
R159_220	159	220	1.4878512515011376e+04
C159_220	159	220	4.7607919450639958e-15
R159_161	159	161	7.9771790326148533e+04
C159_161	159	161	8.8795177150212925e-16
R159_222	159	222	2.7118728942886857e+04
C159_222	159	222	2.6119772311297565e-15
R159_212	159	212	5.0660006442103797e+04
C159_212	159	212	1.3982134529917846e-15
R159_160	159	160	1.0735990039089924e+04
C159_160	159	160	6.5977615737434572e-15
R159_238	159	238	7.6168282317058125e+04
C159_238	159	238	9.2996061327927084e-16
R159_239	159	239	5.0801504801130992e+04
C159_239	159	239	1.3943189835278865e-15
R160_220	160	220	7.8503423366578927e+03
C160_220	160	220	9.0229826290805779e-15
R160_222	160	222	1.7673021043075136e+04
C160_222	160	222	4.0080019348901796e-15
R160_212	160	212	1.8197597187695726e+04
C160_212	160	212	3.8924645822962803e-15
R160_237	160	237	7.3919113469854274e+03
C160_237	160	237	9.5825692721392487e-15
R160_238	160	238	7.8373428629563632e+03
C160_238	160	238	9.0379486740076788e-15
R160_239	160	239	2.4860985330036638e+04
C160_239	160	239	2.8491832321070606e-15
R160_240	160	240	1.3186792620265151e+04
C160_240	160	240	5.3715489866083711e-15
R161_176	161	176	3.5624648039650732e+04
C161_176	161	176	1.9883284869835434e-15
R161_175	161	175	4.5337571049807710e+04
C161_175	161	175	1.5623576847154547e-15
R161_220	161	220	3.2710901688480870e+04
C161_220	161	220	2.1654402318400164e-15
R161_239	161	239	5.4835681920822193e+04
C161_239	161	239	1.2917410717765346e-15
R161_241	161	241	3.6557121280548097e+04
C161_241	161	241	1.9376116076648037e-15
R162_168	162	168	8.8599149781136202e+03
C162_168	162	168	7.9948286988055597e-15
R162_174	162	174	7.2258595544666523e+03
C162_174	162	174	9.8027787562262264e-15
R162_175	162	175	1.8167126880633750e+04
C162_175	162	175	3.8989931099952236e-15
R162_177	162	177	2.2199910829011424e+04
C162_177	162	177	3.1907111285975496e-15
R162_187	162	187	1.6400973568854668e+04
C162_187	162	187	4.3188596237062604e-15
R162_224	162	224	2.7252769070881186e+04
C162_224	162	224	2.5991304719080309e-15
R162_242	162	242	1.2454100208907950e+04
C162_242	162	242	5.6875648459400914e-15
R163_170	163	170	9.0346683060056766e+03
C163_170	163	170	7.8401884980010126e-15
R163_172	163	172	5.4189836321582006e+04
C163_172	163	172	1.3071363071784990e-15
R163_180	163	180	3.2299976823125489e+04
C163_180	163	180	2.1929892681930986e-15
R163_183	163	183	2.3226416842746203e+04
C163_183	163	183	3.0496956554072122e-15
R163_185	163	185	3.9312875666690838e+04
C163_185	163	185	1.8017888881127073e-15
R163_173	163	173	3.7374747804229795e+04
C163_173	163	173	1.8952235586184634e-15
R163_245	163	245	3.8505187424853160e+04
C163_245	163	245	1.8395833723505144e-15
R164_169	164	169	7.3836862205276075e+03
C164_169	164	169	9.5932438649781286e-15
R164_171	164	171	1.3986344955697617e+04
C164_171	164	171	5.0644755838904551e-15
R164_225	164	225	8.8269286738797273e+03
C164_225	164	225	8.0247054386660569e-15
R164_229	164	229	1.7621940806100451e+04
C164_229	164	229	4.0196198202798709e-15
R164_230	164	230	7.7423874285754164e+03
C164_230	164	230	9.1487933391926927e-15
R164_231	164	231	7.7375077964642305e+03
C164_231	164	231	9.1545629935737762e-15
R164_232	164	232	3.4402111326173988e+04
C164_232	164	232	2.0589870739156670e-15
R164_234	164	234	1.8570728290227336e+04
C164_234	164	234	3.8142555008612900e-15
R164_235	164	235	1.1200560253036829e+04
C164_235	164	235	6.3241035212318762e-15
R164_249	164	249	2.9148042484145564e+04
C164_249	164	249	2.4301289726240911e-15
R165_166	165	166	2.0758739371740910e+04
C165_166	165	166	3.4122256302531737e-15
R165_167	165	167	1.0139640408956726e+04
C165_167	165	167	6.9858002531756550e-15
R165_168	165	168	1.3992646322197026e+04
C165_168	165	168	5.0621948775789695e-15
R165_169	165	169	2.3578368193404753e+04
C165_169	165	169	3.0041732300971217e-15
R165_225	165	225	6.7815169411407051e+03
C165_225	165	225	1.0445082295125143e-14
R165_226	165	226	8.9176073344384222e+03
C165_226	165	226	7.9431062480685763e-15
R165_250	165	250	2.0877370826856535e+04
C165_250	165	250	3.3928363453160571e-15
R166_167	166	167	1.0407774830400123e+04
C166_167	166	167	6.8058258071746572e-15
R166_168	166	168	2.5223155121443997e+04
C166_168	166	168	2.8082728823952480e-15
R166_177	166	177	6.9427639689256075e+03
C166_177	166	177	1.0202493250964068e-14
R166_179	166	179	1.3440940922007372e+04
C166_179	166	179	5.2699809445647944e-15
R166_250	166	250	1.7115479885185359e+04
C166_250	166	250	4.1385636284327236e-15
R167_169	167	169	7.4555212563476161e+03
C167_169	167	169	9.5008115597138829e-15
R167_178	167	178	3.4677178342959574e+04
C167_178	167	178	2.0426547349225482e-15
R167_179	167	179	9.6895705920165074e+03
C167_179	167	179	7.3102829339374024e-15
R167_225	167	225	2.1963057291524641e+04
C167_225	167	225	3.2251203280034271e-15
R167_249	167	249	2.6120447520062284e+04
C167_249	167	249	2.7118027928730952e-15
R167_250	167	250	1.0373785514106168e+04
C167_250	167	250	6.8281248382937295e-15
R168_177	168	177	3.9060873502538154e+04
C168_177	168	177	1.8134131724268085e-15
R168_224	168	224	1.4427637855847335e+04
C168_224	168	224	4.9095703152330017e-15
R168_226	168	226	2.0468705985411540e+04
C168_226	168	226	3.4605755042104014e-15
R168_242	168	242	1.9466006417009234e+04
C168_242	168	242	3.6388307400385042e-15
R168_250	168	250	2.9309927857587740e+04
C168_250	168	250	2.4167068196199142e-15
R168_251	168	251	3.7941270529153619e+04
C168_251	168	251	1.8669248959802862e-15
R169_171	169	171	1.0144854136647609e+04
C169_171	169	171	6.9822100526924970e-15
R169_178	169	178	2.2669684300219236e+04
C169_178	169	178	3.1245914851718939e-15
R169_225	169	225	1.7862088980606473e+04
C169_225	169	225	3.9655777447367189e-15
R169_231	169	231	3.2821004241779519e+04
C169_231	169	231	2.1581759660428811e-15
R169_249	169	249	2.0029877373304025e+04
C169_249	169	249	3.5363922212727792e-15
R169_252	169	252	6.9030280633723582e+04
C169_252	169	252	1.0261221870420079e-15
R170_171	170	171	2.0326604395982984e+04
C170_171	170	171	3.4847680978136408e-15
R170_172	170	172	2.0769576046150902e+04
C170_172	170	172	3.4104452771979977e-15
R170_178	170	178	9.4829537200665673e+03
C170_178	170	178	7.4695611332692230e-15
R170_180	170	180	1.1542718006429854e+04
C170_180	170	180	6.1366397841948754e-15
R170_182	170	182	2.8000579643598659e+04
C170_182	170	182	2.5297155786627999e-15
R170_183	170	183	1.6836677796052925e+04
C170_183	170	183	4.2070949740812715e-15
R170_184	170	184	3.3040948026003331e+04
C170_184	170	184	2.1438096291987087e-15
R170_245	170	245	4.9136999891881300e+04
C170_245	170	245	1.4415512280330232e-15
R170_252	170	252	1.5279501549101287e+04
C170_252	170	252	4.6358516544779771e-15
R171_172	171	172	1.2124483471641814e+04
C171_172	171	172	5.8421872322787061e-15
R171_178	171	178	2.3816354936297852e+04
C171_178	171	178	2.9741538000025612e-15
R171_231	171	231	1.0975309532455312e+04
C171_231	171	231	6.4538956579344594e-15
R171_235	171	235	3.2042392430902502e+04
C171_235	171	235	2.2106184077468065e-15
R171_252	171	252	3.4329159810661891e+04
C171_252	171	252	2.0633625444570499e-15
R172_231	172	231	1.2232685838809537e+04
C172_231	172	231	5.7905110512421515e-15
R172_235	172	235	3.3142908717080856e+04
C172_235	172	235	2.1372144231714507e-15
R172_245	172	245	2.7555126766569996e+04
C172_245	172	245	2.5706106575396174e-15
R172_246	172	246	3.8011799994520923e+04
C172_246	172	246	1.8634608870458661e-15
R172_247	172	247	3.7733499129002215e+04
C172_247	172	247	1.8772047165261944e-15
R172_252	172	252	3.1743230792932063e+04
C172_252	172	252	2.2314522109630935e-15
R173_185	173	185	6.0652855749563409e+04
C173_185	173	185	1.1678510708295853e-15
R173_183	173	183	4.7925005430336234e+04
C173_183	173	183	1.4780071885221498e-15
R173_245	173	245	6.7788433074726563e+04
C173_245	173	245	1.0449201924746766e-15
R173_244	173	244	5.2458212106390565e+04
C173_244	173	244	1.3502843442765928e-15
R173_248	173	248	1.0468569285858754e+05
C173_248	173	248	6.7663021184455408e-16
R173_253	173	253	5.4911775388211630e+04
C173_253	173	253	1.2899510539447323e-15
R174_175	174	175	6.0513145875366054e+03
C174_175	174	175	1.1705473498583259e-14
R174_176	174	176	9.6267537179160045e+03
C174_176	174	176	7.3579842812613299e-15
R174_187	174	187	1.9682306363878739e+04
C174_187	174	187	3.5988415801714530e-15
R174_189	174	189	1.8407103801220343e+04
C174_189	174	189	3.8481611936856658e-15
R174_242	174	242	4.1561115212118726e+04
C174_242	174	242	1.7043215076034776e-15
R174_254	174	254	2.8633463343695974e+04
C174_254	174	254	2.4738014289701679e-15
R175_176	175	176	1.4599653485463112e+04
C175_176	175	176	4.8517249129596797e-15
R175_220	175	220	1.0796643822737433e+04
C175_220	175	220	6.5606964255713066e-15
R175_224	175	224	1.4599653485462981e+04
C175_224	175	224	4.8517249129597231e-15
R175_241	175	241	2.0405122297488320e+04
C175_241	175	241	3.4713588825056422e-15
R175_242	175	242	2.1392244846005389e+04
C175_242	175	242	3.3111766925773049e-15
R175_243	175	243	1.7617793455808696e+04
C175_243	175	243	4.0205660665550465e-15
R175_254	175	254	2.0870657488582634e+04
C175_254	175	254	3.3939276984804968e-15
R176_189	176	189	9.1817998394428534e+04
C176_189	176	189	7.7145552914054949e-16
R176_241	176	241	1.0914232453484945e+05
C176_241	176	241	6.4900122695648339e-16
R176_254	176	254	7.4431997180201288e+04
C176_254	176	254	9.5165392867949977e-16
R177_179	177	179	2.9101888180259859e+04
C177_179	177	179	2.4339830493901482e-15
R177_187	177	187	5.7863206500604960e+04
C177_187	177	187	1.2241544639469547e-15
R177_192	177	192	3.6823763437767557e+04
C177_192	177	192	1.9235812943375321e-15
R177_193	177	193	1.6462811387967315e+04
C177_193	177	193	4.3026370688892347e-15
R177_194	177	194	2.3274043162807950e+04
C177_194	177	194	3.0434549786000370e-15
R177_186	177	186	2.8993532565283138e+04
C177_186	177	186	2.4430794135384545e-15
R177_195	177	195	2.1079688428572641e+04
C177_195	177	195	3.3602727467256174e-15
R177_242	177	242	3.1481379294365343e+04
C177_242	177	242	2.2500126780873941e-15
R177_250	177	250	2.6766546923623115e+04
C177_250	177	250	2.6463444365132178e-15
R177_257	177	257	5.0330230411876604e+04
C177_257	177	257	1.4073748909221202e-15
R178_179	178	179	2.2139027117669550e+04
C178_179	178	179	3.1994857840644021e-15
R178_180	178	180	3.1104282588566188e+04
C178_180	178	180	2.2772909914996121e-15
R178_181	178	181	2.8109607947946595e+04
C178_181	178	181	2.5199036097255280e-15
R178_182	178	182	1.4026663045454088e+04
C178_182	178	182	5.0499183096122419e-15
R178_249	178	249	4.1000591290175849e+04
C178_249	178	249	1.7276214880582082e-15
R178_252	178	252	3.7389374031855121e+04
C178_252	178	252	1.8944821722784413e-15
R178_258	178	258	6.9508695899458355e+04
C178_258	178	258	1.0190595812422943e-15
R179_181	179	181	2.4939179173614186e+04
C179_181	179	181	2.8402499554172297e-15
R179_190	179	190	4.4690052277005074e+04
C179_190	179	190	1.5849948462120470e-15
R179_195	179	195	4.4058608009855343e+04
C179_195	179	195	1.6077108591391598e-15
R179_249	179	249	8.8137770930354789e+04
C179_249	179	249	8.0366795969881771e-16
R179_250	179	250	3.0615167490925309e+04
C179_250	179	250	2.3136735265941587e-15
R179_257	179	257	8.3143287940419468e+04
C179_257	179	257	8.5194492893713013e-16
R179_258	179	258	4.3759622576260648e+04
C179_258	179	258	1.6186954632105713e-15
R179_259	179	259	6.8803260278571761e+04
C179_259	179	259	1.0295079368217167e-15
R180_181	180	181	5.1088637490990506e+04
C180_181	180	181	1.3864825138171184e-15
R180_182	180	182	3.6420930463694109e+04
C180_182	180	182	1.9448570268299372e-15
R180_183	180	183	4.5780998631532253e+04
C180_183	180	183	1.5472249329050787e-15
R180_184	180	184	2.0342334542603767e+04
C180_184	180	184	3.4820734261178612e-15
R180_185	180	185	3.1668524676306271e+04
C180_185	180	185	2.2367162114437287e-15
R180_197	180	197	1.5506496683208881e+04
C180_197	180	197	4.5679887587182514e-15
R180_199	180	199	3.3807109259213677e+04
C180_199	180	199	2.0952250602939462e-15
R180_262	180	262	4.1508129809485908e+04
C180_262	180	262	1.7064970852965850e-15
R181_182	181	182	2.0556991517582584e+04
C181_182	181	182	3.4457134681120751e-15
R181_190	181	190	2.5595856604444412e+04
C181_190	181	190	2.7673815973676233e-15
R181_197	181	197	6.3195189738306915e+04
C181_197	181	197	1.1208685792276845e-15
R181_258	181	258	3.4981759755007181e+04
C181_258	181	258	2.0248696186835231e-15
R181_259	181	259	3.3332655286169283e+04
C181_259	181	259	2.1250483025692509e-15
R181_261	181	261	6.0660076407047192e+04
C181_261	181	261	1.1677120559605975e-15
R181_262	181	262	2.0106230335519256e+04
C181_262	181	262	3.5229628505183781e-15
R182_184	182	184	1.1025869591692870e+04
C182_184	182	184	6.4243007725547100e-15
R182_252	182	252	1.7647749538498563e+04
C182_252	182	252	4.0137413771357488e-15
R182_249	182	249	7.3668325805957793e+04
C182_249	182	249	9.6151910283091399e-16
R182_258	182	258	2.3369981072275274e+04
C182_258	182	258	3.0309610571329289e-15
R182_261	182	261	1.5961120174827198e+04
C182_261	182	261	4.4378779033136921e-15
R182_262	182	262	2.7661407137236147e+04
C182_262	182	262	2.5607338840202436e-15
R183_184	183	184	1.3179289808022719e+04
C183_184	183	184	5.3746069452756893e-15
R183_185	183	185	1.9277470472287445e+04
C183_185	183	185	3.6744189357119001e-15
R183_245	183	245	5.4815329864465115e+04
C183_245	183	245	1.2922206746021776e-15
R183_244	183	244	1.7262528490954934e+04
C183_244	183	244	4.1033098119498954e-15
R183_252	183	252	2.5524724571240145e+04
C183_252	183	252	2.7750937072132526e-15
R183_253	183	253	2.6847868537678612e+04
C183_253	183	253	2.6383287163594174e-15
R183_260	183	260	2.7842051571334556e+04
C183_260	183	260	2.5441193639957305e-15
R183_263	183	263	5.0684706219408261e+04
C183_263	183	263	1.3975320726802660e-15
R184_185	184	185	6.6518325682057039e+04
C184_185	184	185	1.0648720004554620e-15
R184_199	184	199	5.4229647214568220e+04
C184_199	184	199	1.3061767165059361e-15
R184_252	184	252	5.2227258855173248e+04
C184_252	184	252	1.3562554131439690e-15
R184_260	184	260	6.6734286681951853e+04
C184_260	184	260	1.0614259334723179e-15
R184_261	184	261	1.9004935325883878e+04
C184_261	184	261	3.7271109488874676e-15
R184_262	184	262	2.1718798183417206e+04
C184_262	184	262	3.2613914424640209e-15
R184_263	184	263	2.8701200281327692e+04
C184_263	184	263	2.4679630761673258e-15
R185_199	185	199	6.0980450074794579e+04
C185_199	185	199	1.1615772341647254e-15
R185_253	185	253	1.2764256623461586e+05
C185_253	185	253	5.5493637134968871e-16
R185_263	185	263	9.4351103350759178e+04
C185_263	185	263	7.5074376473023063e-16
R186_194	186	194	2.4706151632310488e+04
C186_194	186	194	2.8670390917282549e-15
R186_193	186	193	6.4104412701722787e+04
C186_193	186	193	1.1049707742521192e-15
R186_242	186	242	1.3933849369810128e+04
C186_242	186	242	5.0835559260079205e-15
R186_250	186	250	3.5194483471315085e+04
C186_250	186	250	2.0126308315828005e-15
R186_251	186	251	2.1200036123459173e+04
C186_251	186	251	3.3411972566225149e-15
R186_256	186	256	1.9233600613920735e+04
C186_256	186	256	3.6827999061565583e-15
R186_257	186	257	1.3933849369810139e+04
C186_257	186	257	5.0835559260079158e-15
R186_264	186	264	2.6537483773657601e+04
C186_264	186	264	2.6691868430387049e-15
R187_189	187	189	3.2317981317751852e+04
C187_189	187	189	2.1917675438809686e-15
R187_188	187	188	7.1101702350891996e+04
C187_188	187	188	9.9622794101935265e-16
R187_193	187	193	2.0019762291770621e+04
C187_193	187	193	3.5381790005127600e-15
R187_242	187	242	2.2057569598327609e+04
C187_242	187	242	3.2113013276571755e-15
R187_254	187	254	4.6581691044519241e+04
C187_254	187	254	1.5206296926468966e-15
R187_255	187	255	6.3481713294726622e+04
C187_255	187	255	1.1158095593157864e-15
R187_264	187	264	7.3590008568978417e+04
C187_264	187	264	9.6254238738952400e-16
R187_265	187	265	2.9453714021745345e+04
C187_265	187	265	2.4049090204279307e-15
R188_189	188	189	5.5912324520661787e+04
C188_189	188	189	1.2668674240117536e-15
R188_191	188	191	5.4248251041811491e+04
C188_191	188	191	1.3057287778993197e-15
R188_193	188	193	4.5494715354736931e+04
C188_193	188	193	1.5569611103990518e-15
R188_203	188	203	3.7314141121109358e+04
C188_203	188	203	1.8983018343125702e-15
R188_265	188	265	6.7908591026894122e+04
C188_265	188	265	1.0430713031278695e-15
R189_254	189	254	1.3032316436547505e+05
C189_254	189	254	5.4352196618980404e-16
R189_265	189	265	2.0547954996315567e+05
C189_265	189	265	3.4472288141910514e-16
R190_192	190	192	3.2670632249897637e+04
C190_192	190	192	2.1681093281022111e-15
R190_195	190	195	1.4907180243108342e+04
C190_195	190	195	4.7516365523752656e-15
R190_196	190	196	2.4396263201831815e+04
C190_196	190	196	2.9034570561069121e-15
R190_197	190	197	2.8479812857400702e+04
C190_197	190	197	2.4871477523628934e-15
R190_200	190	200	2.6749236015511433e+04
C190_200	190	200	2.6480570321681274e-15
R190_201	190	201	4.8712149518953251e+04
C190_201	190	201	1.4541239349012842e-15
R190_259	190	259	2.8182810841544462e+04
C190_259	190	259	2.5133583351304293e-15
R190_262	190	262	4.6951670140633658e+04
C190_262	190	262	1.5086471327608462e-15
R190_266	190	266	4.2188642898418831e+04
C190_266	190	266	1.6789708715341191e-15
R191_192	191	192	2.1586425022307114e+04
C191_192	191	192	3.2813910808668714e-15
R191_201	191	201	2.7045133245159261e+04
C191_201	191	201	2.6190849900389502e-15
R191_202	191	202	3.1889066638685577e+04
C191_202	191	202	2.2212472800966142e-15
R191_203	191	203	1.0225326426287624e+04
C191_203	191	203	6.9272607624436129e-15
R191_204	191	204	1.9025507889438726e+04
C191_204	191	204	3.7230807685991128e-15
R191_267	191	267	1.9686737462336732e+04
C191_267	191	267	3.5980315515211016e-15
R192_193	192	193	3.1467013465130451e+04
C192_193	192	193	2.2510398902168693e-15
R192_194	192	194	4.2208139043738469e+04
C192_194	192	194	1.6781953466983773e-15
R192_195	192	195	2.3659896832653303e+04
C192_195	192	195	2.9938212764411487e-15
R192_201	192	201	6.0862746128251740e+04
C192_201	192	201	1.1638236366584181e-15
R192_203	192	203	6.4672583198307802e+04
C192_203	192	203	1.0952632326251875e-15
R192_266	192	266	3.1510229625130840e+04
C192_266	192	266	2.2479525975750764e-15
R192_267	192	267	3.1334536643696676e+04
C192_267	192	267	2.2605568846108663e-15
R192_268	192	268	7.4914759000049293e+04
C192_268	192	268	9.4552132959479172e-16
R193_194	193	194	1.4801929975073601e+04
C193_194	193	194	4.7854234316256985e-15
R193_203	193	203	3.2757002088308789e+04
C193_203	193	203	2.1623927105735046e-15
R193_242	193	242	4.4005969348628510e+04
C193_242	193	242	1.6096339561307179e-15
R193_264	193	264	2.5263596856365930e+04
C193_264	193	264	2.8037774248345534e-15
R193_265	193	265	2.0663949775106787e+04
C193_265	193	265	3.4278781794819743e-15
R193_268	193	268	4.0685574625934103e+04
C193_268	193	268	1.7409979627238391e-15
R194_195	194	195	1.5940877703108099e+04
C194_195	194	195	4.4435133281393364e-15
R194_257	194	257	2.0271659040263530e+04
C194_257	194	257	3.4942133939462300e-15
R194_264	194	264	2.0789517696437335e+04
C194_264	194	264	3.4071739215065403e-15
R194_266	194	266	4.8732370052832681e+04
C194_266	194	266	1.4535205749116372e-15
R194_268	194	268	5.5899602773670274e+04
C194_268	194	268	1.2671557403152762e-15
R194_269	194	269	2.0742026595262723e+04
C194_269	194	269	3.4149750127201985e-15
R195_257	195	257	2.6178752962870713e+04
C195_257	195	257	2.7057630528262005e-15
R195_259	195	259	1.0231157848402778e+04
C195_259	195	259	6.9233124525645044e-15
R195_266	195	266	1.6910969224917622e+04
C195_266	195	266	4.1886128224767703e-15
R195_269	195	269	2.6935602904551157e+04
C195_269	195	269	2.6297351793834051e-15
R196_197	196	197	1.3060770777003318e+04
C196_197	196	197	5.4233784319007955e-15
R196_198	196	198	2.4508627073489464e+04
C196_198	196	198	2.8901456749741528e-15
R196_200	196	200	1.0802126163187744e+04
C196_200	196	200	6.5573667133597697e-15
R196_201	196	201	1.8456329509520099e+04
C196_201	196	201	3.8378975895214067e-15
R196_205	196	205	6.2122505963648537e+03
C196_205	196	205	1.1402228779606665e-14
R196_206	196	206	2.2401003759297117e+04
C196_206	196	206	3.1620682402056151e-15
R196_270	196	270	2.6160486356724690e+04
C196_270	196	270	2.7076523566922093e-15
R197_198	197	198	1.3731536359979271e+04
C197_198	197	198	5.1584542821038661e-15
R197_199	197	199	2.1355699214430238e+04
C197_199	197	199	3.3168430508768906e-15
R197_200	197	200	3.2267439740236307e+04
C197_200	197	200	2.1952005831957364e-15
R197_262	197	262	1.1157060396949992e+04
C197_262	197	262	6.3487603379259082e-15
R197_270	197	270	3.2432110451837143e+04
C197_270	197	270	2.1840546775761117e-15
R198_199	198	199	3.2504358791633869e+04
C198_199	198	199	2.1792001186693608e-15
R198_206	198	206	4.4518759929464897e+04
C198_206	198	206	1.5910933424072893e-15
R198_270	198	270	4.2875793472356767e+04
C198_270	198	270	1.6520627794717864e-15
R199_262	199	262	2.2747630374096334e+04
C199_262	199	262	3.1138848913538288e-15
R199_263	199	263	2.9429736283475610e+04
C199_263	199	263	2.4068684086636565e-15
R199_270	199	270	3.5764877725351449e+04
C199_270	199	270	1.9805324955938728e-15
R200_201	200	201	2.3690562661111671e+04
C200_201	200	201	2.9899459776138625e-15
R200_205	200	205	2.4666975556213059e+04
C200_205	200	205	2.8715925215306191e-15
R200_262	200	262	1.3198741236388669e+04
C200_262	200	262	5.3666862064628884e-15
R200_259	200	259	2.3431147526306991e+04
C200_259	200	259	3.0230488052910206e-15
R200_266	200	266	1.1506993949841702e+04
C200_266	200	266	6.1556912991141733e-15
R200_270	200	270	1.1307232570099732e+04
C200_270	200	270	6.2644419929336650e-15
R200_271	200	271	1.0436761458554740e+04
C200_271	200	271	6.7869235890161733e-15
R200_272	200	272	9.3785510417215537e+03
C200_272	200	272	7.5527128040236804e-15
R201_202	201	202	8.2515969310378041e+03
C201_202	201	202	8.5842174706285937e-15
R201_205	201	205	1.1494696213537807e+04
C201_205	201	205	6.1622770380461463e-15
R201_207	201	207	1.0260708055725760e+04
C201_207	201	207	6.9033737390542908e-15
R201_266	201	266	2.3874723065169412e+04
C201_266	201	266	2.9668826877132777e-15
R201_267	201	267	9.7264261528734714e+03
C201_267	201	267	7.2825826693881504e-15
R201_272	201	272	1.5468795849710799e+04
C201_272	201	272	4.5791219448619389e-15
R201_273	201	273	3.0006341675262767e+04
C201_273	201	273	2.3606177421619898e-15
R202_204	202	204	9.3869701530637449e+03
C202_204	202	204	7.5459388259460035e-15
R202_207	202	207	1.5590568633776844e+04
C202_207	202	207	4.5433559352376527e-15
R202_209	202	209	1.6938644342416406e+04
C202_209	202	209	4.1817692788214689e-15
R202_267	202	267	3.8731437990469720e+04
C202_267	202	267	1.8288374047312505e-15
R202_273	202	273	3.4512309162100428e+04
C202_273	202	273	2.0524127262335020e-15
R203_204	203	204	3.1207165075183275e+04
C203_204	203	204	2.2697833130741059e-15
R203_265	203	265	5.1548307509319449e+04
C203_265	203	265	1.3741188791347609e-15
R203_267	203	267	1.1343876217338109e+04
C203_267	203	267	6.2442062288847333e-15
R203_268	203	268	1.5251859759057761e+04
C203_268	203	268	4.6442534651509287e-15
R203_273	203	273	5.5212563048488788e+04
C203_273	203	273	1.2829236431895509e-15
R204_209	204	209	5.9646669296200300e+04
C204_209	204	209	1.1875516834686417e-15
R204_267	204	267	5.8436520462513319e+04
C204_267	204	267	1.2121444257010354e-15
R204_273	204	273	6.7822476586414501e+04
C204_273	204	273	1.0443956944826259e-15
R205_206	205	206	9.4702943577448095e+03
C205_206	205	206	7.4795460267897950e-15
R205_207	205	207	5.6918173638584121e+03
C205_207	205	207	1.2444795397999710e-14
R205_208	205	208	3.0090147097658075e+04
C205_208	205	208	2.3540430794874046e-15
R205_270	205	270	4.4833351965934773e+04
C205_270	205	270	1.5799287679810476e-15
R205_272	205	272	2.2934552174942666e+04
C205_272	205	272	3.0885060233872686e-15
R205_274	205	274	2.3529031766222965e+04
C205_274	205	274	3.0104724767163958e-15
R206_208	206	208	1.0005127069492266e+05
C206_208	206	208	7.0797204317360672e-16
R206_270	206	270	9.3123720903769441e+04
C206_270	206	270	7.6063866272264486e-16
R206_274	206	274	1.1607783094277314e+05
C206_274	206	274	6.1022420871149138e-16
R207_208	207	208	9.1511260975358255e+03
C207_208	207	208	7.7404137787013709e-15
R207_209	207	209	1.9340460356926709e+04
C207_209	207	209	3.6624517322118065e-15
R207_272	207	272	2.7235690827014991e+04
C207_272	207	272	2.6007602665888870e-15
R207_273	207	273	2.2711338837753476e+04
C207_273	207	273	3.1188607171961243e-15
R207_274	207	274	1.7643816928325843e+04
C207_274	207	274	4.0146359953600543e-15
R207_275	207	275	3.0731612615282647e+04
C207_275	207	275	2.3049067884180909e-15
R208_209	208	209	3.8772834675744249e+04
C208_209	208	209	1.8268848055185523e-15
R208_210	208	210	4.9193325252209121e+04
C208_210	208	210	1.4399006810953301e-15
R208_274	208	274	3.5925153034165065e+04
C208_274	208	274	1.9716966123606172e-15
R208_275	208	275	2.5455774099163693e+04
C208_275	208	275	2.7826104309405829e-15
R209_210	209	210	5.9750616864604985e+04
C209_210	209	210	1.1854857113276145e-15
R209_273	209	273	4.5246480973315425e+04
C209_273	209	273	1.5655030184065540e-15
R209_275	209	275	4.0286874334265762e+04
C209_275	209	275	1.7582278026407472e-15
R210_275	210	275	2.0328195395292962e+05
C210_275	210	275	3.4844953601932446e-16
R211_212	211	212	4.2743777194018570e+04
C211_212	211	212	1.6571652574006076e-15
R211_213	211	213	7.0378738906692670e+04
C211_213	211	213	1.0064616620924432e-15
R211_218	211	218	3.8697486214830722e+04
C211_218	211	218	1.8304419605646953e-15
R211_221	211	221	1.8260324704449820e+04
C211_221	211	221	3.8790932627139283e-15
R211_276	211	276	6.6576709477252080e+04
C211_276	211	276	1.0639381713540888e-15
R212_221	212	221	2.0372090500458486e+04
C212_221	212	221	3.4769874272061507e-15
R212_222	212	222	2.1582452284740768e+04
C212_222	212	222	3.2819950949726283e-15
R212_237	212	237	1.9051660131606848e+04
C212_237	212	237	3.7179700900965944e-15
R212_238	212	238	5.6981290135810617e+04
C212_238	212	238	1.2431010664583703e-15
R212_276	212	276	7.0582669271969644e+04
C212_276	212	276	1.0035537514607708e-15
R212_278	212	278	4.6997869440557850e+04
C212_278	212	278	1.5071641199733334e-15
R212_281	212	281	7.4950906248097686e+04
C212_281	212	281	9.4506532451430923e-16
R213_214	213	214	3.9836868785719242e+04
C213_214	213	214	1.7780891092874364e-15
R213_215	213	215	4.4909799662162462e+04
C213_215	213	215	1.5772393345962496e-15
R213_217	213	217	4.4873296937557192e+04
C213_217	213	217	1.5785223589558704e-15
R213_218	213	218	1.2080637822560808e+04
C213_218	213	218	5.8633909547157488e-15
R213_219	213	219	6.1320793933741130e+04
C213_219	213	219	1.1551302256871892e-15
R213_276	213	276	4.5485592264827261e+04
C213_276	213	276	1.5572733916179779e-15
R213_216	213	216	2.4825875898075679e+04
C213_216	213	216	2.8532126248762285e-15
R213_277	213	277	9.2355551665460924e+04
C213_277	213	277	7.6696529075566423e-16
R213_287	213	287	4.9424760658369109e+04
C213_287	213	287	1.4331582306611685e-15
R214_215	214	215	4.9445439006694680e+04
C214_215	214	215	1.4325588761869319e-15
R214_217	214	217	4.3520239064094043e+04
C214_217	214	217	1.6275991138670127e-15
R214_219	214	219	1.2552517461972768e+04
C214_219	214	219	5.6429718381660585e-15
R214_232	214	232	3.7110828386392459e+04
C214_232	214	232	1.9087017352049399e-15
R214_236	214	236	4.2948604144599136e+04
C214_236	214	236	1.6492620411484889e-15
R214_279	214	279	7.3007135169502959e+04
C214_279	214	279	9.7022712056217040e-16
R214_287	214	287	3.0604697055151639e+04
C214_287	214	287	2.3144650773165137e-15
R215_277	215	277	2.8987815422153843e+04
C215_277	215	277	2.4435612516652680e-15
R215_216	215	216	9.3688117716028020e+04
C215_216	215	216	7.5605641636113182e-16
R215_227	215	227	1.5280172014113097e+05
C215_227	215	227	4.6356482420863239e-16
R215_279	215	279	4.6977476898423884e+04
C215_279	215	279	1.5078183677075367e-15
R215_287	215	287	5.8018965942244482e+04
C215_287	215	287	1.2208680624627449e-15
R216_218	216	218	9.1473394553813541e+03
C216_218	216	218	7.7436180084394775e-15
R216_276	216	276	1.4487438147887893e+04
C216_276	216	276	4.8893049145701961e-15
R216_277	216	277	2.3868274915062600e+04
C216_277	216	277	2.9676842079315485e-15
R216_278	216	278	3.3016349601054077e+04
C216_278	216	278	2.1454068481798057e-15
R216_280	216	280	6.5569237663109059e+04
C216_280	216	280	1.0802855891041231e-15
R216_287	216	287	1.0348170105634146e+04
C216_287	216	287	6.8450268803983145e-15
R216_288	216	288	1.2918979206206715e+04
C216_288	216	288	5.4829024341156297e-15
R216_289	216	289	4.9412545331324734e+04
C216_289	216	289	1.4335125232072515e-15
R217_218	217	218	1.9416381573308976e+04
C217_218	217	218	3.6481309490421416e-15
R217_219	217	219	1.4884638871898738e+04
C217_219	217	219	4.7588324544258319e-15
R217_221	217	221	5.8934589163963647e+04
C217_221	217	221	1.2019003363022019e-15
R217_223	217	223	3.4956112831142855e+04
C217_223	217	223	2.0263552437356115e-15
R217_228	217	228	4.0197287284675396e+04
C217_228	217	228	1.7621463367505454e-15
R217_229	217	229	2.0762609064859578e+04
C217_229	217	229	3.4115896665359232e-15
R217_232	217	232	5.1777781632740895e+04
C217_232	217	232	1.3680289170830279e-15
R217_289	217	289	4.3678549810311764e+04
C217_289	217	289	1.6216999612765857e-15
R217_290	217	290	2.2012165782036758e+04
C217_290	217	290	3.2179251799840783e-15
R218_219	218	219	3.4920398261890477e+04
C218_219	218	219	2.0284276830056209e-15
R218_221	218	221	1.3094785865125616e+04
C218_221	218	221	5.4092906341176369e-15
R218_276	218	276	1.7824963711818353e+04
C218_276	218	276	3.9738371242257177e-15
R218_278	218	278	3.4883801646891727e+04
C218_278	218	278	2.0305557075747087e-15
R218_287	218	287	2.3231083792467834e+04
C218_287	218	287	3.0490829945250431e-15
R218_289	218	289	2.2452436330097644e+04
C218_289	218	289	3.1548247813555634e-15
R218_290	218	290	3.6318134248044378e+04
C218_290	218	290	1.9503618234412519e-15
R219_229	219	229	2.3234484331211974e+04
C219_229	219	229	3.0486367386620260e-15
R219_232	219	232	2.5372180200745748e+04
C219_232	219	232	2.7917783168636824e-15
R219_233	219	233	1.3426922716020557e+04
C219_233	219	233	5.2754830003961988e-15
R219_236	219	236	2.8589256620259261e+04
C219_236	219	236	2.4776265950827529e-15
R219_287	219	287	7.3954700344347903e+03
C219_287	219	287	9.5779581563017683e-15
R219_290	219	290	1.1816028289318021e+04
C219_290	219	290	5.9946964243505774e-15
R220_222	220	222	1.1756529931647230e+04
C220_222	220	222	6.0250348485333545e-15
R220_224	220	224	1.8865651383657161e+04
C220_224	220	224	3.7546279794696776e-15
R220_237	220	237	2.8525958191832204e+04
C220_237	220	237	2.4831243900610381e-15
R220_239	220	239	3.1482314683885921e+04
C220_239	220	239	2.2499458266407528e-15
R220_240	220	240	9.8461701917406299e+03
C220_240	220	240	7.1940156585367641e-15
R220_241	220	241	1.4749560802898981e+04
C220_241	220	241	4.8024143554212074e-15
R220_243	220	243	1.1911968794353708e+04
C220_243	220	243	5.9464143802639240e-15
R220_291	220	291	2.0334083227360505e+04
C220_291	220	291	3.4834864077220884e-15
R221_222	221	222	1.2821815783215638e+04
C221_222	221	222	5.5244517417513049e-15
R221_223	221	223	1.0495922320746342e+04
C221_223	221	223	6.7486687087984476e-15
R221_237	221	237	2.8484840598041057e+04
C221_237	221	237	2.4867087562663536e-15
R221_276	221	276	2.9117696212309747e+04
C221_276	221	276	2.4326616370856481e-15
R221_278	221	278	1.2352433866731522e+04
C221_278	221	278	5.7343761804524999e-15
R221_289	221	289	1.4185570652083101e+04
C221_289	221	289	4.9933488241869463e-15
R221_291	221	291	2.3046712409460797e+04
C221_291	221	291	3.0734753520386056e-15
R222_223	222	223	2.6256430784070664e+04
C222_223	222	223	2.6977582413438121e-15
R222_224	222	224	1.8734661264252001e+04
C222_224	222	224	3.7808798107900087e-15
R222_237	222	237	2.4497058314550810e+04
C222_237	222	237	2.8915105490003344e-15
R222_291	222	291	2.1753896026007340e+04
C222_291	222	291	3.2561294975077912e-15
R223_224	223	224	2.6593537955355296e+04
C223_224	223	224	2.6635606986522025e-15
R223_226	223	226	2.1500574500882907e+04
C223_226	223	226	3.2944934812365724e-15
R223_228	223	228	2.7042873700547334e+04
C223_228	223	228	2.6193038254868000e-15
R223_289	223	289	2.0305773496636248e+04
C223_289	223	289	3.4883429851974823e-15
R223_291	223	291	3.6699059503753720e+04
C223_291	223	291	1.9301176513462120e-15
R223_292	223	292	2.0875014899103564e+04
C223_292	223	292	3.3932192565305342e-15
R224_226	224	226	3.1857273355823676e+04
C224_226	224	226	2.2234640656417412e-15
R224_242	224	242	2.2282400427487915e+04
C224_242	224	242	3.1788990942205090e-15
R224_243	224	243	2.8052560177493473e+04
C224_243	224	243	2.5250280932586549e-15
R224_251	224	251	3.3536784553525460e+04
C224_251	224	251	2.1121137127188849e-15
R224_291	224	291	2.7211166529390804e+04
C224_291	224	291	2.6031042241240442e-15
R224_292	224	292	3.5975864887413925e+04
C224_292	224	292	1.9689172937932887e-15
R224_293	224	293	2.2170284425102305e+04
C224_293	224	293	3.1949749122658423e-15
R225_226	225	226	8.9304078132493742e+03
C225_226	225	226	7.9317209266647025e-15
R225_228	225	228	1.6913833736362718e+04
C225_228	225	228	4.1879034428319146e-15
R225_229	225	229	2.4472523596752962e+04
C225_229	225	229	2.8944094080022979e-15
R225_230	225	230	1.1026448869902792e+04
C225_230	225	230	6.4239632697471075e-15
R225_249	225	249	1.6613331639180793e+04
C225_249	225	249	4.2636542792504455e-15
R225_250	225	250	1.8102774358863007e+04
C225_250	225	250	3.9128534185877637e-15
R225_299	225	299	2.8578304468545073e+04
C225_299	225	299	2.4785761035600784e-15
R226_228	226	228	3.4455546349023200e+04
C226_228	226	228	2.0557939153969650e-15
R226_250	226	250	2.1241653740450725e+04
C226_250	226	250	3.3346510305415140e-15
R226_251	226	251	1.8623422084298905e+04
C226_251	226	251	3.8034633063339384e-15
R226_292	226	292	2.3922108435309103e+04
C226_292	226	292	2.9610058297139704e-15
R226_299	226	299	3.8730601704129309e+04
C226_299	226	299	1.8288768937056824e-15
R227_277	227	277	5.6305909741091134e+04
C227_277	227	277	1.2580118652146891e-15
R227_279	227	279	5.2972889174058808e+04
C227_279	227	279	1.3371651733635789e-15
R227_280	227	280	4.2342476612101644e+04
C227_280	227	280	1.6728710317278777e-15
R227_282	227	282	3.9409535792770614e+04
C227_282	227	282	1.7973696241556308e-15
R227_304	227	304	5.0343554069190082e+04
C227_304	227	304	1.4070024225673340e-15
R227_283	227	283	1.6911295136644875e+05
C227_283	227	283	4.1885321002122283e-16
R228_229	228	229	1.0706270761149653e+04
C228_229	228	229	6.6160761404462940e-15
R228_230	228	230	2.0747376180998352e+04
C228_230	228	230	3.4140944820229094e-15
R228_289	228	289	2.0747376180998352e+04
C228_289	228	289	3.4140944820229094e-15
R228_290	228	290	1.1177297396793636e+04
C228_290	228	290	6.3372656216805669e-15
R228_233	228	233	3.4118342032677851e+04
C228_233	228	233	2.0761120944317028e-15
R228_292	228	292	1.2304842969864263e+04
C228_292	228	292	5.7565547735536345e-15
R228_296	228	296	2.0327852365469313e+04
C228_296	228	296	3.4845541605921957e-15
R228_297	228	297	2.2503728947021616e+04
C228_297	228	297	3.1476340078018433e-15
R228_299	228	299	2.2320654667737956e+04
C228_299	228	299	3.1734509399664704e-15
R228_301	228	301	7.0285251535638336e+03
C228_301	228	301	1.0078003704672478e-14
R228_308	228	308	3.5155405815522354e+04
C228_308	228	308	2.0148680094235895e-15
R229_230	229	230	4.3760899203512956e+04
C229_230	229	230	1.6186482413577498e-15
R229_232	229	232	2.5114372353204773e+04
C229_232	229	232	2.8204369012216674e-15
R229_233	229	233	1.8556112174713340e+04
C229_233	229	233	3.8172598801448144e-15
R229_234	229	234	3.5707623650956761e+04
C229_234	229	234	1.9837081075010728e-15
R229_290	229	290	4.1431146042779066e+04
C229_290	229	290	1.7096679503594230e-15
R229_308	229	308	7.5616547799861131e+04
C229_308	229	308	9.3674605092365890e-16
R230_234	230	234	2.5454198346699370e+04
C230_234	230	234	2.7827826895670023e-15
R230_231	230	231	3.3227066085555300e+04
C230_231	230	231	2.1318012957753511e-15
R230_249	230	249	3.0990059599043354e+04
C230_249	230	249	2.2856846179859104e-15
R230_247	230	247	8.9883012822300938e+04
C230_247	230	247	7.8806328706446598e-16
R230_299	230	299	6.9303610756966518e+04
C230_299	230	299	1.0220752102570601e-15
R230_300	230	300	3.2244910246414587e+04
C230_300	230	300	2.1967343681434566e-15
R230_301	230	301	6.5225048343496826e+04
C230_301	230	301	1.0859862021560673e-15
R230_308	230	308	4.4000806526484521e+04
C230_308	230	308	1.6098228220740594e-15
R230_309	230	309	6.6710110061466650e+04
C230_309	230	309	1.0618106081781919e-15
R231_234	231	234	2.6248719878463791e+04
C231_234	231	234	2.6985507431970642e-15
R231_235	231	235	1.7296143784259319e+04
C231_235	231	235	4.0953349729009178e-15
R231_246	231	246	3.3579675359911096e+04
C231_246	231	246	2.1094159421375521e-15
R231_247	231	247	2.2440809365619909e+04
C231_247	231	247	3.1564593496578325e-15
R231_249	231	249	3.6463200022293888e+04
C231_249	231	249	1.9426024729780118e-15
R231_252	231	252	3.9560748090472734e+04
C231_252	231	252	1.7904995723035522e-15
R231_309	231	309	5.1053792401422681e+04
C231_309	231	309	1.3874288119294768e-15
R232_233	232	233	3.4753077478914893e+04
C232_233	232	233	2.0381936701569962e-15
R232_234	232	234	4.0117349715630015e+04
C232_234	232	234	1.7656575780329466e-15
R232_235	232	235	6.4426727628556975e+04
C232_235	232	235	1.0994428111323671e-15
R232_236	232	236	7.1850947547672331e+04
C232_236	232	236	9.8583950460782367e-16
R232_310	232	310	6.5618911808485835e+04
C232_310	232	310	1.0794678025556624e-15
R233_234	233	234	3.3702113409884922e+04
C233_234	233	234	2.1017525421780925e-15
R233_236	233	236	2.0009063080419615e+04
C233_236	233	236	3.5400709294237740e-15
R233_287	233	287	2.9255399369210758e+04
C233_287	233	287	2.4212112657244140e-15
R233_290	233	290	1.4900941919142781e+04
C233_290	233	290	4.7536258392499596e-15
R233_295	233	295	1.2899945680476472e+04
C233_295	233	295	5.4909923103942625e-15
R233_297	233	297	7.9385885577062554e+03
C233_297	233	297	8.9226821646071493e-15
R233_308	233	308	1.7969961725519093e+04
C233_308	233	308	3.9417725879409938e-15
R233_310	233	310	3.1422709952310339e+04
C233_310	233	310	2.2542136767803507e-15
R234_235	234	235	1.5967980696463315e+04
C234_235	234	235	4.4359712027763557e-15
R234_246	234	246	2.7778089289825046e+04
C234_246	234	246	2.5499774947424449e-15
R234_308	234	308	8.3648158730298728e+03
C234_308	234	308	8.4680288976095502e-15
R234_309	234	309	1.2382845735862320e+04
C234_309	234	309	5.7202927377878116e-15
R234_310	234	310	8.0269923317456751e+03
C234_310	234	310	8.8244138786408252e-15
R235_246	235	246	7.2046147725305214e+04
C235_246	235	246	9.8316849370033335e-16
R235_310	235	310	1.0774345367286494e+05
C235_310	235	310	6.5742743639040539e-16
R236_279	236	279	4.4262772261921287e+04
C236_279	236	279	1.6002952123479436e-15
R236_287	236	287	3.2894868013331688e+04
C236_287	236	287	2.1533298904647521e-15
R236_295	236	295	9.5874928915822493e+03
C236_295	236	295	7.3881152598497716e-15
R236_305	236	305	6.7867263615722331e+04
C236_305	236	305	1.0437064758802285e-15
R236_310	236	310	4.6560155117806971e+04
C236_310	236	310	1.5213330444620807e-15
R236_313	236	313	6.3032129195511479e+04
C236_313	236	313	1.1237682026620175e-15
R237_238	237	238	9.6280949749917618e+03
C237_238	237	238	7.3569592655644352e-15
R237_240	237	240	1.3451530325762151e+04
C237_240	237	240	5.2658322748855459e-15
R237_278	237	278	1.1112371186598059e+04
C237_278	237	278	6.3742923401827973e-15
R237_281	237	281	2.8806151445895812e+04
C237_281	237	281	2.4589713995304325e-15
R237_291	237	291	8.6969426422634369e+03
C237_291	237	291	8.1446440950155703e-15
R237_302	237	302	2.5966509468267672e+04
C237_302	237	302	2.7278792562613000e-15
R237_303	237	303	1.3768643750605674e+04
C237_303	237	303	5.1445519122305784e-15
R237_316	237	316	2.4609439926366060e+04
C237_316	237	316	2.8783061600727621e-15
R238_239	238	239	3.7067195006731155e+04
C238_239	238	239	1.9109485496039594e-15
R238_240	238	240	3.6510957977307226e+04
C238_240	238	240	1.9400614626443217e-15
R238_281	238	281	5.1572369716185924e+04
C238_281	238	281	1.3734777541891587e-15
R238_302	238	302	5.5485219318438292e+04
C238_302	238	302	1.2766193124240088e-15
R238_316	238	316	1.4788778810981339e+04
C238_316	238	316	4.7896789478927714e-15
R238_317	238	317	7.4097833182544928e+04
C238_317	238	317	9.5594566660939978e-16
R238_318	238	318	5.2166574941285915e+04
C238_318	238	318	1.3578331070369087e-15
R239_240	239	240	1.9108885480862293e+04
C239_240	239	240	3.7068358909231180e-15
R239_241	239	241	3.2582890129120467e+04
C239_241	239	241	2.1739478068182058e-15
R239_316	239	316	3.7053693710443309e+04
C239_316	239	316	1.9116448440884077e-15
R239_317	239	317	4.8874335193680708e+04
C239_317	239	317	1.4492985378788039e-15
R239_322	239	322	3.2582890129120457e+04
C239_322	239	322	2.1739478068182066e-15
R240_241	240	241	1.5492768063592781e+04
C240_241	240	241	4.5720365944453241e-15
R240_243	240	243	1.1102413443845502e+04
C240_243	240	243	6.3800094361704544e-15
R240_291	240	291	1.3139406722351618e+04
C240_291	240	291	5.3909209169622705e-15
R240_303	240	303	1.8393555583918642e+04
C240_303	240	303	3.8509956496898976e-15
R240_316	240	316	1.0003822240241419e+04
C240_316	240	316	7.0806438614097772e-15
R240_320	240	320	3.4933560980368115e+03
C240_320	240	320	2.0276633858141993e-14
R240_322	240	322	7.1271278272200152e+03
C240_322	240	322	9.9385761351819474e-15
R240_325	240	325	2.3224240229553976e+04
C240_325	240	325	3.0499814777949524e-15
R241_243	241	243	1.7373346227779184e+04
C241_243	241	243	4.0771364138671505e-15
R241_254	241	254	3.4550845671006136e+04
C241_254	241	254	2.0501235544414191e-15
R241_322	241	322	5.2178382191327044e+04
C241_322	241	322	1.3575258480852973e-15
R241_325	241	325	3.3589263443294338e+04
C241_325	241	325	2.1088138075900861e-15
R242_243	242	243	6.4897963443345383e+04
C242_243	242	243	1.0914595586321632e-15
R242_250	242	250	1.0381833877476561e+05
C242_250	242	250	6.8228314353665064e-16
R242_251	242	251	3.2583712256179449e+04
C242_251	242	251	2.1738929554463688e-15
R242_254	242	254	8.8288923917955326e+04
C242_254	242	254	8.0229205876179652e-16
R242_255	242	255	3.3312084167758760e+04
C242_255	242	255	2.1263605777196165e-15
R242_256	242	256	4.9844634837419151e+04
C242_256	242	256	1.4210857952323522e-15
R242_264	242	264	6.8065590997550127e+04
C242_264	242	264	1.0406653567225987e-15
R242_293	242	293	7.6072013549724346e+04
C242_293	242	293	9.3113747396340190e-16
R242_326	242	326	1.1069352414345754e+05
C242_326	242	326	6.3990647225397383e-16
R243_254	243	254	4.6500695659121877e+04
C243_254	243	254	1.5232783409360642e-15
R243_255	243	255	4.3990825970023638e+04
C243_255	243	255	1.6101880556702346e-15
R243_291	243	291	3.0674175363982678e+04
C243_291	243	291	2.3092227157041045e-15
R243_293	243	293	1.7096075577235631e+04
C243_293	243	293	4.1432609616161693e-15
R243_319	243	319	2.8605643244847786e+04
C243_319	243	319	2.4762072969206157e-15
R243_320	243	320	5.2578962075982563e+04
C243_320	243	320	1.3471833550772182e-15
R243_325	243	325	2.0977384683807784e+04
C243_325	243	325	3.3766603227081799e-15
R243_326	243	326	2.4180649410449074e+04
C243_326	243	326	2.9293465751747366e-15
R244_245	244	245	1.6896636349880606e+04
C244_245	244	245	4.1921658884787752e-15
R244_248	244	248	4.5237245541591059e+04
C244_248	244	248	1.5658226244318034e-15
R244_252	244	252	2.3272857979922632e+04
C244_252	244	252	3.0436099681916028e-15
R244_247	244	247	4.1411163721414414e+04
C244_247	244	247	1.7104929243843203e-15
R244_253	244	253	1.0328652669235000e+04
C244_253	244	253	6.8579615177674823e-15
R244_260	244	260	1.4177164065933908e+04
C244_260	244	260	4.9963097137462604e-15
R244_329	244	329	1.1420378263839155e+04
C244_329	244	329	6.2023779685374566e-15
R244_330	244	330	3.2148051103771239e+04
C244_330	244	330	2.2033529282181163e-15
R245_246	245	246	1.0112905899156397e+05
C245_246	245	246	7.0042679366678209e-16
R245_247	245	247	5.8648042569045771e+04
C245_247	245	247	1.2077726627041034e-15
R245_248	245	248	1.0529730115331961e+05
C245_248	245	248	6.7270007645174018e-16
R245_252	245	252	9.1127112946224908e+04
C245_252	245	252	7.7730436360690638e-16
R245_328	245	328	1.3374780809382399e+05
C245_328	245	328	5.2960495985332607e-16
R245_329	245	329	4.8053785113993981e+04
C245_329	245	329	1.4740462664484723e-15
R245_331	245	331	1.0898041348060196e+05
C245_331	245	331	6.4996544125434132e-16
R246_247	246	247	1.8818989694443411e+04
C246_247	246	247	3.7639375803959701e-15
R246_309	246	309	1.1167476920355643e+04
C246_309	246	309	6.3428384980037408e-15
R246_310	246	310	4.1462078026851450e+04
C246_310	246	310	1.7083924855412991e-15
R246_315	246	315	4.6854276955453686e+04
C246_315	246	315	1.5117830673887972e-15
R246_328	246	328	2.0832521929230803e+04
C246_328	246	328	3.4001405483515260e-15
R246_331	246	331	6.8109220027053540e+04
C246_331	246	331	1.0399987330329781e-15
R247_249	247	249	3.5806435020384735e+04
C247_249	247	249	1.9782338704111211e-15
R247_252	247	252	1.1681775947400243e+04
C247_252	247	252	6.0635902327645555e-15
R247_300	247	300	2.5842831886573476e+04
C247_300	247	300	2.7409342306947882e-15
R247_309	247	309	1.1902555170111264e+04
C247_309	247	309	5.9511173461200492e-15
R247_323	247	323	1.9534919308402208e+04
C247_323	247	323	3.6259941194399336e-15
R247_328	247	328	1.7956088635317075e+04
C247_328	247	328	3.9448180488862472e-15
R247_329	247	329	4.5343390150172316e+04
C247_329	247	329	1.5621571810446294e-15
R247_330	247	330	1.2102307208257378e+04
C247_330	247	330	5.8528924540661527e-15
R247_333	247	333	2.2342656871459974e+04
C247_333	247	333	3.1703258454674292e-15
R248_253	248	253	1.3398099497002855e+05
C248_253	248	253	5.2868321027057166e-16
R248_329	248	329	3.3297955935751248e+04
C248_329	248	329	2.1272627867210216e-15
R248_331	248	331	1.8393068887169927e+05
C248_331	248	331	3.8510975504153018e-16
R248_332	248	332	2.0006956017208856e+05
C248_332	248	332	3.5404437574148225e-16
R248_335	248	335	1.6881905034562718e+05
C248_335	248	335	4.1958240134025709e-16
R249_250	249	250	1.9713921762404851e+04
C249_250	249	250	3.5930700846688967e-15
R249_252	249	252	1.5149178440132318e+04
C249_252	249	252	4.6757322726064173e-15
R249_258	249	258	1.4497087594817911e+04
C249_258	249	258	4.8860505306817593e-15
R249_299	249	299	3.3164501660441609e+04
C249_299	249	299	2.1358229127407552e-15
R249_300	249	300	2.5606571489405309e+04
C249_300	249	300	2.7662236065186349e-15
R249_323	249	323	2.5872648246208308e+04
C249_323	249	323	2.7377755018325500e-15
R249_336	249	336	3.7015778544434615e+04
C249_336	249	336	1.9136029369467348e-15
R249_337	249	337	2.3020134054890517e+04
C249_337	249	337	3.0770238942614571e-15
R250_251	250	251	8.2876788165652615e+03
C250_251	250	251	8.5468445512655844e-15
R250_257	250	257	1.5159165453115880e+04
C250_257	250	257	4.6726518524435388e-15
R250_258	250	258	2.6795977495988041e+04
C250_258	250	258	2.6434379020733755e-15
R250_299	250	299	2.5203500532239330e+04
C250_299	250	299	2.8104628738136027e-15
R250_337	250	337	2.7319601245859798e+04
C250_337	250	337	2.5927721967294309e-15
R251_256	251	256	2.0046825846030715e+04
C251_256	251	256	3.5334023989650758e-15
R251_257	251	257	5.2037385426762230e+04
C251_257	251	257	1.3612041026867417e-15
R251_292	251	292	2.7992466234799223e+04
C251_292	251	292	2.5304487979677319e-15
R251_293	251	293	2.9560858070047907e+04
C251_293	251	293	2.3961923692523322e-15
R251_298	251	298	2.6576029238759671e+04
C251_298	251	298	2.6653154953898556e-15
R251_299	251	299	2.7707035053061521e+04
C251_299	251	299	2.5565168701864829e-15
R251_337	251	337	5.2684571598980197e+04
C251_337	251	337	1.3444828416782858e-15
R252_258	252	258	2.5870633710914848e+04
C252_258	252	258	2.7379886912517057e-15
R252_260	252	260	8.3334370207051106e+03
C252_260	252	260	8.4999145442640690e-15
R252_261	252	261	1.8310226401472428e+04
C252_261	252	261	3.8685213925210604e-15
R252_323	252	323	1.6950054660423684e+04
C252_323	252	323	4.1789542249316529e-15
R252_330	252	330	1.7953820829017870e+04
C252_330	252	330	3.9453163318593071e-15
R252_336	252	336	1.2572216665260021e+04
C252_336	252	336	5.6341299567107813e-15
R252_339	252	339	2.8292752800780709e+04
C252_339	252	339	2.5035917513846668e-15
R253_260	253	260	2.1698616983137992e+04
C253_260	253	260	3.2644247599303107e-15
R253_263	253	263	6.6057882691334235e+04
C253_263	253	263	1.0722944734238698e-15
R253_329	253	329	3.8246023195035901e+04
C253_329	253	329	1.8520488306662364e-15
R253_335	253	335	6.6592667750969034e+04
C253_335	253	335	1.0636832091017895e-15
R253_340	253	340	8.9845334882873882e+04
C253_340	253	340	7.8839377279122505e-16
R254_255	254	255	8.7467742977439666e+03
C254_255	254	255	8.0982428635742790e-15
R254_265	254	265	3.7746612895030143e+04
C254_265	254	265	1.8765525461312640e-15
R254_325	254	325	3.6836217600713258e+04
C254_325	254	325	1.9229309399732849e-15
R254_343	254	343	4.7893943019175036e+04
C254_343	254	343	1.4789657745999487e-15
R255_264	255	264	2.0492293065839509e+04
C255_264	255	264	3.4565923056253222e-15
R255_256	255	256	4.2286425342504677e+04
C255_256	255	256	1.6750884465233082e-15
R255_265	255	265	8.1357459866692006e+04
C255_265	255	265	8.7064545343554238e-16
R255_325	255	325	5.8830431014632013e+04
C255_325	255	325	1.2040282777867571e-15
R255_326	255	326	3.1241222874675834e+04
C255_326	255	326	2.2673088956904343e-15
R255_327	255	327	1.6868366711709565e+04
C255_327	255	327	4.1991915249761133e-15
R255_343	255	343	2.2794604410925152e+04
C255_343	255	343	3.1074679454428452e-15
R256_257	256	257	2.8914753618076338e+04
C256_257	256	257	2.4497356426277054e-15
R256_264	256	264	2.3936055444454072e+04
C256_264	256	264	2.9592805172254044e-15
R256_293	256	293	8.1633549820221044e+04
C256_293	256	293	8.6770087411357664e-16
R256_298	256	298	2.1832063579321435e+04
C256_298	256	298	3.2444712465518383e-15
R256_326	256	326	2.5442306529860300e+04
C256_326	256	326	2.7840833712488463e-15
R256_327	256	327	2.3841564860211638e+04
C256_327	256	327	2.9710089480834198e-15
R256_337	256	337	7.7663713549964770e+04
C256_337	256	337	9.1205402495245650e-16
R256_341	256	341	3.3124094608613472e+04
C256_341	256	341	2.1384283366217866e-15
R256_342	256	342	2.6111637285726392e+04
C256_342	256	342	2.7127177725741569e-15
R256_344	256	344	4.4180109726257382e+04
C256_344	256	344	1.6032894208477221e-15
R256_345	256	345	4.7192009334451774e+04
C256_345	256	345	1.5009639033167662e-15
R257_258	257	258	1.5385561543905265e+04
C257_258	257	258	4.6038945236977397e-15
R257_259	257	259	1.7840607005742855e+04
C257_259	257	259	3.9703527191198606e-15
R257_264	257	264	2.8229817386962717e+04
C257_264	257	264	2.5091732463247459e-15
R257_269	257	269	1.1123179032059787e+04
C257_269	257	269	6.3680987541277641e-15
R257_337	257	337	1.2948232790204971e+04
C257_337	257	337	5.4705150643865357e-15
R257_344	257	344	1.8275986858286728e+04
C257_344	257	344	3.8757689576627468e-15
R257_345	257	345	1.8525734406610089e+04
C257_345	257	345	3.8235192722360408e-15
R257_346	257	346	1.7900082723623815e+04
C257_346	257	346	3.9571606248789435e-15
R258_259	258	259	1.9261454826107536e+04
C258_259	258	259	3.6774741666963919e-15
R258_261	258	261	1.8555519805180666e+04
C258_261	258	261	3.8173817429907541e-15
R258_336	258	336	1.6206474789904751e+04
C258_336	258	336	4.3706915571869612e-15
R258_337	258	337	2.0728621798808454e+04
C258_337	258	337	3.4171834106246152e-15
R258_346	258	346	1.5366037157298471e+04
C258_346	258	346	4.6097443219025367e-15
R259_261	259	261	3.0505877992570200e+04
C259_261	259	261	2.3219624281343983e-15
R259_262	259	262	2.5196129132627586e+04
C259_262	259	262	2.8112851050709431e-15
R259_266	259	266	1.6453173103248319e+04
C259_266	259	266	4.3051575578461206e-15
R259_269	259	269	8.3745647210126881e+03
C259_269	259	269	8.4581712477868954e-15
R259_271	259	271	1.3864924409920393e+04
C259_271	259	271	5.1088271700434540e-15
R259_346	259	346	8.6435200451801411e+03
C259_346	259	346	8.1949833130194060e-15
R260_261	260	261	9.6069930103379138e+03
C260_261	260	261	7.3731189832008169e-15
R260_263	260	263	1.7020020314120342e+04
C260_263	260	263	4.1617754402581007e-15
R260_329	260	329	1.8606424879833579e+04
C260_329	260	329	3.8069378181712018e-15
R260_330	260	330	1.1506166150105759e+04
C260_330	260	330	6.1561341642323628e-15
R260_335	260	335	3.1965570486913319e+04
C260_335	260	335	2.2159311239259504e-15
R260_336	260	336	1.4599702548024914e+04
C260_336	260	336	4.8517086086512462e-15
R260_338	260	338	1.7073545001678580e+04
C260_338	260	338	4.1487284877883316e-15
R260_339	260	339	6.0793139295718856e+03
C260_339	260	339	1.1651561896062214e-14
R260_340	260	340	7.0101090634276889e+03
C260_340	260	340	1.0104479387566764e-14
R260_347	260	347	1.7092561376740865e+04
C260_347	260	347	4.1441128087677067e-15
R261_262	261	262	1.1128851940303315e+04
C261_262	261	262	6.3648526295399209e-15
R261_263	261	263	2.2470863155118521e+04
C261_263	261	263	3.1522377243379376e-15
R261_271	261	271	5.6274976551052525e+04
C261_271	261	271	1.2587033683033175e-15
R261_336	261	336	2.1966630323411020e+04
C261_336	261	336	3.2245957387696803e-15
R261_340	261	340	5.8076676163110940e+04
C261_340	261	340	1.2196548978984429e-15
R261_346	261	346	1.9403395816793698e+04
C261_346	261	346	3.6505724670468976e-15
R261_347	261	347	2.8751502949895537e+04
C261_347	261	347	2.4636452104587240e-15
R261_348	261	348	3.0629263002673611e+04
C261_348	261	348	2.3126087797090316e-15
R262_263	262	263	2.0902491410885508e+04
C262_263	262	263	3.3887588394899013e-15
R262_270	262	270	1.4418695364451954e+04
C262_270	262	270	4.9126152363710984e-15
R262_271	262	271	2.0891952286963759e+04
C262_271	262	271	3.3904683278545953e-15
R262_348	262	348	4.3123088441943524e+04
C262_348	262	348	1.6425888101999679e-15
R263_270	263	270	1.1285575465831962e+05
C263_270	263	270	6.2764635042718427e-16
R263_340	263	340	5.7144061395172925e+04
C263_340	263	340	1.2395601713738789e-15
R263_348	263	348	5.0834613433836748e+04
C263_348	263	348	1.3934108622305669e-15
R264_265	264	265	1.9712512372997029e+04
C264_265	264	265	3.5933269791135555e-15
R264_268	264	268	4.6422876579585842e+04
C264_268	264	268	1.5258318259224070e-15
R264_269	264	269	3.5565039410579200e+04
C264_269	264	269	1.9916610162655923e-15
R264_327	264	327	2.7870146303426383e+04
C264_327	264	327	2.5415547433739758e-15
R264_342	264	342	2.2011697688765445e+04
C264_342	264	342	3.2179936112857275e-15
R264_343	264	343	1.7455453222326018e+04
C264_343	264	343	4.0579583717369168e-15
R264_344	264	344	1.5153725208666887e+04
C264_344	264	344	4.6743293520650711e-15
R264_349	264	349	1.7755091116152144e+04
C264_349	264	349	3.9894755860510013e-15
R265_268	265	268	2.9001981820443722e+04
C265_268	265	268	2.4423676621322795e-15
R265_343	265	343	3.9398434330934462e+04
C265_343	265	343	1.7978760765217437e-15
R265_349	265	349	5.6216240839013095e+04
C265_349	265	349	1.2600184836059475e-15
R266_267	266	267	1.6593425224414797e+04
C266_267	266	267	4.2687692009350103e-15
R266_268	266	268	3.3970266485232023e+04
C266_268	266	268	2.0851618154598118e-15
R266_269	266	269	1.5836758332735944e+04
C266_269	266	269	4.4727273756259226e-15
R266_271	266	271	1.6598420955184014e+04
C266_271	266	271	4.2674844027182779e-15
R266_272	266	272	1.5913535458555003e+04
C266_272	266	272	4.4511480632621096e-15
R266_350	266	350	3.8176069166597314e+04
C266_350	266	350	1.8554425346121482e-15
R267_268	267	268	1.9291750509861664e+04
C267_268	267	268	3.6716990767525699e-15
R267_272	267	272	3.0796038194031367e+04
C267_272	267	272	2.3000849034447674e-15
R267_273	267	273	1.0614738680472279e+04
C267_273	267	273	6.6731273061211553e-15
R267_350	267	350	5.5036585423864577e+04
C267_350	267	350	1.2870257482450151e-15
R268_269	268	269	4.6367994209827266e+04
C268_269	268	269	1.5276378403486668e-15
R268_273	268	273	9.9658683488373310e+04
C268_273	268	273	7.1076096990849564e-16
R268_349	268	349	3.3244145816502678e+04
C268_349	268	349	2.1307060475242423e-15
R268_350	268	350	2.7640838644781030e+04
C268_350	268	350	2.5626394135973271e-15
R268_351	268	351	9.2708844423767485e+04
C268_351	268	351	7.6404255684844489e-16
R269_271	269	271	2.2381150413278639e+04
C269_271	269	271	3.1648731735422670e-15
R269_344	269	344	1.4619211262704486e+04
C269_344	269	344	4.8452342101865302e-15
R269_345	269	345	2.8817682189378393e+04
C269_345	269	345	2.4579874977630149e-15
R269_346	269	346	1.3674840479155340e+04
C269_346	269	346	5.1798412306141361e-15
R269_349	269	349	5.0695800535428592e+04
C269_349	269	349	1.3972262354649723e-15
R269_350	269	350	5.1734312096915564e+04
C269_350	269	350	1.3691783975653392e-15
R269_351	269	351	1.3694710346647989e+04
C269_351	269	351	5.1723257186916475e-15
R269_352	269	352	1.8673170486642204e+04
C269_352	269	352	3.7933302535137525e-15
R270_271	270	271	4.1201847832076855e+04
C270_271	270	271	1.7191826644448222e-15
R270_272	270	272	4.7962517657801334e+04
C270_272	270	272	1.4768512162221450e-15
R270_274	270	274	8.7290187792037512e+04
C270_274	270	274	8.1147153337275042e-16
R270_348	270	348	8.5546954246070425e+04
C270_348	270	348	8.2800729915236848e-16
R270_353	270	353	6.4809041625811595e+04
C270_353	270	353	1.0929571053522422e-15
R271_272	271	272	1.7885450296137842e+04
C271_272	271	272	3.9603980533437106e-15
R271_346	271	346	1.5650925080702305e+04
C271_346	271	346	4.5258348737058480e-15
R271_348	271	348	2.1596292587884021e+04
C271_348	271	348	3.2798917799316683e-15
R271_350	271	350	3.4384265672379981e+04
C271_350	271	350	2.0600557013756083e-15
R271_352	271	352	9.0773082782930123e+03
C271_352	271	352	7.8033598027498349e-15
R271_353	271	353	1.4428592828193117e+04
C271_353	271	353	4.9092453699014278e-15
R272_273	272	273	1.6496184149646415e+04
C272_273	272	273	4.2939325781907131e-15
R272_274	272	274	8.8394632313932652e+03
C272_274	272	274	8.0133262260128551e-15
R272_350	272	350	2.3774648154805476e+04
C272_350	272	350	2.9793712224373214e-15
R272_353	272	353	1.9886282601328985e+04
C272_353	272	353	3.5619277848976282e-15
R272_354	272	354	2.8921203470657347e+04
C272_354	272	354	2.4491893156474528e-15
R273_274	273	274	5.3448983447616367e+04
C273_274	273	274	1.3252544382892082e-15
R273_275	273	275	5.9846781286586418e+04
C273_275	273	275	1.1835808211105259e-15
R273_350	273	350	6.3548926536439627e+04
C273_350	273	350	1.1146294107011126e-15
R273_354	273	354	5.7577482645226817e+04
C273_354	273	354	1.2302292368781098e-15
R274_275	274	275	4.4470242216798157e+04
C274_275	274	275	1.5928292495165093e-15
R274_353	274	353	9.5674300468003275e+04
C274_353	274	353	7.4036080942853734e-16
R274_354	274	354	4.1010870030098464e+04
C274_354	274	354	1.7271884864674728e-15
R275_354	275	354	1.8165257792910017e+05
C275_354	275	354	3.8993942912082777e-16
R276_277	276	277	4.1625558213217031e+04
C276_277	276	277	1.7016829461642825e-15
R276_278	276	278	1.2686935900814367e+04
C276_278	276	278	5.5831843945434650e-15
R276_281	276	281	2.9030910862782199e+04
C276_281	276	281	2.4399338646590305e-15
R276_288	276	288	1.7469253297127707e+04
C276_288	276	288	4.0547527321987164e-15
R276_355	276	355	6.3879613199819840e+04
C276_355	276	355	1.1088592899651400e-15
R277_279	277	279	5.9390092012676236e+04
C277_279	277	279	1.1926821484109047e-15
R277_280	277	280	1.1172769773502696e+04
C277_280	277	280	6.3398337182234344e-15
R277_282	277	282	9.4504227001728606e+04
C277_282	277	282	7.4952734690591542e-16
R277_287	277	287	5.8731651400650408e+04
C277_287	277	287	1.2060533093611530e-15
R277_288	277	288	5.2965742304051586e+04
C277_288	277	288	1.3373456021701342e-15
R277_355	277	355	4.5214407841399858e+04
C277_355	277	355	1.5666135180729372e-15
R278_281	278	281	2.7135624308789676e+04
C278_281	278	281	2.6103509442034786e-15
R278_288	278	288	1.6076751858187692e+04
C278_288	278	288	4.4059585643181636e-15
R278_289	278	289	2.2613020257324897e+04
C278_289	278	289	3.1324211330441514e-15
R278_291	278	291	4.0367679328817270e+04
C278_291	278	291	1.7547083140207688e-15
R278_294	278	294	1.7002149008585762e+04
C278_294	278	294	4.1661499672912182e-15
R278_302	278	302	3.1461209827729817e+04
C278_302	278	302	2.2514551386885178e-15
R278_303	278	303	4.0479259568921720e+04
C278_303	278	303	1.7498714969179673e-15
R278_356	278	356	4.4140418134765321e+04
C278_356	278	356	1.6047311178552479e-15
R279_280	279	280	3.6721251606328740e+04
C279_280	279	280	1.9289512050235283e-15
R279_287	279	287	4.2875171557697126e+04
C279_287	279	287	1.6520867430391353e-15
R279_295	279	295	9.9342228924066774e+04
C279_295	279	295	7.1302509822023727e-16
R279_304	279	304	8.1248394922088672e+04
C279_304	279	304	8.7181417680834441e-16
R279_305	279	305	5.7067686186976185e+04
C279_305	279	305	1.2412191078489077e-15
R279_307	279	307	7.1778001276525771e+04
C279_307	279	307	9.8684138978895409e-16
R279_357	279	357	8.1686271604103531e+04
C279_357	279	357	8.6714084441628096e-16
R280_282	280	282	1.8136096669127019e+04
C280_282	280	282	3.9056641474887754e-15
R280_287	280	287	2.7528231230046968e+04
C280_287	280	287	2.5731221866040373e-15
R280_288	280	288	2.5414044777162242e+04
C280_288	280	288	2.7871794181952860e-15
R280_304	280	304	5.1667937363218516e+04
C280_304	280	304	1.3709372998200062e-15
R280_307	280	307	4.7127569031525061e+04
C280_307	280	307	1.5030162597314816e-15
R280_355	280	355	2.6247578629383363e+04
C280_355	280	355	2.6986680766318026e-15
R280_357	280	357	1.0162918470088840e+04
C280_357	280	357	6.9697993489246996e-15
R280_358	280	358	2.2739542860448044e+04
C280_358	280	358	3.1149923712496453e-15
R280_359	280	359	2.5622453662371681e+04
C280_359	280	359	2.7645089525529651e-15
R280_361	280	361	1.8297886774203096e+04
C280_361	280	361	3.8711302244947309e-15
R281_288	281	288	4.0103236495000085e+04
C281_288	281	288	1.7662789521945753e-15
R281_302	281	302	1.0104548398081975e+04
C281_302	281	302	7.0100611868458643e-15
R281_318	281	318	6.8505201465803344e+04
C281_318	281	318	1.0339872158665047e-15
R281_355	281	355	6.2971403727523779e+04
C281_355	281	355	1.1248518905898208e-15
R281_363	281	363	9.6859640919499259e+04
C281_363	281	363	7.3130048659658188e-16
R282_304	282	304	3.9946343067152731e+04
C282_304	282	304	1.7732161969600992e-15
R282_283	282	283	3.6950220070135489e+04
C282_283	282	283	1.9169981234631464e-15
R282_306	282	306	3.5042899323843354e+04
C282_306	282	306	2.0213368158097740e-15
R282_355	282	355	5.8029815831555577e+04
C282_355	282	355	1.2206397956114485e-15
R282_357	282	357	4.6638076911689328e+04
C282_357	282	357	1.5187912372571769e-15
R282_359	282	359	1.1097893753847789e+04
C282_359	282	359	6.3826077368456586e-15
R282_365	282	365	5.9021581172233717e+04
C282_365	282	365	1.2001288533646253e-15
R282_364	282	364	5.6767524965976532e+04
C282_364	282	364	1.2477821180059179e-15
R282_367	282	367	6.3466410451669108e+04
C282_367	282	367	1.1160786001902705e-15
R283_304	283	304	5.5027019198600865e+04
C283_304	283	304	1.2872494924784340e-15
R283_306	283	306	6.1437834119478859e+04
C283_306	283	306	1.1529296817047501e-15
R283_364	283	364	6.3677274740159628e+04
C283_364	283	364	1.1123827586064567e-15
R283_367	283	367	4.0379561284416348e+04
C283_367	283	367	1.7541919793798440e-15
R283_285	283	285	8.6414150103032749e+04
C283_285	283	285	8.1969795978487631e-16
R283_368	283	368	4.8987853413893878e+04
C283_368	283	368	1.4459401177988808e-15
R284_375	284	375	1.5754616107359298e+04
C284_375	284	375	4.4960475109839239e-15
R284_373	284	373	2.2180326229822498e+04
C284_373	284	373	3.1935284360588445e-15
R284_374	284	374	2.0232811488250049e+04
C284_374	284	374	3.5009223793310030e-15
R284_286	284	286	9.8043063712227609e+04
C284_286	284	286	7.2247336888520629e-16
R284_370	284	370	2.6569146908587147e+04
C284_370	284	370	2.6660059045067277e-15
R284_285	284	285	9.8043063712227347e+04
C284_285	284	285	7.2247336888520826e-16
R284_376	284	376	3.5319905181831156e+04
C284_376	284	376	2.0054839380610040e-15
R285_364	285	364	3.8046681959359492e+04
C285_364	285	364	1.8617524285471879e-15
R285_367	285	367	3.2963235560637746e+04
C285_367	285	367	2.1488637668986636e-15
R285_368	285	368	6.2447816439770926e+04
C285_368	285	368	1.1342830954596600e-15
R285_370	285	370	2.7396133812486984e+04
C285_370	285	370	2.5855291487777210e-15
R285_376	285	376	3.2889306797216559e+04
C285_376	285	376	2.1536939946084447e-15
R285_377	285	377	4.1817176678920659e+04
C285_377	285	377	1.6938853399853270e-15
R286_375	286	375	6.4760519633907279e+04
C286_375	286	375	1.0937760063758512e-15
R286_373	286	373	7.0720503171773424e+04
C286_373	286	373	1.0015978303201848e-15
R286_382	286	382	7.6567436666053967e+04
C286_382	286	382	9.2511262777331435e-16
R286_381	286	381	2.1249778397589058e+05
C286_381	286	381	3.3333760574198072e-16
R286_378	286	378	2.1249778397589058e+05
C286_378	286	378	3.3333760574198072e-16
R287_288	287	288	3.2090803662488423e+04
C287_288	287	288	2.2072835345908991e-15
R287_289	287	289	4.2199183252859482e+04
C287_289	287	289	1.6785515044583292e-15
R287_290	287	290	1.3451470253894835e+04
C287_290	287	290	5.2658557911534139e-15
R287_295	287	295	3.3185697709943277e+04
C287_295	287	295	2.1344587404825452e-15
R287_297	287	297	3.7244997211306487e+04
C287_297	287	297	1.9018259589101819e-15
R287_307	287	307	1.6857485759502702e+04
C287_307	287	307	4.2019019648923966e-15
R287_361	287	361	3.1014527374031532e+04
C287_361	287	361	2.2838814108548666e-15
R287_383	287	383	3.3017506763593163e+04
C287_383	287	383	2.1453316582372822e-15
R288_289	288	289	4.7142624888534345e+04
C288_289	288	289	1.5025362440780761e-15
R288_294	288	294	4.0757414753060475e+04
C288_294	288	294	1.7379292323903132e-15
R288_302	288	302	2.9262120369288419e+04
C288_302	288	302	2.4206551556100548e-15
R288_355	288	355	1.8307955046690433e+04
C288_355	288	355	3.8690013360506224e-15
R288_356	288	356	2.1658885628748085e+04
C288_356	288	356	3.2704130651108804e-15
R288_358	288	358	8.0133937168122675e+03
C288_358	288	358	8.8393887832304892e-15
R288_360	288	360	3.2871521350022587e+04
C288_360	288	360	2.1548592710921596e-15
R288_361	288	361	1.6524575818275625e+04
C288_361	288	361	4.2865549660682093e-15
R288_383	288	383	3.2171260499281689e+04
C288_383	288	383	2.2017633576272704e-15
R289_290	289	290	1.2407626125391163e+04
C289_290	289	290	5.7088682250866038e-15
R289_291	289	291	2.2148654120747404e+04
C289_291	289	291	3.1980951144858888e-15
R289_292	289	292	1.6967894606625785e+04
C289_292	289	292	4.1745604966417146e-15
R289_294	289	294	1.1398819422999799e+04
C289_294	289	294	6.2141086640145176e-15
R289_296	289	296	1.5283253963260731e+04
C289_296	289	296	4.6347134390540123e-15
R289_383	289	383	2.7951751952272156e+04
C289_383	289	383	2.5341346280171914e-15
R290_296	290	296	3.4416091497569032e+04
C290_296	290	296	2.0581506921261908e-15
R290_297	290	297	1.5941531861807433e+04
C290_297	290	297	4.4433309891442880e-15
R290_383	290	383	3.9906639751083756e+04
C290_383	290	383	1.7749803786493039e-15
R291_292	291	292	2.3261179656560420e+04
C291_292	291	292	3.0451380188718255e-15
R291_293	291	293	1.5342656020526685e+04
C291_293	291	293	4.6167692504630909e-15
R291_294	291	294	2.2023800403475794e+04
C291_294	291	294	3.2162252308108037e-15
R291_303	291	303	1.7292181820494112e+04
C291_303	291	303	4.0962732910921945e-15
R291_319	291	319	2.6219889944162194e+04
C291_319	291	319	2.7015179196726931e-15
R291_320	291	320	4.1775355944104194e+04
C291_320	291	320	1.6955810653241560e-15
R291_384	291	384	3.8828972267496392e+04
C291_384	291	384	1.8242435583414736e-15
R292_293	292	293	1.4089010963893794e+04
C292_293	292	293	5.0275709712716197e-15
R292_294	292	294	5.1370495628231205e+04
C292_294	292	294	1.3788752019957677e-15
R292_296	292	296	1.4369341588241687e+04
C292_296	292	296	4.9294883903353296e-15
R292_298	292	298	2.3670377330785865e+04
C292_298	292	298	2.9924957066009013e-15
R292_299	292	299	1.5359759938353447e+04
C292_299	292	299	4.6116282298871210e-15
R292_301	292	301	4.3592187820672101e+04
C292_301	292	301	1.6249127671084598e-15
R292_324	292	324	6.5973086267954423e+04
C292_324	292	324	1.0736727132683267e-15
R292_384	292	384	3.3236320435282621e+04
C292_384	292	384	2.1312077151839413e-15
R293_298	293	298	3.0977199348249484e+04
C293_298	293	298	2.2866335248606911e-15
R293_319	293	319	2.4627281934334645e+04
C293_319	293	319	2.8762208807641903e-15
R293_324	293	324	2.5047181455185779e+04
C293_324	293	324	2.8280029297002846e-15
R293_326	293	326	1.4671360118676117e+04
C293_326	293	326	4.8280119881885724e-15
R293_384	293	384	6.7373815072500685e+04
C293_384	293	384	1.0513506242711116e-15
R294_296	294	296	3.2954881119644000e+04
C294_296	294	296	2.1494085285526038e-15
R294_303	294	303	2.3466688389372484e+04
C294_303	294	303	3.0184703252836841e-15
R294_356	294	356	1.3634464816846106e+04
C294_356	294	356	5.1951802646834689e-15
R294_383	294	383	2.8526987179168184e+04
C294_383	294	383	2.4830348221184090e-15
R294_384	294	384	1.3501518310010701e+04
C294_384	294	384	5.2463360719572182e-15
R295_297	295	297	1.4862609242070701e+04
C295_297	295	297	4.7658860824716990e-15
R295_305	295	305	4.5007604188423858e+04
C295_305	295	305	1.5738118883079469e-15
R295_307	295	307	1.3580122647331193e+04
C295_307	295	307	5.2159692791817615e-15
R295_308	295	308	5.5530071626584628e+04
C295_308	295	308	1.2755881716185105e-15
R295_310	295	310	5.9236467693757470e+04
C295_310	295	310	1.1957752596288699e-15
R295_312	295	312	2.1108752021706157e+04
C295_312	295	312	3.3556461539347198e-15
R295_313	295	313	3.4342753886021899e+04
C295_313	295	313	2.0625457926608061e-15
R295_314	295	314	3.2896519241229158e+04
C295_314	295	314	2.1532218049143778e-15
R295_385	295	385	2.4241498847489274e+04
C295_385	295	385	2.9219935195276231e-15
R296_297	296	297	2.6635025545942572e+04
C296_297	296	297	2.6594118490263804e-15
R296_299	296	299	3.8794548828808322e+04
C296_299	296	299	1.8258622583438832e-15
R296_298	296	298	5.4909553101484715e+04
C296_298	296	298	1.2900032605452899e-15
R296_301	296	301	1.3465413601472575e+04
C296_301	296	301	5.2604030319762081e-15
R296_383	296	383	1.0487230709937083e+04
C296_383	296	383	6.7542618728586149e-15
R296_384	296	384	1.2771123901688137e+04
C296_384	296	384	5.5463797142111313e-15
R296_386	296	386	1.3632021319480935e+04
C296_386	296	386	5.1961114845657483e-15
R297_301	297	301	2.4805520850350204e+04
C297_301	297	301	2.8555539294390581e-15
R297_307	297	307	4.8822119264639827e+04
C297_307	297	307	1.4508485826280437e-15
R297_308	297	308	1.9358755628473085e+04
C297_308	297	308	3.6589904793166167e-15
R297_312	297	312	5.5499887889912672e+04
C297_312	297	312	1.2762819030644254e-15
R297_383	297	383	3.4835488804883011e+04
C297_383	297	383	2.0333718562913067e-15
R297_385	297	385	1.8432816163362106e+04
C297_385	297	385	3.8427933045191353e-15
R297_386	297	386	6.3669420562281994e+04
C297_386	297	386	1.1125199807136621e-15
R297_387	297	387	4.5831103546422702e+04
C297_387	297	387	1.5455334271899470e-15
R298_299	298	299	7.1973842835543064e+03
C298_299	298	299	9.8415618432173079e-15
R298_324	298	324	7.1926695847205347e+03
C298_324	298	324	9.8480128555428696e-15
R298_326	298	326	1.6259106617675128e+04
C298_326	298	326	4.3565433330142223e-15
R298_337	298	337	1.5862397751530369e+04
C298_337	298	337	4.4654978172619672e-15
R298_341	298	341	8.0458193661190126e+03
C298_341	298	341	8.8037649508116290e-15
R298_345	298	345	3.3904044730386770e+04
C298_345	298	345	2.0892345765611536e-15
R298_384	298	384	3.8569754019351065e+04
C298_384	298	384	1.8365038703762979e-15
R298_386	298	386	2.7816061310735266e+04
C298_386	298	386	2.5464964915310525e-15
R298_388	298	388	6.7525412770384582e+03
C298_388	298	388	1.0489902931339990e-14
R299_300	299	300	2.1515109739339572e+04
C299_300	299	300	3.2922677780482616e-15
R299_301	299	301	9.8718495507378684e+03
C299_301	299	301	7.1753020720119859e-15
R299_337	299	337	1.2299925926497614e+04
C299_337	299	337	5.7588560255801265e-15
R299_386	299	386	3.1780316602569539e+04
C299_386	299	386	2.2288482340126497e-15
R299_388	299	388	2.3146372227075266e+04
C299_388	299	388	3.0602420906868133e-15
R299_390	299	390	1.2475637830055215e+04
C299_390	299	390	5.6777459798772078e-15
R300_301	300	301	2.5934605705176600e+04
C300_301	300	301	2.7312349893124264e-15
R300_308	300	308	3.2030230956570536e+04
C300_308	300	308	2.2114577516485109e-15
R300_309	300	309	2.7047657110271099e+04
C300_309	300	309	2.6188405985486131e-15
R300_311	300	311	9.5047523567656081e+03
C300_311	300	311	7.4524300978320370e-15
R300_323	300	323	9.7922055751828484e+03
C300_323	300	323	7.2336617110570986e-15
R300_333	300	333	2.2814525850210484e+04
C300_333	300	333	3.1047545323124256e-15
R300_337	300	337	5.1501630750910575e+04
C300_337	300	337	1.3753642652324680e-15
R300_389	300	389	3.0279718638071532e+04
C300_389	300	389	2.3393051759384272e-15
R300_390	300	390	9.4122522664007356e+03
C300_390	300	390	7.5256697898819571e-15
R301_308	301	308	2.2859340814519590e+04
C301_308	301	308	3.0986677660892405e-15
R301_311	301	311	3.3188323789350434e+04
C301_311	301	311	2.1342898480076074e-15
R301_386	301	386	2.3308983396557447e+04
C301_386	301	386	3.0388928307556115e-15
R301_387	301	387	6.2326779489636516e+04
C301_387	301	387	1.1364858431002033e-15
R301_390	301	390	2.6387167809112292e+04
C301_390	301	390	2.6843920138916550e-15
R302_303	302	303	2.4696828865332642e+04
C302_303	302	303	2.8681213657932496e-15
R302_316	302	316	3.8196764031077153e+04
C302_316	302	316	1.8544372627578967e-15
R302_318	302	318	1.8798441405426918e+04
C302_318	302	318	3.7680518830434055e-15
R302_355	302	355	6.4833947242268732e+04
C302_355	302	355	1.0925372516856395e-15
R302_356	302	356	1.4434313857819674e+04
C302_356	302	356	4.9072995941283718e-15
R302_358	302	358	3.7467502506378230e+04
C302_358	302	358	1.8905317354403797e-15
R302_362	302	362	2.2389568881591724e+04
C302_362	302	362	3.1636831825840989e-15
R302_363	302	363	2.7023746328870049e+04
C302_363	302	363	2.6211577652476358e-15
R302_393	302	393	7.2861356248180164e+04
C302_393	302	393	9.7216832328411678e-16
R302_394	302	394	1.9978092703111575e+04
C302_394	302	394	3.5455588072713145e-15
R303_316	303	316	2.5824632918052386e+04
C303_316	303	316	2.7428658041634638e-15
R303_320	303	320	2.6453515940950059e+04
C303_320	303	320	2.6776592833298848e-15
R303_319	303	319	4.6993214459924442e+04
C303_319	303	319	1.5073134142889166e-15
R303_321	303	321	1.4584902394814082e+04
C303_321	303	321	4.8566319210463899e-15
R303_356	303	356	2.7177388408998493e+04
C303_356	303	356	2.6063395595636729e-15
R303_384	303	384	3.4436430676685413e+04
C303_384	303	384	2.0569350871766336e-15
R303_391	303	391	7.8377566495635823e+04
C303_391	303	391	9.0374715244500640e-16
R303_394	303	394	3.6262094969915343e+04
C303_394	303	394	1.9533759038126907e-15
R304_306	304	306	1.1950037539257932e+04
C304_306	304	306	5.9274711316428713e-15
R304_357	304	357	2.6958479051351551e+04
C304_357	304	357	2.6275036659551010e-15
R304_305	304	305	4.6241113373090957e+04
C304_305	304	305	1.5318295207230036e-15
R304_368	304	368	7.0318526721976988e+04
C304_368	304	368	1.0073234727465083e-15
R304_396	304	396	7.0300172309762609e+04
C304_396	304	396	1.0075864711097349e-15
R305_307	305	307	5.1195783852022665e+04
C305_307	305	307	1.3835807796348737e-15
R305_313	305	313	5.8555092142363923e+04
C305_313	305	313	1.2096898825431578e-15
R305_314	305	314	2.0971579700111448e+04
C305_314	305	314	3.3775949904061624e-15
R305_306	305	306	6.1582870881205054e+04
C305_306	305	306	1.1502143619228088e-15
R305_357	305	357	3.4828447820800568e+04
C305_357	305	357	2.0337829265447813e-15
R305_395	305	395	6.3429731362478553e+04
C305_395	305	395	1.1167239875447602e-15
R305_396	305	396	5.8862643950177240e+04
C305_396	305	396	1.2033693660780033e-15
R305_399	305	399	3.8113247489822279e+04
C305_399	305	399	1.8585008416014748e-15
R306_357	306	357	1.5092296850505178e+04
C306_357	306	357	4.6933547118528232e-15
R306_359	306	359	3.7035231166341953e+04
C306_359	306	359	1.9125978238897646e-15
R306_367	306	367	2.5841142949820161e+04
C306_367	306	367	2.7411133738762498e-15
R306_368	306	368	3.9631008860276364e+04
C306_368	306	368	1.7873252428604979e-15
R306_396	306	396	3.8352437789576834e+04
C306_396	306	396	1.8469100432320016e-15
R306_369	306	369	1.1530426839168502e+05
C306_369	306	369	6.1431812997052977e-16
R306_397	306	397	4.7899720818871232e+04
C306_397	306	397	1.4787873775684607e-15
R306_398	306	398	2.4316628075898672e+04
C306_398	306	398	2.9129656593385303e-15
R306_399	306	399	2.2691814181051475e+04
C306_399	306	399	3.1215442701425194e-15
R306_400	306	400	9.1327493023150964e+04
C306_400	306	400	7.7559889351221033e-16
R307_314	307	314	1.8964626119759992e+04
C307_314	307	314	3.7350329022408617e-15
R307_357	307	357	2.1304258036753272e+04
C307_357	307	357	3.3248518870641177e-15
R307_361	307	361	1.0405053754221195e+04
C307_361	307	361	6.8076056317598337e-15
R307_383	307	383	2.2405692470634403e+04
C307_383	307	383	3.1614065322389198e-15
R307_360	307	360	3.8107500494738953e+04
C307_360	307	360	1.8587811222564739e-15
R307_385	307	385	1.1086406094540844e+04
C307_385	307	385	6.3892213519834676e-15
R307_402	307	402	4.4534659663685976e+04
C307_402	307	402	1.5905252913329969e-15
R308_309	308	309	9.4412753065049110e+03
C308_309	308	309	7.5025354347199968e-15
R308_310	308	310	1.4125065543101779e+04
C308_310	308	310	5.0147379720013246e-15
R308_311	308	311	7.9760617848911606e+03
C308_311	308	311	8.8807615144328501e-15
R308_312	308	312	1.9347201914183875e+04
C308_312	308	312	3.6611755462204760e-15
R308_387	308	387	2.3841647526706580e+04
C308_387	308	387	2.9709986466604203e-15
R308_404	308	404	1.4775507631912733e+04
C308_404	308	404	4.7939809785628592e-15
R309_310	309	310	3.4787885685433685e+04
C309_310	309	310	2.0361542859058914e-15
R309_311	309	311	2.0689451190423330e+04
C309_311	309	311	3.4236530434788527e-15
R309_315	309	315	4.4319017267866286e+04
C309_315	309	315	1.5982642870413595e-15
R309_328	309	328	1.2103015138765310e+04
C309_328	309	328	5.8525501062230421e-15
R309_333	309	333	3.7710009867773995e+04
C309_333	309	333	1.8783740122150566e-15
R309_404	309	404	3.3467850454538100e+04
C309_404	309	404	2.1164640565195087e-15
R310_312	310	312	5.0273326306119990e+04
C310_312	310	312	1.4089678909385623e-15
R310_313	310	313	3.8294838717536528e+04
C310_313	310	313	1.8496879712294731e-15
R310_315	310	315	4.7478628751087381e+04
C310_315	310	315	1.4919028708127497e-15
R310_404	310	404	3.5388899660237999e+04
C310_404	310	404	2.0015740307288108e-15
R311_328	311	328	3.0549616227613064e+04
C311_328	311	328	2.3186380479626228e-15
R311_333	311	333	1.3047040254301048e+04
C311_333	311	333	5.4290859195172068e-15
R311_334	311	334	2.3363008995804761e+04
C311_334	311	334	3.0318655678606898e-15
R311_386	311	386	4.1094986173990947e+04
C311_386	311	386	1.7236531540879458e-15
R311_387	311	387	1.8346967647351907e+04
C311_387	311	387	3.8607743741360827e-15
R311_389	311	389	5.5515712650884852e+03
C311_389	311	389	1.2759180987451671e-14
R311_390	311	390	1.7876384780125460e+04
C311_390	311	390	3.9624064600998638e-15
R311_404	311	404	1.2011708919302248e+04
C311_404	311	404	5.8970378829421960e-15
R312_313	312	313	1.3234549311590019e+04
C312_313	312	313	5.3521658250929857e-15
R312_314	312	314	2.5348245030640104e+04
C312_314	312	314	2.7944144634225704e-15
R312_385	312	385	1.5940999983428932e+04
C312_385	312	385	4.4434792428099371e-15
R312_387	312	387	1.5881459173907928e+04
C312_387	312	387	4.4601381875775149e-15
R312_395	312	395	7.4488507874939882e+04
C312_395	312	395	9.5093195657676028e-16
R312_404	312	404	7.3696150258576190e+03
C312_404	312	404	9.6115607514731687e-15
R312_405	312	405	1.2942050953157983e+04
C312_405	312	405	5.4731280839777532e-15
R312_406	312	406	5.7029625224272459e+04
C312_406	312	406	1.2420474842232079e-15
R313_314	313	314	5.4576356675495605e+04
C313_314	313	314	1.2978789140720295e-15
R313_395	313	395	7.5049368480997626e+04
C313_395	313	395	9.4382543077540928e-16
R313_315	313	315	1.0030044223456441e+05
C313_315	313	315	7.0621326245349457e-16
R313_404	313	404	4.1148009800124208e+04
C313_404	313	404	1.7214320420373332e-15
R313_406	313	406	6.4867043668433500e+04
C313_406	313	406	1.0919798179498350e-15
R314_357	314	357	3.5173644907745162e+04
C314_357	314	357	2.0138232111509890e-15
R314_385	314	385	1.2170725283506950e+04
C314_385	314	385	5.8199902541543175e-15
R314_395	314	395	2.5256310573989133e+04
C314_395	314	395	2.8045862965016637e-15
R314_399	314	399	1.7536554334527635e+04
C314_399	314	399	4.0391915757667552e-15
R314_402	314	402	1.6438852551881733e+04
C314_402	314	402	4.3089079552509142e-15
R314_403	314	403	1.0301976732302564e+04
C314_403	314	403	6.8757195222443690e-15
R314_405	314	405	2.0577290990367193e+04
C314_405	314	405	3.4423142759248114e-15
R314_407	314	407	2.4912497028424619e+04
C314_407	314	407	2.8432919612666891e-15
R315_328	315	328	1.3363713635506139e+04
C315_328	315	328	5.3004355277265153e-15
R315_331	315	331	6.4415037665028787e+04
C315_331	315	331	1.0996423366908289e-15
R315_404	315	404	1.1992046871854778e+04
C315_404	315	404	5.9067066108827163e-15
R315_334	315	334	3.0075800363007405e+04
C315_334	315	334	2.3551660032669888e-15
R315_406	315	406	4.7543958872171701e+04
C315_406	315	406	1.4898528481072720e-15
R315_410	315	410	3.1277233477870192e+04
C315_410	315	410	2.2646984614581512e-15
R315_411	315	411	3.5086947289464209e+04
C315_411	315	411	2.0187992404021326e-15
R316_317	316	317	1.3643724978703258e+04
C316_317	316	317	5.1916542327381511e-15
R316_318	316	318	1.5947741931251514e+04
C316_318	316	318	4.4416007508369105e-15
R316_320	316	320	1.2743519154007256e+04
C316_320	316	320	5.5583941672599990e-15
R316_321	316	321	2.2966994936909585e+04
C316_321	316	321	3.0841432555969940e-15
R316_322	316	322	1.4104167673021815e+04
C316_322	316	322	5.0221682114208691e-15
R316_394	316	394	2.4770957260422238e+04
C316_394	316	394	2.8595383614493633e-15
R316_414	316	414	1.3123939929868488e+04
C316_414	316	414	5.3972742114425255e-15
R317_318	317	318	5.5184705183412909e+04
C317_318	317	318	1.2835712775954220e-15
R317_322	317	322	8.0075029334432198e+04
C317_322	317	322	8.8458915500567496e-16
R317_392	317	392	1.6015005866886413e+05
C317_392	317	392	4.4229457750283822e-16
R317_414	317	414	5.1497698182046093e+04
C317_414	317	414	1.3754692935129100e-15
R318_363	318	363	6.1067471912150162e+04
C318_363	318	363	1.1599219734836732e-15
R318_393	318	393	3.9065177899065580e+04
C318_393	318	393	1.8132133615010188e-15
R318_366	318	366	8.9217897044675075e+04
C318_366	318	366	7.9393826667457476e-16
R318_392	318	392	4.2287082423933331e+04
C318_392	318	392	1.6750624180189405e-15
R318_394	318	394	4.2610246422627330e+04
C318_394	318	394	1.6623584344817418e-15
R318_414	318	414	5.0267118756046992e+04
C318_414	318	414	1.4091418861654752e-15
R318_415	318	415	5.3910951184376318e+04
C318_415	318	415	1.3138982151093624e-15
R319_320	319	320	4.1727154408693023e+03
C319_320	319	320	1.6975397325738382e-14
R319_321	319	321	1.1137360990693887e+04
C319_321	319	321	6.3599898212140911e-15
R319_325	319	325	1.7002155260270712e+04
C319_325	319	325	4.1661484353997233e-15
R319_326	319	326	1.2847983849227152e+04
C319_326	319	326	5.5131998426555375e-15
R319_324	319	324	9.0591613228440110e+03
C319_324	319	324	7.8189911860144146e-15
R319_384	319	384	1.9081362443482078e+04
C319_384	319	384	3.7121826465906132e-15
R319_419	319	419	1.1759759974677434e+04
C319_419	319	419	6.0233799574589493e-15
R319_421	319	421	1.5571063500735663e+04
C319_421	319	421	4.5490471818224515e-15
R319_422	319	422	1.9130414734382186e+04
C319_422	319	422	3.7026642401376863e-15
R320_321	320	321	1.3151330128142945e+04
C320_321	320	321	5.3860333400361668e-15
R320_322	320	322	1.4082571372037484e+04
C320_322	320	322	5.0298699480868836e-15
R320_325	320	325	3.1406731872040837e+04
C320_325	320	325	2.2553605012006356e-15
R320_414	320	414	5.4188429304005891e+04
C320_414	320	414	1.3071702473347686e-15
R320_422	320	422	2.4618431500166233e+04
C320_422	320	422	2.8772548947938342e-15
R321_384	321	384	4.3757171165252403e+04
C321_384	321	384	1.6187861474977830e-15
R321_391	321	391	3.2410606629380476e+04
C321_391	321	391	2.1855037564088316e-15
R321_394	321	394	2.2456014373263813e+04
C321_394	321	394	3.1543221053658815e-15
R321_414	321	414	4.0493887162372521e+04
C321_414	321	414	1.7492393914165762e-15
R321_420	321	420	1.7034250755533794e+04
C321_420	321	420	4.1582986861332216e-15
R321_421	321	421	2.1486603446046985e+04
C321_421	321	421	3.2966356322377079e-15
R321_422	321	422	2.5615149328780350e+04
C321_422	321	422	2.7652972710338167e-15
R322_325	322	325	9.9402976363025969e+04
C322_325	322	325	7.1258935222735757e-16
R322_414	322	414	1.0442288658074138e+05
C322_414	322	414	6.7833312078794588e-16
R322_422	322	422	1.4920559667863714e+05
C322_422	322	422	4.7473757092747022e-16
R323_330	323	330	2.3694271541545109e+04
C323_330	323	330	2.9894779593372103e-15
R323_333	323	333	9.9985953362291584e+03
C323_333	323	333	7.0843453659275640e-15
R323_336	323	336	1.4959158074374755e+04
C323_336	323	336	4.7351262807589938e-15
R323_337	323	337	2.8526164497656748e+04
C323_337	323	337	2.4831064317047790e-15
R323_339	323	339	1.8039589074254167e+04
C323_339	323	339	3.9265585399111182e-15
R323_389	323	389	3.9430299360231184e+04
C323_389	323	389	1.7964231488295934e-15
R323_390	323	390	2.9434183593699581e+04
C323_390	323	390	2.4065047467857065e-15
R323_423	323	423	1.1768094447844449e+04
C323_423	323	423	6.0191140417788286e-15
R324_326	324	326	1.0116670624294473e+04
C324_326	324	326	7.0016614325565097e-15
R324_341	324	341	1.2996519952007948e+04
C324_341	324	341	5.4501899583554517e-15
R324_384	324	384	1.0662716189640048e+04
C324_384	324	384	6.6431011832446788e-15
R324_386	324	386	4.0667403118239803e+04
C324_386	324	386	1.7417758967803471e-15
R324_388	324	388	3.3423114322939895e+04
C324_388	324	388	2.1192968988944147e-15
R324_419	324	419	6.2160673500098937e+03
C324_419	324	419	1.1395227649180356e-14
R324_421	324	421	1.4973097187681189e+04
C324_421	324	421	4.7307181438905531e-15
R324_424	324	424	1.1537741919318994e+04
C324_424	324	424	6.1392864419505835e-15
R325_326	325	326	1.7079978797533211e+04
C325_326	325	326	4.1471657181582802e-15
R325_327	325	327	2.9097535378873788e+04
C325_327	325	327	2.4343471573688171e-15
R325_343	325	343	4.9178247186362503e+04
C325_343	325	343	1.4403421550909336e-15
R325_419	325	419	3.6882513531320576e+04
C325_419	325	419	1.9205172249404394e-15
R325_422	325	422	3.5937457931890109e+04
C325_422	325	422	1.9710215082615485e-15
R325_425	325	425	3.4303938234062509e+04
C325_425	325	425	2.0648796080697526e-15
R326_327	326	327	9.1488295124125343e+03
C326_327	326	327	7.7423568162350971e-15
R326_341	326	341	1.9246768158779541e+04
C326_341	326	341	3.6802803437775534e-15
R326_419	326	419	2.1203169825026576e+04
C326_419	326	419	3.3407034476700569e-15
R326_425	326	425	5.4369324582441855e+04
C326_425	326	425	1.3028210867065861e-15
R327_341	327	341	1.9250150437733613e+04
C327_341	327	341	3.6796337132594119e-15
R327_342	327	342	8.2385315191923855e+03
C327_342	327	342	8.5978311026652188e-15
R327_343	327	343	8.2246034489366011e+03
C327_343	327	343	8.6123912205345819e-15
R327_425	327	425	2.2434358239395504e+04
C327_425	327	425	3.1573670073438493e-15
R328_329	328	329	3.6857174621160928e+04
C328_329	328	329	1.9218375598256556e-15
R328_330	328	330	2.8254083130911426e+04
C328_330	328	330	2.5070182673351204e-15
R328_331	328	331	1.6772250406512248e+04
C328_331	328	331	4.2232557241392675e-15
R328_333	328	333	1.6442557730457513e+04
C328_333	328	333	4.3079369826259421e-15
R328_334	328	334	1.3460985956178394e+04
C328_334	328	334	5.2621333063265299e-15
R328_404	328	404	4.2400574870041200e+04
C328_404	328	404	1.6705788247708062e-15
R328_410	328	410	6.5698130182873938e+04
C328_410	328	410	1.0781661873607592e-15
R328_426	328	426	2.7427224133166164e+04
C328_426	328	426	2.5825983042281380e-15
R329_330	329	330	1.1599340780135639e+04
C329_330	329	330	6.1066834640555949e-15
R329_331	329	331	1.5731882708769916e+04
C329_331	329	331	4.5025445362946359e-15
R329_332	329	332	4.6880630474125799e+04
C329_332	329	332	1.5109332323312975e-15
R329_335	329	335	9.8769123292525437e+03
C329_335	329	335	7.1716241042468079e-15
R329_338	329	338	2.8285637388268588e+04
C329_338	329	338	2.5042215440893007e-15
R329_426	329	426	2.8811638915581967e+04
C329_426	329	426	2.4585030634162129e-15
R330_333	330	333	1.0647071500249982e+04
C330_333	330	333	6.6528624828279710e-15
R330_338	330	338	1.9675147796880701e+04
C330_338	330	338	3.6001509755992777e-15
R330_339	330	339	1.7908409935105999e+04
C330_339	330	339	3.9553205891911451e-15
R330_426	330	426	4.7143132949013612e+04
C330_426	330	426	1.5025200512789019e-15
R331_332	331	332	8.2307337765722768e+04
C331_332	331	332	8.6059766308586535e-16
R331_410	331	410	8.5135164544222047e+04
C331_410	331	410	8.3201228206009652e-16
R331_426	331	426	9.4064861692199032e+04
C331_426	331	426	7.5302829623864064e-16
R332_335	332	335	7.0940776837610261e+04
C332_335	332	335	9.9848783300109882e-16
R332_413	332	413	2.0241959364126981e+05
C332_413	332	413	3.4993402200743438e-16
R332_410	332	410	6.2057052467229048e+04
C332_410	332	410	1.1414255063661879e-15
R332_418	332	418	5.5583410310136846e+04
C332_418	332	418	1.2743640978625231e-15
R332_426	332	426	6.6839843554266146e+04
C332_426	332	426	1.0597496757827013e-15
R333_334	333	334	1.3409072004932072e+04
C333_334	333	334	5.2825059414959002e-15
R333_339	333	339	2.1051848266672412e+04
C333_339	333	339	3.3647165625897982e-15
R333_338	333	338	1.9237381716787324e+04
C333_338	333	338	3.6820760526983673e-15
R333_389	333	389	1.1327055845551740e+04
C333_389	333	389	6.2534787063680909e-15
R333_423	333	423	1.3528930873446405e+04
C333_423	333	423	5.2357058513046899e-15
R333_426	333	426	1.7436989487424264e+04
C333_426	333	426	4.0622552756074015e-15
R333_427	333	427	2.2635428612342421e+04
C333_427	333	427	3.1293201356645231e-15
R334_389	334	389	2.4183998770929436e+04
C334_389	334	389	2.9289408756150773e-15
R334_404	334	404	1.1504057987156302e+04
C334_404	334	404	6.1572622995365661e-15
R334_410	334	410	4.6438125714444737e+04
C334_410	334	410	1.5253307803929521e-15
R334_411	334	411	9.6447521292796773e+03
C334_411	334	411	7.3442532878540897e-15
R334_416	334	416	1.5909489117132844e+04
C334_416	334	416	4.4522801464265617e-15
R334_426	334	426	1.1504057987156302e+04
C334_426	334	426	6.1572622995365661e-15
R334_427	334	427	3.2662547982115750e+04
C334_427	334	427	2.1686459542220839e-15
R335_338	335	338	1.4751484647604868e+04
C335_338	335	338	4.8017880388399381e-15
R335_340	335	340	5.5118484543652019e+04
C335_340	335	340	1.2851133902257819e-15
R335_426	335	426	2.9806005747163483e+04
C335_426	335	426	2.3764842272682227e-15
R335_418	335	418	8.3678594939421295e+04
C335_418	335	418	8.4649488423269510e-16
R335_428	335	428	4.0138363258141355e+04
C335_428	335	428	1.7647332074915308e-15
R336_337	336	337	1.2284126376950115e+04
C336_337	336	337	5.7662629284660996e-15
R336_339	336	339	1.0293033964225075e+04
C336_339	336	339	6.8816932677179613e-15
R336_346	336	346	2.0783650527578287e+04
C336_346	336	346	3.4081357575758637e-15
R336_347	336	347	9.9889457658037099e+03
C336_347	336	347	7.0911890200157434e-15
R336_423	336	423	1.7788770398896999e+04
C336_423	336	423	3.9819223559370967e-15
R336_431	336	431	2.4625146573627306e+04
C336_431	336	431	2.8764702912209381e-15
R337_345	337	345	1.3726590371055332e+04
C337_345	337	345	5.1603129853254413e-15
R337_346	337	346	3.0592200844214807e+04
C337_346	337	346	2.3154104831066804e-15
R337_388	337	388	1.2969667778816351e+04
C337_388	337	388	5.4614739362633442e-15
R337_390	337	390	2.3896682514903980e+04
C337_390	337	390	2.9641563213564174e-15
R337_423	337	423	2.1993182794707551e+04
C337_423	337	423	3.2207026694219724e-15
R337_431	337	431	2.5890636168266778e+04
C337_431	337	431	2.7358733897322340e-15
R337_432	337	432	4.0272432181119271e+04
C337_432	337	432	1.7588583231684861e-15
R338_339	338	339	7.0341918901042163e+03
C338_339	338	339	1.0069884876989125e-14
R338_340	338	340	2.0890250410791021e+04
C338_340	338	340	3.3907445407839829e-15
R338_423	338	423	3.1303948609797579e+04
C338_423	338	423	2.2627657430357003e-15
R338_426	338	426	8.9962643856767118e+03
C338_426	338	426	7.8736572758773813e-15
R338_427	338	427	2.5265271391828919e+04
C338_427	338	427	2.8035915956520614e-15
R338_428	338	428	8.7980072974173618e+03
C338_428	338	428	8.0510847674328539e-15
R338_429	338	429	1.8355379316305083e+04
C338_429	338	429	3.8590051077331100e-15
R338_433	338	433	4.7098763382724428e+04
C338_433	338	433	1.5039355059156681e-15
R339_340	339	340	3.2669346695585471e+04
C339_340	339	340	2.1681946442342403e-15
R339_347	339	347	1.1294812544818846e+04
C339_347	339	347	6.2713305116774812e-15
R339_423	339	423	1.3187290468258061e+04
C339_423	339	423	5.3713461993194851e-15
R339_429	339	429	3.6986290139520199e+04
C339_429	339	429	1.9151286130293382e-15
R339_433	339	433	5.7475782625325199e+04
C339_433	339	433	1.2324060552207092e-15
R340_347	340	347	2.1032274654923509e+04
C340_347	340	347	3.3678479241149683e-15
R340_348	340	348	5.6015662734820617e+04
C340_348	340	348	1.2645302952377331e-15
R340_428	340	428	8.7453742722730633e+04
C340_428	340	428	8.0995392913686277e-16
R340_433	340	433	2.8318714164017656e+04
C340_433	340	433	2.5012965675539929e-15
R341_342	341	342	1.4342720719644962e+04
C341_342	341	342	4.9386377885041475e-15
R341_345	341	345	3.0656481199343627e+04
C341_345	341	345	2.3105555420860439e-15
R341_388	341	388	1.8402922831573836e+04
C341_388	341	388	3.8490354594364322e-15
R341_419	341	419	1.8578960975617552e+04
C341_419	341	419	3.8125653328493281e-15
R341_424	341	424	4.7409147419943030e+04
C341_424	341	424	1.4940893559752848e-15
R341_425	341	425	2.8035449712110571e+04
C341_425	341	425	2.5265691566703070e-15
R341_430	341	430	1.5500781159944805e+04
C341_430	341	430	4.5696730897046112e-15
R341_432	341	432	3.8124165892188081e+04
C341_432	341	432	1.8579685844488027e-15
R341_435	341	435	2.2664444851153461e+04
C341_435	341	435	3.1253138120607922e-15
R342_343	342	343	2.0424592987978835e+04
C342_343	342	343	3.4680496486608085e-15
R342_344	342	344	1.2367902304135023e+04
C342_344	342	344	5.7272042416051344e-15
R342_345	342	345	3.3794083479036330e+04
C342_345	342	345	2.0960326555368946e-15
R342_349	342	349	4.5841067235688803e+04
C342_349	342	349	1.5451975010052506e-15
R342_425	342	425	3.5696142439543881e+04
C342_425	342	425	1.9843461420506679e-15
R342_435	342	435	1.7884496642355462e+04
C342_435	342	435	3.9606092333762738e-15
R342_436	342	436	1.8549472548610487e+04
C342_436	342	436	3.8186262358875563e-15
R343_349	343	349	7.0148851732412979e+04
C343_349	343	349	1.0097599716414271e-15
R343_425	343	425	9.0516705179089040e+04
C343_425	343	425	7.8254618742313434e-16
R343_436	343	436	1.2806155967472833e+05
C343_436	343	436	5.5312072347013825e-16
R344_345	344	345	5.5535289542750952e+03
C344_345	344	345	1.2754683214800295e-14
R344_349	344	349	1.2062876082641291e+04
C344_349	344	349	5.8720243871136805e-15
R344_351	344	351	8.8285498326417382e+03
C344_351	344	351	8.0232318873149215e-15
R344_435	344	435	2.0919664264310250e+04
C344_435	344	435	3.3859770233906038e-15
R344_436	344	436	2.5324401770198721e+04
C344_436	344	436	2.7970454417349966e-15
R345_346	345	346	1.1339115746477109e+04
C345_346	345	346	6.2468277174088201e-15
R345_351	345	351	1.5990219878874925e+04
C345_351	345	351	4.4298016582986392e-15
R345_352	345	352	2.3331295351448163e+04
C345_352	345	352	3.0359867066533622e-15
R345_388	345	388	2.3798417993626430e+04
C345_388	345	388	2.9763954290982815e-15
R345_431	345	431	1.4185758525154733e+04
C345_431	345	431	4.9932826933713360e-15
R345_432	345	432	8.5638943312334504e+03
C345_432	345	432	8.2711789515737647e-15
R345_435	345	435	9.1506387094632282e+03
C345_435	345	435	7.7408260543328847e-15
R345_437	345	437	8.3781656596014091e+03
C345_437	345	437	8.4545359227678371e-15
R346_347	346	347	1.0493222902379124e+04
C346_347	346	347	6.7504048274758322e-15
R346_348	346	348	2.3026661774450735e+04
C346_348	346	348	3.0761516032946395e-15
R346_352	346	352	5.1663638427212127e+03
C346_352	346	352	1.3710513756361917e-14
R346_431	346	431	1.5869750421380779e+04
C346_431	346	431	4.4634288917718852e-15
R346_437	346	437	1.9454944840046166e+04
C346_437	346	437	3.6408996848038321e-15
R347_348	347	348	1.2599117077966481e+04
C347_348	347	348	5.6221005089217458e-15
R347_352	347	352	3.6652857990236305e+04
C347_352	347	352	1.9325505955052355e-15
R347_423	347	423	1.9026253100388760e+04
C347_423	347	423	3.7229349447975489e-15
R347_429	347	429	1.7535515940488975e+04
C347_429	347	429	4.0394307630520067e-15
R347_431	347	431	5.9364214536514783e+03
C347_431	347	431	1.1932020509162216e-14
R347_433	347	433	8.6472484829345703e+03
C347_433	347	433	8.1914498786279360e-15
R347_434	347	434	1.8352580918350821e+04
C347_434	347	434	3.8595935280782940e-15
R347_437	347	437	1.4969139861914338e+04
C347_437	347	437	4.7319687830708403e-15
R348_352	348	352	1.0979105089750248e+04
C348_352	348	352	6.4516644987876079e-15
R348_353	348	353	2.2889720547623216e+04
C348_353	348	353	3.0945551470856686e-15
R348_433	348	433	2.3736826835872431e+04
C348_433	348	433	2.9841184344384402e-15
R348_437	348	437	3.0340174541136690e+04
C348_437	348	437	2.3346438709494064e-15
R348_438	348	438	1.9366890893303713e+04
C348_438	348	438	3.6574534821431431e-15
R349_351	349	351	9.7344176796549164e+03
C349_351	349	351	7.2766039908111959e-15
R349_350	349	350	4.8406350861900508e+04
C349_350	349	350	1.4633101085864207e-15
R349_436	349	436	2.4516606907135039e+04
C349_436	349	436	2.8892049705045199e-15
R349_439	349	439	4.8004473871351867e+04
C349_439	349	439	1.4755604389255071e-15
R350_351	350	351	1.0430540240232256e+04
C350_351	350	351	6.7909715992258881e-15
R350_352	350	352	2.1463772106020857e+04
C350_352	350	352	3.3001423135745248e-15
R350_353	350	353	2.2789572663656785e+04
C350_353	350	353	3.1081540484065470e-15
R350_354	350	354	2.8275228175438227e+04
C350_354	350	354	2.5051434455807776e-15
R350_439	350	439	4.0948703299643872e+04
C350_439	350	439	1.7298106369247603e-15
R350_440	350	440	1.7741996625793512e+04
C350_440	350	440	3.9924200206994446e-15
R351_352	351	352	6.6311210483683572e+03
C351_352	351	352	1.0681980018058812e-14
R351_435	351	435	2.7880740542738644e+04
C351_435	351	435	2.5405889928719317e-15
R351_436	351	436	3.4200298107650931e+04
C351_436	351	436	2.0711369916437618e-15
R351_437	351	437	1.5559624424416346e+04
C351_437	351	437	4.5523915361894740e-15
R351_438	351	438	3.9418846028728127e+04
C351_438	351	438	1.7969451080424103e-15
R351_439	351	439	6.9714716018228091e+03
C351_439	351	439	1.0160480682081439e-14
R351_440	351	440	4.1394459559350384e+04
C351_440	351	440	1.7111831701641286e-15
R352_353	352	353	2.0696601255342517e+04
C352_353	352	353	3.4224702723938983e-15
R352_437	352	437	1.1195167026103029e+04
C352_437	352	437	6.3271501328066159e-15
R352_438	352	438	1.7603711025418368e+04
C352_438	352	438	4.0237823964345945e-15
R352_440	352	440	4.2613033448751390e+04
C352_440	352	440	1.6622497110229901e-15
R353_354	353	354	5.8942895431724668e+04
C353_354	353	354	1.2017309637944167e-15
R353_438	353	438	9.3005751972253027e+04
C353_438	353	438	7.6160346036589435e-16
R353_440	353	440	5.1616228150161129e+04
C353_440	353	440	1.3723107068174816e-15
R354_440	354	440	1.4044161139852574e+05
C354_440	354	440	5.0436264459397654e-16
R355_358	355	358	1.0683724539849780e+04
C355_358	355	358	6.6300382672535637e-15
R355_359	355	359	2.9059413883498419e+04
C355_359	355	359	2.4375406475841991e-15
R355_363	355	363	2.8321066511338915e+04
C355_363	355	363	2.5010888099019990e-15
R355_365	355	365	5.4871435893795475e+04
C355_365	355	365	1.2908993792890599e-15
R355_441	355	441	5.1809328731466267e+04
C355_441	355	441	1.3671959137540314e-15
R356_358	356	358	4.1002872856816779e+04
C356_358	356	358	1.7275253561708387e-15
R356_360	356	360	2.0875957826957383e+04
C356_360	356	360	3.3930659911820588e-15
R356_362	356	362	1.6685304457959697e+04
C356_362	356	362	4.2452628128226336e-15
R356_383	356	383	2.0501579785938673e+04
C356_383	356	383	3.4550265528601981e-15
R356_384	356	384	2.7422709145613033e+04
C356_384	356	384	2.5830235138285617e-15
R356_391	356	391	2.2042189249422154e+04
C356_391	356	391	3.2135420730886312e-15
R356_394	356	394	2.0161030209660326e+04
C356_394	356	394	3.5133870541029963e-15
R356_442	356	442	2.1539410799958667e+04
C356_442	356	442	3.2885533960908502e-15
R357_359	357	359	6.2713704275162208e+03
C357_359	357	359	1.1294740655919705e-14
R357_358	357	358	1.8453956700327428e+04
C357_358	357	358	3.8383910662770343e-15
R357_361	357	361	7.5232721176438326e+03
C357_361	357	361	9.4152519579717019e-15
R357_398	357	398	1.2592000996325993e+04
C357_398	357	398	5.6252777105614372e-15
R357_399	357	399	1.3118908533335272e+04
C357_399	357	399	5.3993441875146392e-15
R357_402	357	402	1.2215160011890594e+04
C357_402	357	402	5.7988190467458951e-15
R357_443	357	443	1.3461721326081055e+04
C357_443	357	443	5.2618458531573906e-15
R358_359	358	359	1.7265520283057540e+04
C358_359	358	359	4.1025987850194197e-15
R358_360	358	360	1.0624919238816919e+04
C358_360	358	360	6.6667332658132536e-15
R358_361	358	361	9.5024628522627754e+03
C358_361	358	361	7.4542256715197536e-15
R358_362	358	362	1.2120327411142751e+04
C358_362	358	362	5.8441905183914131e-15
R358_363	358	363	3.0493934157939239e+04
C358_363	358	363	2.3228718921319686e-15
R358_441	358	441	1.8566457401422223e+04
C358_441	358	441	3.8151329036294248e-15
R358_443	358	443	1.7098360454812700e+04
C358_443	358	443	4.1427072919182955e-15
R359_365	359	365	8.6556509911093726e+03
C359_365	359	365	8.1834979955587929e-15
R359_364	359	364	3.1458461267918556e+04
C359_364	359	364	2.2516518507609351e-15
R359_367	359	367	2.1893621812598318e+04
C359_367	359	367	3.2353487761097650e-15
R359_372	359	372	1.8280493396746904e+04
C359_372	359	372	3.8748134964784465e-15
R359_398	359	398	9.7274274182983572e+03
C359_398	359	398	7.2818330571919199e-15
R359_441	359	441	1.1272809276211328e+04
C359_441	359	441	6.2835714505946491e-15
R359_443	359	443	1.7204450890740110e+04
C359_443	359	443	4.1171614825628913e-15
R360_361	360	361	3.2627453260658381e+03
C360_361	360	361	2.1709785918660663e-14
R360_362	360	362	8.0741512188052366e+03
C360_362	360	362	8.7728729146196882e-15
R360_383	360	383	6.0794917913973295e+03
C360_383	360	383	1.1651221017558015e-14
R360_385	360	385	2.3583835632885737e+04
C360_385	360	385	3.0034767727616137e-15
R360_402	360	402	9.1101548923331666e+03
C360_402	360	402	7.7752248313155858e-15
R360_407	360	407	2.3934502780344119e+04
C360_407	360	407	2.9594724898221425e-15
R360_442	360	442	5.1781822598372191e+03
C360_442	360	442	1.3679221584260481e-14
R360_443	360	443	5.3228220469893067e+03
C360_443	360	443	1.3307509045143606e-14
R361_383	361	383	2.5673858867403655e+04
C361_383	361	383	2.7589737445325164e-15
R361_402	361	402	4.5233414365890007e+04
C361_402	361	402	1.5659552463369808e-15
R361_443	361	443	3.3610701891731740e+04
C361_443	361	443	2.1074687093465646e-15
R362_363	362	363	6.1462477793297301e+04
C362_363	362	363	1.1524674090461848e-15
R362_393	362	393	5.8911836623010808e+04
C362_393	362	393	1.2023645263222475e-15
R362_394	362	394	3.7225203358489300e+04
C362_394	362	394	1.9028372217030821e-15
R362_441	362	441	2.7176349057248572e+04
C362_441	362	441	2.6064392382797665e-15
R362_442	362	442	2.6939199090351543e+04
C362_442	362	442	2.6293841289947445e-15
R362_443	362	443	4.0483691192905753e+04
C362_443	362	443	1.7496799439180750e-15
R362_444	362	444	2.4006542324458231e+04
C362_444	362	444	2.9505916170124080e-15
R363_393	363	393	2.1151577215204827e+04
C363_393	363	393	3.3488520414014942e-15
R363_366	363	366	2.9333670024205552e+04
C363_366	363	366	2.4147507787995721e-15
R363_441	363	441	1.0695459523578365e+04
C363_441	363	441	6.6227638354243753e-15
R363_365	363	365	5.6430407462747091e+04
C363_365	363	365	1.2552364181095308e-15
R363_371	363	371	3.1639137386174742e+04
C363_371	363	371	2.2387937342107158e-15
R363_445	363	445	3.2450510233271798e+04
C363_445	363	445	2.1828162955469888e-15
R364_365	364	365	2.9068884834040146e+04
C364_365	364	365	2.4367464710257068e-15
R364_367	364	367	7.3965013246083581e+03
C364_367	364	367	9.5766227067836856e-15
R364_372	364	372	1.4248493648082795e+04
C364_372	364	372	4.9712976182244380e-15
R364_370	364	370	4.6503322369728230e+04
C364_370	364	370	1.5231922995271785e-15
R364_377	364	377	1.8335733911627856e+04
C364_377	364	377	3.8631397509035620e-15
R364_446	364	446	2.9286908075058906e+04
C364_446	364	446	2.4186063736896385e-15
R365_372	365	372	1.5813704165491974e+04
C365_372	365	372	4.4792479860961364e-15
R365_441	365	441	1.5580768787384593e+04
C365_441	365	441	4.5462135728085731e-15
R365_371	365	371	2.7154623079474448e+04
C365_371	365	371	2.6085246084502429e-15
R365_446	365	446	6.6815885727507164e+04
C365_446	365	446	1.0601296647458619e-15
R366_393	366	393	9.4186686188875701e+03
C366_393	366	393	7.5205430196318031e-15
R366_392	366	392	9.0132880943393466e+04
C366_392	366	392	7.8587860273195826e-16
R366_371	366	371	5.6790582898220455e+04
C366_371	366	371	1.2472754974701904e-15
R366_445	366	445	4.2262526466514741e+04
C366_445	366	445	1.6760356859432555e-15
R366_450	366	450	3.3155727269344854e+04
C366_450	366	450	2.1363881407448818e-15
R366_451	366	451	5.1088431814224146e+04
C366_451	366	451	1.3864880956529653e-15
R366_453	366	453	3.6202125054983277e+04
C366_453	366	453	1.9566117300688590e-15
R366_454	366	454	5.5071816220297776e+04
C366_454	366	454	1.2862024061936231e-15
R367_368	367	368	1.7107199205263612e+04
C367_368	367	368	4.1405668856773269e-15
R367_372	367	372	2.0528639046316370e+04
C367_372	367	372	3.4504724047311000e-15
R367_376	367	376	8.1151641427019626e+04
C367_376	367	376	8.7285360210121190e-16
R367_377	367	377	1.5667639536144947e+04
C367_377	367	377	4.5210066502097174e-15
R367_397	367	397	2.4404333412852215e+04
C367_397	367	397	2.9024969187929749e-15
R367_398	367	398	3.4746472266517259e+04
C367_398	367	398	2.0385811253782240e-15
R367_455	367	455	6.0359738141193287e+04
C367_455	367	455	1.1735223630411804e-15
R368_376	368	376	6.0976639788808032e+04
C368_376	368	376	1.1616498183784991e-15
R368_396	368	396	7.5020452396314897e+04
C368_396	368	396	9.4418922138463983e-16
R368_369	368	369	2.7068422503458205e+04
C368_369	368	369	2.6168315692187256e-15
R368_397	368	397	5.8322936804219760e+04
C368_397	368	397	1.2145050715428837e-15
R368_455	368	455	5.4746176496515785e+04
C368_455	368	455	1.2938529604986766e-15
R369_396	369	396	2.6998960779808764e+04
C369_396	369	396	2.6235640369155622e-15
R369_397	369	397	3.0824291803728720e+04
C369_397	369	397	2.2979766408593205e-15
R369_400	369	400	1.0175381929044592e+04
C369_400	369	400	6.9612622926529166e-15
R369_401	369	401	5.1203281119466199e+04
C369_401	369	401	1.3833781934937544e-15
R369_455	369	455	1.2441333033505480e+04
C369_455	369	455	5.6934013698724936e-15
R369_376	369	376	6.2395949068691953e+04
C369_376	369	376	1.1352259817062663e-15
R369_456	369	456	2.5338699007394403e+04
C369_456	369	456	2.7954672225014079e-15
R370_375	370	375	4.8573405309218768e+04
C370_375	370	375	1.4582774686080427e-15
R370_374	370	374	9.4938059299345259e+03
C370_374	370	374	7.4610228035795252e-15
R370_376	370	376	4.1520821519807228e+04
C370_376	370	376	1.7059754586553485e-15
R370_377	370	377	1.4071319832828804e+04
C370_377	370	377	5.0338918720860400e-15
R370_379	370	379	4.7130890885701840e+04
C370_379	370	379	1.5029103249454778e-15
R370_446	370	446	4.6507526327446983e+04
C370_446	370	446	1.5230546135109479e-15
R370_458	370	458	3.7134613173511563e+04
C370_458	370	458	1.9074792082801646e-15
R371_441	371	441	2.5482651308539676e+04
C371_441	371	441	2.7796755399726583e-15
R371_372	371	372	4.9805331055083960e+04
C371_372	371	372	1.4222072423865468e-15
R371_445	371	445	1.7147859257980457e+04
C371_445	371	445	4.1307490031465442e-15
R371_446	371	446	6.2678397859000659e+04
C371_446	371	446	1.1301102924702192e-15
R371_450	371	450	2.4996550421119740e+04
C371_450	371	450	2.8337311085993832e-15
R371_451	371	451	7.6549475176830441e+04
C371_451	371	451	9.2532969523792996e-16
R371_452	371	452	3.6069086192163937e+04
C371_452	371	452	1.9638285860257997e-15
R371_459	371	459	1.8861172847424208e+04
C371_459	371	459	3.7555195060774523e-15
R372_377	372	377	1.5455810899546841e+04
C372_377	372	377	4.5829690202845869e-15
R372_397	372	397	2.8132179028706814e+04
C372_397	372	397	2.5178818343122181e-15
R372_398	372	398	1.4520842163124282e+04
C372_398	372	398	4.8780574666586415e-15
R372_441	372	441	2.2396971515931797e+04
C372_441	372	441	3.1626375238104637e-15
R372_446	372	446	1.2100701802603600e+04
C372_446	372	446	5.8536689599903551e-15
R372_458	372	458	3.0639294107186230e+04
C372_458	372	458	2.3118516467187969e-15
R372_459	372	459	1.4360790833717736e+04
C372_459	372	459	4.9324235243152395e-15
R372_460	372	460	1.4178249910860393e+04
C372_460	372	460	4.9959270700781127e-15
R372_461	372	461	1.5170635639167440e+04
C372_461	372	461	4.6691189624990134e-15
R373_375	373	375	3.2319536432529916e+04
C373_375	373	375	2.1916620828974958e-15
R373_374	373	374	3.4898308166669412e+04
C373_374	373	374	2.0297116466995808e-15
R373_376	373	376	4.2525880341347460e+04
C373_376	373	376	1.6656563477918020e-15
R373_382	373	382	3.7221027151611008e+04
C373_382	373	382	1.9030507204295189e-15
R373_378	373	378	2.7708720528581431e+04
C373_378	373	378	2.5563613615047847e-15
R373_462	373	462	1.3433513878803380e+04
C373_462	373	462	5.2728945810498283e-15
R373_457	373	457	4.8688479688180814e+04
C373_457	373	457	1.4548308550532728e-15
R374_375	374	375	1.2467137632821539e+04
C374_375	374	375	5.6816171139011569e-15
R374_376	374	376	1.9566077815346063e+04
C374_376	374	376	3.6202198112717246e-15
R374_377	374	377	2.2468298184039453e+04
C374_377	374	377	3.1525975824157962e-15
R374_379	374	379	3.6316389326568424e+04
C374_379	374	379	1.9504555339751101e-15
R374_380	374	380	1.0766398143462302e+04
C374_380	374	380	6.5791271688212980e-15
R374_458	374	458	2.5793665378663438e+04
C374_458	374	458	2.7461588531963199e-15
R374_462	374	462	1.3080851459044279e+04
C374_462	374	462	5.4150528929846345e-15
R374_463	374	463	1.0954248174612787e+04
C374_463	374	463	6.4663043421055094e-15
R375_379	375	379	3.7414348753239719e+04
C375_379	375	379	1.8932175728400595e-15
R375_380	375	380	2.0402644327477607e+04
C375_380	375	380	3.4717804907574545e-15
R375_381	375	381	2.2105820069303471e+04
C375_381	375	381	3.2042920060839835e-15
R375_382	375	382	3.1185974000529313e+04
C375_382	375	382	2.2713256457790208e-15
R375_462	375	462	2.9815956637139418e+04
C375_462	375	462	2.3756910904467918e-15
R375_464	375	464	4.4937556743877540e+04
C375_464	375	464	1.5762651035906755e-15
R376_377	376	377	2.1066302166548234e+04
C376_377	376	377	3.3624079810493981e-15
R376_455	376	455	1.4312926374715635e+04
C376_455	376	455	4.9489182492498717e-15
R376_456	376	456	4.4442124691803088e+04
C376_456	376	456	1.5938369964806058e-15
R376_462	376	462	2.4354519898135808e+04
C376_462	376	462	2.9084335405610647e-15
R376_457	376	457	4.2187310678016278e+04
C376_457	376	457	1.6790238912505793e-15
R376_463	376	463	2.6684454842652780e+04
C376_463	376	463	2.6544856529269925e-15
R376_465	376	465	2.6620957800636970e+04
C376_465	376	465	2.6608172052436506e-15
R377_397	377	397	4.2702177362682938e+04
C377_397	377	397	1.6587796433514134e-15
R377_446	377	446	4.8631477550143063e+04
C377_446	377	446	1.4565360976944370e-15
R377_455	377	455	2.3685923827681454e+04
C377_455	377	455	2.9905315516221396e-15
R377_458	377	458	1.3623818748865224e+04
C377_458	377	458	5.1992399371798740e-15
R377_460	377	460	2.1267751453193316e+04
C377_460	377	460	3.3305590716485674e-15
R377_463	377	463	2.3086083125825793e+04
C377_463	377	463	3.0682338857543331e-15
R377_466	377	466	3.8635305452948865e+04
C377_466	377	466	1.8333879260321361e-15
R378_382	378	382	2.1646208497626019e+04
C378_382	378	382	3.2723283869213606e-15
R378_462	378	462	3.2478177716092803e+04
C378_462	378	462	2.1809567998300072e-15
R378_457	378	457	3.4969734633804001e+04
C378_457	378	457	2.0255659151478888e-15
R378_470	378	470	3.5792029804517013e+04
C378_470	378	470	1.9790300500660818e-15
R378_469	378	469	1.3044267435400923e+05
C378_469	378	469	5.4302399798830033e-16
R379_380	379	380	1.1911704713191442e+04
C379_380	379	380	5.9465462116061771e-15
R379_381	379	381	5.1073200188103372e+04
C379_381	379	381	1.3869015897793586e-15
R379_458	379	458	1.9466402789432825e+04
C379_458	379	458	3.6387566466286931e-15
R379_447	379	447	4.1051132484785136e+04
C379_447	379	447	1.7254944808709763e-15
R379_446	379	446	9.0645004887985837e+04
C379_446	379	446	7.8143856491079896e-16
R379_475	379	475	1.1852749046769808e+04
C379_475	379	475	5.9761243789519058e-15
R379_471	379	471	6.9027230197263547e+04
C379_471	379	471	1.0261675332122490e-15
R379_472	379	472	7.4904710539279651e+04
C379_472	379	472	9.4564817120353572e-16
R380_381	380	381	5.6705022343037213e+04
C380_381	380	381	1.2491574751085098e-15
R380_458	380	458	2.3035355409528882e+04
C380_458	380	458	3.0749906514009674e-15
R380_462	380	462	2.7717067933379603e+04
C380_462	380	462	2.5555914754855935e-15
R380_463	380	463	1.5887316350974032e+04
C380_463	380	463	4.4584938683906359e-15
R380_464	380	464	1.3071959760117119e+04
C380_464	380	464	5.4187362748862518e-15
R380_474	380	474	3.1409165670028815e+04
C380_474	380	474	2.2551857403710216e-15
R380_475	380	475	1.8417170472531539e+04
C380_475	380	475	3.8460578209690403e-15
R381_382	381	382	4.8759762129620525e+04
C381_382	381	382	1.4527040215598210e-15
R381_464	381	464	4.7274353788767592e+04
C381_464	381	464	1.4983494613696884e-15
R381_475	381	475	6.6576703576424465e+04
C381_475	381	475	1.0639382656530765e-15
R381_472	381	472	9.9808783479053600e+04
C381_472	381	472	7.0969207385305405e-16
R381_476	381	476	8.1350159560319211e+04
C381_476	381	476	8.7072358454907076e-16
R382_462	382	462	3.0299479696041908e+04
C382_462	382	462	2.3377795013837527e-15
R382_464	382	464	1.6999436873501840e+04
C382_464	382	464	4.1668146458670602e-15
R382_470	382	470	4.1573498601860098e+04
C382_470	382	470	1.7038138457952815e-15
R382_476	382	476	8.9415596470976903e+04
C382_476	382	476	7.9218285547076346e-16
R383_384	383	384	2.2866266448753999e+04
C383_384	383	384	3.0977292552217158e-15
R383_385	383	385	2.0460688990014940e+04
C383_385	383	385	3.4619314418281615e-15
R383_386	383	386	3.6182473642347170e+04
C383_386	383	386	1.9576744043585249e-15
R383_391	383	391	5.7901679651715152e+04
C383_391	383	391	1.2233410664780568e-15
R383_407	383	407	6.7801914587681502e+04
C383_407	383	407	1.0447124239301243e-15
R383_442	383	442	4.5596517241107016e+04
C383_442	383	442	1.5534849331023218e-15
R383_481	383	481	3.9772255355196532e+04
C383_481	383	481	1.7809777671244158e-15
R384_386	384	386	2.1056666937336908e+04
C384_386	384	386	3.3639465707842224e-15
R384_391	384	391	1.1031899518519027e+04
C384_391	384	391	6.4207893134897779e-15
R384_421	384	421	3.1985787270277026e+04
C384_421	384	421	2.2145305331228302e-15
R384_424	384	424	2.6403396855267580e+04
C384_424	384	424	2.6827420321816835e-15
R384_481	384	481	4.2619112284612325e+04
C384_481	384	481	1.6620126215433757e-15
R385_386	385	386	7.3988488296213662e+04
C385_386	385	386	9.5735842381881562e-16
R385_387	385	387	1.7721804466359376e+04
C385_387	385	387	3.9969689695234216e-15
R385_402	385	402	9.5391922989406492e+04
C385_402	385	402	7.4255241236583780e-16
R385_405	385	405	7.2722571496045304e+04
C385_405	385	405	9.7402362263622616e-16
R385_407	385	407	2.4221874065066277e+04
C385_407	385	407	2.9243609452234258e-15
R385_481	385	481	9.7138629104562511e+04
C385_481	385	481	7.2920014611028738e-16
R386_387	386	387	2.5511741912106376e+04
C386_387	386	387	2.7765059234307551e-15
R386_388	386	388	4.1743321562353420e+04
C386_388	386	388	1.6968822768498095e-15
R386_389	386	389	5.0969841147623294e+04
C386_389	386	389	1.3897140140351986e-15
R386_390	386	390	2.5991571525792697e+04
C386_390	386	390	2.7252489317819236e-15
R386_424	386	424	4.7741276050531917e+04
C386_424	386	424	1.4836952087544968e-15
R386_481	386	481	2.3673955217636307e+04
C386_481	386	481	2.9920434454159740e-15
R386_482	386	482	2.3139346594309041e+04
C386_482	386	482	3.0611712499012837e-15
R387_389	387	389	2.1422355121920165e+04
C387_389	387	389	3.3065226550894247e-15
R387_404	387	404	1.5609153705765000e+04
C387_404	387	404	4.5379463788506835e-15
R387_405	387	405	2.9548108501716782e+04
C387_405	387	405	2.3972262905385127e-15
R387_407	387	407	2.9903708282332216e+04
C387_407	387	407	2.3687196874459224e-15
R387_416	387	416	3.6088758716134333e+04
C387_416	387	416	1.9627580735918256e-15
R387_417	387	417	9.5957786395990170e+03
C387_417	387	417	7.3817357815748810e-15
R387_481	387	481	3.8277225913230577e+04
C387_481	387	481	1.8505390828627506e-15
R387_482	387	482	4.3367413778925518e+04
C387_482	387	482	1.6333347175620995e-15
R388_390	388	390	1.6165253545821472e+04
C388_390	388	390	4.3818367794366973e-15
R388_423	388	423	3.5735947230636702e+04
C388_423	388	423	1.9821358610937811e-15
R388_424	388	424	3.9653319677899919e+04
C388_424	388	424	1.7863196098428505e-15
R388_430	388	430	3.2372872774047399e+04
C388_430	388	430	2.1880511819385282e-15
R388_432	388	432	1.4105876754513398e+04
C388_432	388	432	5.0215597207267321e-15
R388_482	388	482	1.9612094399489204e+04
C388_482	388	482	3.6117255553208463e-15
R389_390	389	390	7.8944613200349168e+03
C389_390	389	390	8.9725567919669921e-15
R389_404	389	404	3.2889114404127300e+04
C389_404	389	404	2.1537065931793842e-15
R389_416	389	416	2.0629974459261863e+04
C389_416	389	416	3.4335235206362163e-15
R389_423	389	423	1.5765405694808027e+04
C389_423	389	423	4.4929704891341550e-15
R389_427	389	427	1.7875443850169100e+04
C389_427	389	427	3.9626150337704717e-15
R389_482	389	482	1.3445998730793377e+04
C389_482	389	482	5.2679986034641319e-15
R390_423	390	423	2.3684245718723123e+04
C390_423	390	423	2.9907434409027408e-15
R390_482	390	482	3.6691196572865178e+04
C390_482	390	482	1.9305312759514806e-15
R391_394	391	394	3.4344885797001167e+04
C391_394	391	394	2.0624177630017003e-15
R391_420	391	420	3.0886605716855087e+04
C391_420	391	420	2.2933404591410171e-15
R391_421	391	421	6.3401758743748585e+04
C391_421	391	421	1.1172166819896648e-15
R391_424	391	424	4.4225432545894495e+04
C391_424	391	424	1.6016463482294551e-15
R391_442	391	442	2.1039283853800214e+04
C391_442	391	442	3.3667259317481822e-15
R391_448	391	448	3.4490404153324234e+04
C391_448	391	448	2.0537162226663263e-15
R391_481	391	481	3.4652091128163709e+04
C391_481	391	481	2.0441335639461490e-15
R391_484	391	484	3.8335586552577137e+04
C391_484	391	484	1.8477218925254238e-15
R392_393	392	393	5.4385449225605778e+04
C392_393	392	393	1.3024348156464274e-15
R392_414	392	414	6.2686771361617604e+04
C392_414	392	414	1.1299593358762541e-15
R392_415	392	415	5.6308599913463571e+04
C392_415	392	415	1.2579517630496703e-15
R392_454	392	454	9.6678227716644236e+04
C392_454	392	454	7.3267274554936040e-16
R392_485	392	485	6.1755896857498068e+04
C392_485	392	485	1.1469917229029730e-15
R393_394	393	394	2.3850656743710104e+04
C393_394	393	394	2.9698763978346308e-15
R393_415	393	415	1.0746529225513326e+04
C393_415	393	415	6.5912911089316390e-15
R393_441	393	441	4.3763711019855051e+04
C393_441	393	441	1.6185442432855780e-15
R393_444	393	444	1.0423579012178965e+04
C393_444	393	444	6.7955068458959997e-15
R393_445	393	445	1.2973368033177410e+04
C393_445	393	445	5.4599162187378112e-15
R393_449	393	449	7.2635665448562613e+03
C393_449	393	449	9.7518900802473110e-15
R393_450	393	450	2.3741550348772827e+04
C393_450	393	450	2.9835247275526517e-15
R393_453	393	453	1.9341157112452365e+04
C393_453	393	453	3.6623197942172480e-15
R393_454	393	454	4.7077474827039427e+04
C393_454	393	454	1.5046155894350574e-15
R393_485	393	485	1.8458747972017096e+04
C393_485	393	485	3.8373947487327665e-15
R393_486	393	486	2.0529237998406094e+04
C393_486	393	486	3.4503717352538647e-15
R394_414	394	414	3.4461197307703238e+04
C394_414	394	414	2.0554568056219666e-15
R394_415	394	415	8.7582009382697415e+03
C394_415	394	415	8.0876772564656162e-15
R394_420	394	420	1.7664382235320427e+04
C394_420	394	420	4.0099620576804797e-15
R394_442	394	442	2.5137222459899716e+04
C394_442	394	442	2.8178730823979261e-15
R394_444	394	444	1.5633549955360444e+04
C394_444	394	444	4.5308648859827617e-15
R394_448	394	448	2.7542736177144445e+04
C394_448	394	448	2.5717670924350347e-15
R394_486	394	486	2.8513429026424605e+04
C394_486	394	486	2.4842155066777691e-15
R395_396	395	396	9.2448772539737809e+04
C395_396	395	396	7.6619192002309388e-16
R395_399	395	399	6.9521133060725551e+04
C395_399	395	399	1.0188772739668687e-15
R395_403	395	403	4.5177129715591705e+04
C395_403	395	403	1.5679062167500577e-15
R395_405	395	405	5.7514913270191137e+04
C395_405	395	405	1.2315675797552082e-15
R395_406	395	406	7.6523168898404212e+04
C395_406	395	406	9.2564779472269268e-16
R395_408	395	408	4.1370241303472721e+04
C395_408	395	408	1.7121849016155982e-15
R395_409	395	409	8.7276594400516886e+04
C395_409	395	409	8.1159792063999811e-16
R395_487	395	487	3.2581357968040018e+04
C395_487	395	487	2.1740500382299167e-15
R395_401	395	401	1.6700660083007306e+05
C395_401	395	401	4.2413594542931947e-16
R396_399	396	399	1.6729859792251362e+04
C396_399	396	399	4.2339567345810869e-15
R396_400	396	400	1.7571712641211889e+04
C396_400	396	400	4.0311097718426349e-15
R396_401	396	401	5.3215190121176594e+04
C396_401	396	401	1.3310767541129639e-15
R396_487	396	487	5.4783433414581144e+04
C396_487	396	487	1.2929730416850247e-15
R397_398	397	398	2.3780826526453824e+04
C397_398	397	398	2.9785971676470011e-15
R397_399	397	399	5.6581249572602617e+04
C397_399	397	399	1.2518900354985888e-15
R397_400	397	400	1.8430715509299178e+04
C397_400	397	400	3.8432312896512964e-15
R397_455	397	455	1.7940170717229277e+04
C397_455	397	455	3.9483181989998212e-15
R397_460	397	460	3.6526912727537747e+04
C397_460	397	460	1.9392140546988641e-15
R397_461	397	461	3.4551202873148177e+04
C397_461	397	461	2.0501023595635504e-15
R397_488	397	488	3.5512904207269974e+04
C397_488	397	488	1.9945849013807054e-15
R397_489	397	489	5.0411348636115239e+04
C397_489	397	489	1.4051102470457242e-15
R397_490	397	490	2.6641471774117545e+04
C397_490	397	490	2.6587683719791888e-15
R397_491	397	491	4.3713889868305683e+04
C397_491	397	491	1.6203889141276611e-15
R398_399	398	399	2.5575468033213296e+04
C398_399	398	399	2.7695877332142222e-15
R398_402	398	402	2.2714136524508198e+04
C398_402	398	402	3.1184765689671617e-15
R398_441	398	441	4.4355561696548255e+04
C398_441	398	441	1.5969474813687740e-15
R398_443	398	443	1.3030325517159181e+04
C398_443	398	443	5.4360501157643262e-15
R398_461	398	461	1.6858353048372595e+04
C398_461	398	461	4.2016857953296837e-15
R398_489	398	489	3.5358409348570181e+04
C398_489	398	489	2.0033000307708800e-15
R398_491	398	491	6.4367176971536239e+04
C398_491	398	491	1.1004599839344088e-15
R399_400	399	400	1.9274782062766913e+04
C399_400	399	400	3.6749314365960625e-15
R399_402	399	402	1.7604707391794440e+04
C399_402	399	402	4.0235546640789698e-15
R399_403	399	403	2.6309407668713073e+04
C399_403	399	403	2.6923260085492016e-15
R399_487	399	487	4.0663966208130289e+04
C399_487	399	487	1.7419231113230092e-15
R399_491	399	491	1.6147912384995745e+04
C399_491	399	491	4.3865424116257185e-15
R400_401	400	401	1.4135346254070115e+04
C400_401	400	401	5.0110907269501302e-15
R400_455	400	455	2.2243677013574725e+04
C400_455	400	455	3.1844331534202822e-15
R400_456	400	456	3.9787527706939538e+04
C400_456	400	456	1.7802941428714502e-15
R400_487	400	487	1.8488014925097472e+04
C400_487	400	487	3.8313200645377868e-15
R400_488	400	488	9.5253043899631684e+03
C400_488	400	488	7.4363505496619527e-15
R400_491	400	491	1.5443176169350139e+04
C400_491	400	491	4.5867185454105161e-15
R401_456	401	456	6.9067934976989272e+04
C401_456	401	456	1.0255627674346850e-15
R401_487	401	487	1.4868219013476664e+04
C401_487	401	487	4.7640879160978191e-15
R401_409	401	409	1.1882793512737633e+05
C401_409	401	409	5.9610143406153448e-16
R401_467	401	467	5.8400637689341354e+04
C401_467	401	467	1.2128891967377914e-15
R401_488	401	488	3.9563880767926988e+04
C401_488	401	488	1.7903578001231414e-15
R401_492	401	492	7.6864508379219405e+04
C401_492	401	492	9.2153718315005974e-16
R401_493	401	493	7.1120183576248572e+04
C401_493	401	493	9.9596906214476791e-16
R402_403	402	403	2.6073137740378934e+04
C402_403	402	403	2.7167233664516566e-15
R402_407	402	407	1.3661423096160715e+04
C402_407	402	407	5.1849285420276919e-15
R402_442	402	442	4.4107997395745071e+04
C402_442	402	442	1.6059106447401995e-15
R402_443	402	443	9.6301799247672770e+03
C402_443	402	443	7.3553664717963997e-15
R402_483	402	483	2.7429326721824062e+04
C402_483	402	483	2.5824003357560189e-15
R402_489	402	489	1.6176030290705407e+04
C402_489	402	489	4.3789175256861538e-15
R402_491	402	491	2.4755676850811651e+04
C402_491	402	491	2.8613034078152311e-15
R402_494	402	494	2.8056272651966316e+04
C402_494	402	494	2.5246939753786450e-15
R403_405	403	405	9.9249476452624294e+03
C403_405	403	405	7.1369144773082648e-15
R403_407	403	407	1.9253563331347352e+04
C403_407	403	407	3.6789814600538739e-15
R403_408	403	408	2.6751875542816397e+04
C403_408	403	408	2.6477957563248581e-15
R403_487	403	487	2.9193795085091620e+04
C403_487	403	487	2.4263204673986533e-15
R403_491	403	491	2.4106319864168054e+04
C403_491	403	491	2.9383789369395964e-15
R403_494	403	494	3.6366527887446260e+04
C403_494	403	494	1.9477664393815216e-15
R403_496	403	496	1.1092506718424176e+04
C403_496	403	496	6.3857074270100387e-15
R404_405	404	405	1.9873173766167332e+04
C404_405	404	405	3.5642773202430821e-15
R404_406	404	406	2.5571348068077099e+04
C404_406	404	406	2.7700339593917435e-15
R404_411	404	411	2.1027235230667877e+04
C404_411	404	411	3.3686550684842538e-15
R404_416	404	416	1.8724032605503660e+04
C404_416	404	416	3.7830260194686645e-15
R404_417	404	417	3.2715375716158331e+04
C404_417	404	417	2.1651440946470589e-15
R404_498	404	498	2.5714210999938761e+04
C404_498	404	498	2.7546442135116918e-15
R405_406	405	406	2.7010701808688831e+04
C405_406	405	406	2.6224236244470411e-15
R405_407	405	407	2.2508918173907263e+04
C405_407	405	407	3.1469083493364631e-15
R405_408	405	408	9.1404916837288201e+03
C405_408	405	408	7.7494192858456634e-15
R405_417	405	417	1.5513071606082254e+04
C405_417	405	417	4.5660527028205118e-15
R405_496	405	496	1.8462390260953434e+04
C405_496	405	496	3.8366377015552286e-15
R405_498	405	498	9.5066182240621638e+03
C405_498	405	498	7.4509674067602320e-15
R406_408	406	408	1.3196032056525772e+04
C406_408	406	408	5.3677880011644147e-15
R406_409	406	409	5.8124601185710395e+04
C406_409	406	409	1.2186492653890937e-15
R406_410	406	410	5.1404016516368742e+04
C406_410	406	410	1.3779760286522411e-15
R406_411	406	411	2.8414038635742738e+04
C406_411	406	411	2.4929051249651199e-15
R406_497	406	497	1.4912899264177584e+04
C406_497	406	497	4.7498143239088213e-15
R406_412	406	412	7.6309792569066791e+04
C406_412	406	412	9.2823607758977611e-16
R406_498	406	498	3.1774277211123914e+04
C406_498	406	498	2.2292718750248007e-15
R407_417	407	417	8.0697903763112226e+03
C407_417	407	417	8.7776136966247533e-15
R407_442	407	442	3.2303611466082526e+04
C407_442	407	442	2.1927425238621476e-15
R407_481	407	481	1.2764709439074197e+04
C407_481	407	481	5.5491668552337568e-15
R407_483	407	483	1.7532126300614858e+04
C407_483	407	483	4.0402117416594154e-15
R407_494	407	494	1.6157220382540640e+04
C407_494	407	494	4.3840153726282099e-15
R407_495	407	495	1.5005531410116813e+04
C407_495	407	495	4.7204927703022669e-15
R407_496	407	496	2.6299612934547418e+04
C407_496	407	496	2.6933287083838585e-15
R407_499	407	499	3.2138311389181730e+04
C407_499	407	499	2.2040206679882908e-15
R408_409	408	409	2.0338561628418942e+04
C408_409	408	409	3.4827193697426862e-15
R408_487	408	487	2.5643103126665479e+04
C408_487	408	487	2.7622827933933785e-15
R408_496	408	496	1.0008067059770950e+04
C408_496	408	496	7.0776406785608742e-15
R408_497	408	497	9.6575943580340863e+03
C408_497	408	497	7.3344872346055927e-15
R408_498	408	498	1.3755878819244912e+04
C408_498	408	498	5.1493258603660933e-15
R408_500	408	500	3.7168229718027767e+04
C408_500	408	500	1.9057540020972139e-15
R409_487	409	487	2.0374982143135341e+04
C409_487	409	487	3.4764939688482109e-15
R409_492	409	492	5.5511280075717194e+04
C409_492	409	492	1.2760199807927928e-15
R409_497	409	497	3.3023152528562860e+04
C409_497	409	497	2.1449648840986238e-15
R409_412	409	412	5.7457736662466807e+04
C409_412	409	412	1.2327931215270208e-15
R409_500	409	500	1.7284926731858006e+04
C409_500	409	500	4.0979926403417216e-15
R409_501	409	501	5.1421552640146489e+04
C409_501	409	501	1.3775061019977442e-15
R409_503	409	503	4.8630608899638493e+04
C409_503	409	503	1.4565621146587488e-15
R410_411	410	411	1.3249909009001065e+04
C410_411	410	411	5.3459614317261100e-15
R410_413	410	413	5.7774956209584350e+04
C410_413	410	413	1.2260243396644818e-15
R410_418	410	418	4.7471985800877352e+04
C410_418	410	418	1.4921116389171762e-15
R410_426	410	426	4.0038165568518823e+04
C410_426	410	426	1.7691495484422226e-15
R410_497	410	497	5.2636237017893785e+04
C410_497	410	497	1.3457174476952072e-15
R410_412	410	412	5.8741997550590771e+04
C410_412	410	412	1.2058408887950326e-15
R410_505	410	505	4.6487456316394331e+04
C410_505	410	505	1.5237121612743471e-15
R411_416	411	416	1.3242664716903591e+04
C411_416	411	416	5.3488858964755501e-15
R411_426	411	426	1.6232004796602580e+04
C411_426	411	426	4.3638172501541967e-15
R411_418	411	418	4.2851799192771614e+04
C411_418	411	418	1.6529878294573087e-15
R411_497	411	497	1.4339433265156245e+04
C411_497	411	497	4.9397700192322200e-15
R411_498	411	498	1.6402495403735735e+04
C411_498	411	498	4.3184589169198837e-15
R411_504	411	504	7.6958733809256637e+03
C411_504	411	504	9.2040888707397246e-15
R411_505	411	505	2.9618954284764270e+04
C411_505	411	505	2.3914923482776750e-15
R412_497	412	497	1.3511633776298038e+04
C412_497	412	497	5.2424084095777798e-15
R412_503	412	503	1.4333191905213005e+04
C412_503	412	503	4.9419210322745868e-15
R412_501	412	501	6.2040546298880327e+04
C412_501	412	501	1.1417291877921194e-15
R412_502	412	502	2.9211088769074569e+04
C412_502	412	502	2.4248840259247920e-15
R412_413	412	413	5.4543185326295941e+04
C412_413	412	413	1.2986682408123001e-15
R412_505	412	505	1.4111479534587241e+04
C412_505	412	505	5.0195659755156843e-15
R412_506	412	506	3.7027526105922501e+04
C412_506	412	506	1.9129958165006952e-15
R413_418	413	418	4.4155074899044674e+04
C413_418	413	418	1.6041984459986172e-15
R413_505	413	505	2.4808971352580076e+04
C413_505	413	505	2.8551567708845563e-15
R413_502	413	502	6.9769218960529208e+04
C413_502	413	502	1.0152543426933432e-15
R413_507	413	507	5.7538095540039947e+04
C413_507	413	507	1.2310713775138416e-15
R414_415	414	415	1.2544771606570024e+04
C414_415	414	415	5.6464561298910107e-15
R414_420	414	420	3.2842984172091492e+04
C414_420	414	420	2.1567316223411628e-15
R414_422	414	422	3.2510962549217104e+04
C414_422	414	422	2.1787574707690640e-15
R414_485	414	485	6.6500354286744070e+04
C414_485	414	485	1.0651597769024171e-15
R414_509	414	509	4.2781143268815264e+04
C414_509	414	509	1.6557178495889597e-15
R415_420	415	420	4.3456314585246393e+04
C415_420	415	420	1.6299933211558691e-15
R415_444	415	444	5.5481893445928406e+04
C415_444	415	444	1.2766958396081594e-15
R415_485	415	485	1.9666247995162073e+04
C415_485	415	485	3.6017801948508515e-15
R415_486	415	486	9.9823549990732772e+03
C415_486	415	486	7.0958709184932730e-15
R415_509	415	509	4.0835652552750471e+04
C415_509	415	509	1.7345995008773048e-15
R416_417	416	417	9.2115721970202048e+03
C416_417	416	417	7.6896213828637767e-15
R416_426	416	426	3.3699394821149392e+04
C416_426	416	426	2.1019220942076275e-15
R416_427	416	427	1.0347851799258646e+04
C416_427	416	427	6.8452374376945347e-15
R416_482	416	482	3.9598101299830727e+04
C416_482	416	482	1.7888105795694506e-15
R416_498	416	498	9.1763709252495737e+03
C416_498	416	498	7.7191193678860074e-15
R416_504	416	504	1.3019209557394555e+04
C416_504	416	504	5.4406914815937138e-15
R416_511	416	511	1.5868861653296726e+04
C416_511	416	511	4.4636788752446212e-15
R416_512	416	512	2.3525583546754144e+04
C416_512	416	512	3.0109137312248738e-15
R417_481	417	481	2.4977109180563173e+04
C417_481	417	481	2.8359367781088786e-15
R417_482	417	482	4.0237508808702391e+04
C417_482	417	482	1.7603848904453162e-15
R417_495	417	495	2.0934987449897595e+04
C417_495	417	495	3.3834986863747314e-15
R417_496	417	496	2.9127549227923311e+04
C417_496	417	496	2.4318387373317016e-15
R417_498	417	498	7.2954469031831622e+03
C417_498	417	498	9.7092753159636874e-15
R417_499	417	499	1.6496415007026219e+04
C417_499	417	499	4.2938724871937520e-15
R417_511	417	511	2.6598296708209480e+04
C417_511	417	511	2.6630841558413575e-15
R417_512	417	512	1.3165185198937266e+04
C417_512	417	512	5.3803650663203658e-15
R418_426	418	426	1.0935154287982485e+04
C418_426	418	426	6.4775951642350931e-15
R418_428	418	428	5.3182107582846504e+04
C418_428	418	428	1.3319047656329971e-15
R418_504	418	504	2.2152308636700240e+04
C418_504	418	504	3.1975675175746022e-15
R418_505	418	505	1.5721227039174200e+04
C418_505	418	505	4.5055963099761144e-15
R418_507	418	507	5.0575656414132063e+04
C418_507	418	507	1.4005453919567402e-15
R418_513	418	513	1.9007525587851098e+04
C418_513	418	513	3.7266030346040491e-15
R419_421	419	421	5.5930679953573053e+03
C419_421	419	421	1.2664516611419261e-14
R419_422	419	422	2.7525212215466283e+04
C419_422	419	422	2.5734044112546024e-15
R419_424	419	424	1.6129944523583901e+04
C419_424	419	424	4.3914287759907035e-15
R419_425	419	425	8.0134683966305338e+03
C419_425	419	425	8.8393064064224372e-15
R419_430	419	430	2.8989315067153671e+04
C419_430	419	430	2.4434348439041900e-15
R419_515	419	515	2.4804443246624927e+04
C419_515	419	515	2.8556779860655865e-15
R420_421	420	421	8.0422617132081095e+03
C420_421	420	421	8.8076594696821988e-15
R420_422	420	422	1.6434568531182395e+04
C420_422	420	422	4.3100311639823640e-15
R420_424	420	424	2.9086751473187378e+04
C420_424	420	424	2.4352496909562224e-15
R420_448	420	448	1.3695473775985380e+04
C420_448	420	448	5.1720373967788182e-15
R420_484	420	484	3.5709222124094369e+04
C420_484	420	484	1.9836193095958246e-15
R420_486	420	486	2.0424183919284907e+04
C420_486	420	486	3.4681191089900851e-15
R420_508	420	508	2.8058276411621137e+04
C420_508	420	508	2.5245136763519189e-15
R420_509	420	509	7.7882638115814916e+03
C420_509	420	509	9.0949028242555747e-15
R420_514	420	514	1.7886719746942043e+04
C420_514	420	514	3.9601169771841404e-15
R420_516	420	516	2.5796809090704894e+04
C420_516	420	516	2.7458241942614031e-15
R421_422	421	422	1.2152495357854072e+04
C421_422	421	422	5.8287208059059930e-15
R421_424	421	424	5.4340022012080544e+03
C421_424	421	424	1.3035236261084463e-14
R421_425	421	425	2.7769781640042711e+04
C421_425	421	425	2.5507403498578994e-15
R421_514	421	514	3.8686199409951332e+04
C421_514	421	514	1.8309759970316276e-15
R421_515	421	515	1.6281181482671358e+04
C421_515	421	515	4.3506365070244221e-15
R421_516	421	516	1.8739699669445352e+04
C421_516	421	516	3.7798632734489559e-15
R422_425	422	425	6.7879788784804536e+04
C422_425	422	425	1.0435138913080512e-15
R422_509	422	509	1.0189720379497379e+05
C422_509	422	509	6.9514667623778269e-16
R422_516	422	516	6.7686545231529351e+04
C422_516	422	516	1.0464930998281289e-15
R423_427	423	427	1.1062470547058621e+04
C423_427	423	427	6.4030455253807475e-15
R423_429	423	429	8.9049897099443406e+03
C423_429	423	429	7.9543609642691819e-15
R423_431	423	431	6.8036376704972099e+03
C423_431	423	431	1.0411122103570736e-14
R423_432	423	432	1.6346560631736649e+04
C423_432	423	432	4.3332358489208810e-15
R423_482	423	482	1.5663652099634017e+04
C423_482	423	482	4.5221575457268388e-15
R423_517	423	517	2.2039554604096000e+04
C423_517	423	517	3.2139262252983902e-15
R424_430	424	430	1.0889394132023843e+04
C424_430	424	430	6.5048157571678677e-15
R424_481	424	481	1.3426174384607593e+04
C424_481	424	481	5.2757770387078337e-15
R424_482	424	482	1.7641924909710724e+04
C424_482	424	482	4.0150665473590592e-15
R424_484	424	484	2.2460997776893742e+04
C424_484	424	484	3.1536222584407369e-15
R424_514	424	514	2.4713342793112603e+04
C424_514	424	514	2.8662048323038156e-15
R424_515	424	515	1.2268368952777060e+04
C424_515	424	515	5.7736690841830446e-15
R424_518	424	518	1.3805979012443189e+04
C424_518	424	518	5.1306395926111794e-15
R425_430	425	430	4.3101103465050423e+04
C425_430	425	430	1.6434266606059651e-15
R425_435	425	435	4.7325079229588329e+04
C425_435	425	435	1.4967434537693045e-15
R425_436	425	436	5.5958077898718358e+04
C425_436	425	436	1.2658315867139952e-15
R425_515	425	515	3.0706300999413259e+04
C425_515	425	515	2.3068067540064012e-15
R425_516	425	516	6.5328798846081852e+04
C425_516	425	516	1.0842615169289662e-15
R425_519	425	519	4.4242166397941473e+04
C425_519	425	519	1.6010405525552155e-15
R426_427	426	427	1.3623909662544633e+04
C426_427	426	427	5.1992052421441235e-15
R426_428	426	428	2.5955388691368760e+04
C426_428	426	428	2.7290480361619511e-15
R426_504	426	504	1.8525346323205860e+04
C426_504	426	504	3.8235993703000371e-15
R426_513	426	513	6.4830027231229673e+04
C426_513	426	513	1.0926033130197168e-15
R426_521	426	521	5.9833821575557296e+04
C426_521	426	521	1.1838371788864008e-15
R427_428	427	428	4.1707532918636622e+04
C427_428	427	428	1.6983383475158445e-15
R427_429	427	429	1.3814194323787500e+04
C427_429	427	429	5.1275883975388625e-15
R427_482	427	482	2.8087483697416083e+04
C427_482	427	482	2.5218885144387767e-15
R427_504	427	504	2.5578981845072511e+04
C427_504	427	504	2.7692072720105256e-15
R427_511	427	511	4.1473437851366885e+04
C427_511	427	511	1.7079245465460123e-15
R427_512	427	512	2.6618084533757097e+04
C427_512	427	512	2.6611044249321861e-15
R427_517	427	517	2.2178332563118700e+04
C427_517	427	517	3.1938155104496936e-15
R427_521	427	521	8.4875461449767663e+03
C427_521	427	521	8.3455808458752002e-15
R428_429	428	429	1.0887862176577661e+04
C428_429	428	429	6.5057310046024882e-15
R428_433	428	433	2.9734668678951595e+04
C428_433	428	433	2.3821857004965120e-15
R428_513	428	513	3.1125918587229044e+04
C428_513	428	513	2.2757080192667140e-15
R428_521	428	521	2.1042701977047498e+04
C428_521	428	521	3.3661790493094584e-15
R428_522	428	522	2.0552488656704867e+04
C428_522	428	522	3.4464683921813961e-15
R429_431	429	431	1.3273283854547068e+04
C429_431	429	431	5.3365469549371823e-15
R429_433	429	433	1.3426315257192089e+04
C429_433	429	433	5.2757216838072196e-15
R429_434	429	434	1.0335258115020670e+04
C429_434	429	434	6.8535784735801315e-15
R429_517	429	517	1.3513933802820129e+04
C429_517	429	517	5.2415161691274724e-15
R429_521	429	521	1.1726866426137569e+04
C429_521	429	521	6.0402753780943476e-15
R429_522	429	522	1.1344320766767773e+04
C429_522	429	522	6.2439615374329649e-15
R429_523	429	523	1.9008118422248986e+04
C429_523	429	523	3.7264868075048118e-15
R429_524	429	524	3.0544328368331073e+04
C429_524	429	524	2.3190394524910066e-15
R430_432	430	432	6.5085776880593321e+03
C430_432	430	432	1.0883100107409257e-14
R430_435	430	435	9.3005262622801711e+03
C430_435	430	435	7.6160746756102445e-15
R430_482	430	482	1.4894641044161928e+04
C430_482	430	482	4.7556367639865858e-15
R430_515	430	515	3.6649497530538265e+03
C430_515	430	515	1.9327277946164979e-14
R430_517	430	517	1.6064739750037566e+04
C430_517	430	517	4.4092530372821240e-15
R430_518	430	518	1.2497635038221117e+04
C430_518	430	518	5.6677525243273779e-15
R430_519	430	519	1.3646419279692316e+04
C430_519	430	519	5.1906292108003505e-15
R430_520	430	520	7.6373466701179632e+03
C430_520	430	520	9.2746218805471560e-15
R430_524	430	524	1.6466305998287251e+04
C430_524	430	524	4.3017239290565706e-15
R431_432	431	432	4.9548401811114809e+03
C431_432	431	432	1.4295819834114304e-14
R431_434	431	434	1.0258389166984138e+04
C431_434	431	434	6.9049342331418231e-15
R431_437	431	437	7.2293014189581481e+03
C431_437	431	437	9.7981116612797429e-15
R431_517	431	517	2.8179866859067017e+04
C431_517	431	517	2.5136209085107496e-15
R431_524	431	524	1.2884280426372265e+04
C431_524	431	524	5.4976684915219670e-15
R432_435	432	435	6.5615478770675609e+03
C432_435	432	435	1.0795242809027008e-14
R432_437	432	437	1.5725015126747070e+04
C432_437	432	437	4.5045109314723349e-15
R432_482	432	482	2.3155414757975643e+04
C432_482	432	482	3.0590470210257034e-15
R432_517	432	517	1.5184233339453576e+04
C432_517	432	517	4.6649376990243905e-15
R432_524	432	524	7.6593226705879106e+03
C432_524	432	524	9.2480112906071120e-15
R433_434	433	434	1.3831479129247360e+04
C433_434	433	434	5.1211805963845905e-15
R433_437	433	437	6.1617855535497009e+04
C433_437	433	437	1.1495613068714154e-15
R433_438	433	438	6.7794663056879028e+04
C433_438	433	438	1.0448241696631997e-15
R433_522	433	522	6.7381031005758443e+04
C433_522	433	522	1.0512380335935573e-15
R433_525	433	525	7.8808710616844837e+04
C433_525	433	525	8.9880296202764960e-16
R434_437	434	437	1.7171060906635790e+04
C434_437	434	437	4.1251675083527460e-15
R434_438	434	438	7.4107683018774012e+04
C434_438	434	438	9.5581860949633881e-16
R434_522	434	522	5.2084821810935951e+04
C434_522	434	522	1.3599643825819426e-15
R434_523	434	523	5.2496918743053335e+04
C434_523	434	523	1.3492887626928212e-15
R434_524	434	524	1.7881291541126364e+04
C434_524	434	524	3.9613191459400646e-15
R434_525	434	525	1.3503364230654284e+04
C434_525	434	525	5.2456188936383208e-15
R435_436	435	436	1.0232833445236847e+04
C435_436	435	436	6.9221787802059268e-15
R435_437	435	437	2.2375490658719416e+04
C435_437	435	437	3.1656737104174823e-15
R435_439	435	439	6.1576841300945969e+04
C435_439	435	439	1.1503269904640567e-15
R435_519	435	519	3.7275016347263234e+04
C435_519	435	519	1.9002943386019649e-15
R435_524	435	524	2.2850241760025794e+04
C435_524	435	524	3.0999016675576766e-15
R435_526	435	526	3.4609102347244770e+04
C435_526	435	526	2.0466726303763574e-15
R436_439	436	439	5.5280604709502375e+04
C436_439	436	439	1.2813445675608573e-15
R436_519	436	519	9.0523006601749628e+04
C436_519	436	519	7.8249171337876167e-16
R436_526	436	526	8.2021351829146486e+04
C436_526	436	526	8.6359833087790139e-16
R437_438	437	438	1.8312147582040921e+04
C437_438	437	438	3.8681155347102919e-15
R437_439	437	439	3.3304674020937477e+04
C437_439	437	439	2.1268336838087491e-15
R437_524	437	524	1.8094658968066738e+04
C437_524	437	524	3.9146083195602757e-15
R437_525	437	525	4.3215424814225502e+04
C437_525	437	525	1.6390791676929967e-15
R437_526	437	526	4.4308006116217002e+04
C437_526	437	526	1.5986614777972262e-15
R437_527	437	527	6.8092378241304788e+04
C437_527	437	527	1.0402559635232780e-15
R438_439	438	439	8.7218728007256825e+04
C438_439	438	439	8.1213638577836706e-16
R438_440	438	440	6.4279775592380080e+04
C438_440	438	440	1.1019562822555471e-15
R438_525	438	525	9.4235060914698217e+04
C438_525	438	525	7.5166824161252100e-16
R438_527	438	527	7.1327865366864222e+04
C438_527	438	527	9.9306914866551037e-16
R439_440	439	440	6.7864743945794078e+04
C439_440	439	440	1.0437452264253320e-15
R439_526	439	526	6.8018993426840578e+04
C439_526	439	526	1.0413782822615075e-15
R439_527	439	527	6.1243332345400362e+04
C439_527	439	527	1.1565912536651822e-15
R440_527	440	527	1.7362165201390343e+05
C440_527	440	527	4.0797620408730900e-16
R441_443	441	443	9.2002817676990071e+03
C441_443	441	443	7.6990579554516715e-15
R441_444	441	444	2.6437053854990056e+04
C441_444	441	444	2.6793266346745372e-15
R441_445	441	445	1.2916810272030920e+04
C441_445	441	445	5.4838230990647504e-15
R441_459	441	459	2.9219087431639109e+04
C441_459	441	459	2.4242202191195008e-15
R441_461	441	461	3.9932078445532410e+04
C441_461	441	461	1.7738496290048444e-15
R441_535	441	535	3.1140159490644815e+04
C441_535	441	535	2.2746673008299764e-15
R442_443	442	443	2.5388729439625953e+04
C442_443	442	443	2.7899585406367460e-15
R442_444	442	444	1.8272532884393306e+04
C442_444	442	444	3.8765015766642499e-15
R442_448	442	448	1.5956811936547958e+04
C442_448	442	448	4.4390761022733396e-15
R442_481	442	481	4.0491414877521900e+04
C442_481	442	481	1.7493461947490991e-15
R442_483	442	483	2.1849086193768540e+04
C442_483	442	483	3.2419434802816629e-15
R442_484	442	484	4.7288987872052618e+04
C442_484	442	484	1.4978857810966600e-15
R442_535	442	535	4.7464187640890152e+04
C442_535	442	535	1.4923567863821885e-15
R443_444	443	444	4.5614818385922925e+04
C443_444	443	444	1.5528616586109166e-15
R443_461	443	461	3.9598329743066519e+04
C443_461	443	461	1.7888002598999174e-15
R443_483	443	483	5.9731941923261817e+04
C443_483	443	483	1.1858563484676335e-15
R443_489	443	489	3.9103044544231314e+04
C443_489	443	489	1.8114574801426751e-15
R443_535	443	535	2.1722529171203601e+04
C443_535	443	535	3.2608312769537086e-15
R444_445	444	445	1.8308759548938608e+04
C444_445	444	445	3.8688313288873992e-15
R444_448	444	448	1.2724079984471560e+04
C444_448	444	448	5.5668859848763176e-15
R444_449	444	449	9.3557523040923206e+03
C444_449	444	449	7.5711177715785141e-15
R444_486	444	486	1.1290556675482103e+04
C444_486	444	486	6.2736944308350885e-15
R444_508	444	508	2.6713305295437804e+04
C444_508	444	508	2.6516188001676161e-15
R444_535	444	535	8.9537292418807465e+03
C444_535	444	535	7.9110614831503785e-15
R445_449	445	449	8.4626350524486497e+03
C445_449	445	449	8.3701473710017131e-15
R445_450	445	450	4.0274775315220199e+03
C445_450	445	450	1.7587559950764371e-14
R445_459	445	459	6.9875671495503157e+03
C445_459	445	459	1.0137076470250239e-14
R445_535	445	535	1.3335523937105905e+04
C445_535	445	535	5.3116400128012077e-15
R445_536	445	536	1.1775739435643809e+04
C445_536	445	536	6.0152063420828713e-15
R446_458	446	458	2.0604801942304442e+04
C446_458	446	458	3.4377181947364054e-15
R446_447	446	447	5.8786912426943956e+04
C446_447	446	447	1.2049195919929742e-15
R446_452	446	452	6.1604574397037963e+04
C446_452	446	452	1.1498091372157229e-15
R446_459	446	459	4.4968456285242224e+04
C446_459	446	459	1.5751819917208544e-15
R446_537	446	537	6.6137305612661890e+04
C446_537	446	537	1.0710067771862639e-15
R447_458	447	458	5.2041756601525682e+04
C447_458	447	458	1.3610897702465987e-15
R447_475	447	475	4.3788810548652837e+04
C447_475	447	475	1.6176165017612977e-15
R447_471	447	471	3.8421508770927874e+04
C447_471	447	471	1.8435898225214177e-15
R447_452	447	452	4.5566519677706528e+04
C447_452	447	452	1.5545076305367995e-15
R447_537	447	537	1.8743784161886430e+04
C447_537	447	537	3.7790395964990204e-15
R447_478	447	478	4.8724626471513067e+04
C447_478	447	478	1.4537515762673509e-15
R447_538	447	538	3.6302843321785243e+04
C447_538	447	538	1.9511833249020744e-15
R448_484	448	484	9.5781175196681324e+03
C448_484	448	484	7.3953469865604942e-15
R448_483	448	483	2.3678806366925593e+04
C448_483	448	483	2.9914304563485002e-15
R448_486	448	486	2.8007467918804399e+04
C448_486	448	486	2.5290934097059849e-15
R448_508	448	508	1.0863323149357946e+04
C448_508	448	508	6.5204267204539957e-15
R448_510	448	510	1.4225741047879959e+04
C448_510	448	510	4.9792486941519438e-15
R448_514	448	514	4.0443869657646712e+04
C448_514	448	514	1.7514027004734827e-15
R448_535	448	535	3.4537432604419831e+04
C448_535	448	535	2.0509197469106399e-15
R448_540	448	540	2.9409469215497142e+04
C448_540	448	540	2.4085270637483904e-15
R449_450	449	450	9.3009182614893271e+03
C449_450	449	450	7.6157536863094271e-15
R449_453	449	453	1.6805897431030200e+04
C449_453	449	453	4.2148003596174456e-15
R449_485	449	485	2.6599421020697278e+04
C449_485	449	485	2.6629715917832848e-15
R449_486	449	486	8.7622677023772503e+03
C449_486	449	486	8.0839235848480748e-15
R449_508	449	508	1.9669229481045277e+04
C449_508	449	508	3.6012342325997262e-15
R449_535	449	535	1.7031834593966556e+04
C449_535	449	535	4.1588885886134920e-15
R449_536	449	536	1.4342944777541465e+04
C449_536	449	536	4.9385606397169451e-15
R449_541	449	541	4.7977856386858302e+03
C449_541	449	541	1.4763790604742850e-14
R450_451	450	451	1.5284021584965436e+04
C450_451	450	451	4.6344806661145652e-15
R450_452	450	452	2.9119935823438165e+04
C450_452	450	452	2.4324745413411001e-15
R450_453	450	453	1.0570612199484747e+04
C450_453	450	453	6.7009839353914339e-15
R450_459	450	459	2.0471899155561772e+04
C450_459	450	459	3.4600357298436613e-15
R450_536	450	536	1.1574089797797031e+04
C450_536	450	536	6.1200063049002948e-15
R450_537	450	537	5.0681286091571616e+04
C450_537	450	537	1.3976263824090239e-15
R450_541	450	541	4.0182171168264140e+04
C450_541	450	541	1.7628092379424307e-15
R450_542	450	542	1.8127449499928967e+04
C450_542	450	542	3.9075272302525281e-15
R451_452	451	452	4.0380017269918877e+04
C451_452	451	452	1.7541721704207264e-15
R451_453	451	453	1.4804627669051501e+04
C451_453	451	453	4.7845514334733796e-15
R451_454	451	454	9.1654631333916725e+04
C451_454	451	454	7.7283058701026201e-16
R451_479	451	479	6.2762645347776968e+04
C451_479	451	479	1.1285933239987135e-15
R451_478	451	478	9.9484466874674501e+04
C451_478	451	478	7.1200565034170072e-16
R451_542	451	542	3.5574768607282233e+04
C451_542	451	542	1.9911163251108324e-15
R452_459	452	459	2.6541245737949866e+04
C452_459	452	459	2.6688085116788277e-15
R452_537	452	537	1.3932817883443502e+04
C452_537	452	537	5.0839322761960537e-15
R452_478	452	478	3.2791545934553877e+04
C452_478	452	478	2.1601147648656501e-15
R452_542	452	542	3.3944525371731106e+04
C452_542	452	542	2.0867430538589864e-15
R453_454	453	454	1.9929924538108113e+04
C453_454	453	454	3.5541279848079151e-15
R453_479	453	479	5.8870176690005821e+04
C453_479	453	479	1.2032153888205529e-15
R453_485	453	485	4.5462262562257849e+04
C453_485	453	485	1.5580725318938486e-15
R453_541	453	541	4.1931582483621431e+04
C453_541	453	541	1.6892637563504248e-15
R453_542	453	542	3.8387134781064822e+04
C453_542	453	542	1.8452406760751514e-15
R453_543	453	543	2.0787568021456736e+04
C453_543	453	543	3.4074934818198223e-15
R454_479	454	479	9.4608593054379395e+04
C454_479	454	479	7.4870051703745478e-16
R454_485	454	485	6.1602120031119091e+04
C454_485	454	485	1.1498549481773933e-15
R454_543	454	543	8.8517008761520658e+04
C454_543	454	543	8.0022476501479030e-16
R455_456	455	456	1.3212836391591030e+04
C455_456	455	456	5.3609611469252884e-15
R455_460	455	460	4.1955220620960208e+04
C455_460	455	460	1.6883120023593114e-15
R455_463	455	463	2.6578896782825774e+04
C455_463	455	463	2.6650279398266752e-15
R455_465	455	465	1.7069883423501789e+04
C455_465	455	465	4.1496184114811566e-15
R455_466	455	466	1.2126222343510313e+04
C455_466	455	466	5.8413494763196849e-15
R455_488	455	488	2.2002081475469819e+04
C455_488	455	488	3.2194000651698565e-15
R455_490	455	490	2.0264752321221331e+04
C455_490	455	490	3.4954043066108879e-15
R455_545	455	545	4.0104850645518076e+04
C455_545	455	545	1.7662078625373470e-15
R456_465	456	465	2.3046513076318271e+04
C456_465	456	465	3.0735019350404835e-15
R456_457	456	457	4.4111979721672506e+04
C456_457	456	457	1.6057656668988506e-15
R456_467	456	467	2.9406814679366526e+04
C456_467	456	467	2.4087444800915747e-15
R456_488	456	488	3.8523843348716015e+04
C456_488	456	488	1.8386925181586502e-15
R456_468	456	468	4.3532306140961518e+04
C456_468	456	468	1.6271479463236974e-15
R456_545	456	545	2.9416721709771500e+04
C456_545	456	545	2.4079332576502195e-15
R456_546	456	546	4.4555775565665470e+04
C456_546	456	546	1.5897715085580075e-15
R457_462	457	462	2.2687780178861794e+04
C457_462	457	462	3.1220992965189064e-15
R457_465	457	465	1.9055208689519011e+04
C457_465	457	465	3.7172777107899511e-15
R457_469	457	469	4.9169881600329878e+04
C457_469	457	469	1.4405872097020627e-15
R457_470	457	470	4.0642191391173503e+04
C457_470	457	470	1.7428563793285839e-15
R457_546	457	546	2.9666682707894037e+04
C457_546	457	546	2.3876448618622211e-15
R457_468	457	468	7.4903952304755992e+04
C457_468	457	468	9.4565774377038405e-16
R458_459	458	459	3.8040896572621852e+04
C458_459	458	459	1.8620355700811507e-15
R458_460	458	460	9.5444732420155469e+03
C458_460	458	460	7.4214155920292364e-15
R458_463	458	463	1.9133170487760555e+04
C458_463	458	463	3.7021309448589318e-15
R458_466	458	466	2.9482643789874986e+04
C458_466	458	466	2.4025492096582549e-15
R458_474	458	474	1.0037118787535795e+04
C458_474	458	474	7.0571549500800794e-15
R458_475	458	475	2.6843801396875027e+04
C458_475	458	475	2.6387284531260898e-15
R458_537	458	537	2.0362374121328412e+04
C458_537	458	537	3.4786465524079534e-15
R458_547	458	547	4.1959045081119621e+04
C458_547	458	547	1.6881581170176125e-15
R459_460	459	460	4.7525423177683733e+04
C459_460	459	460	1.4904339151526151e-15
R459_461	459	461	2.8045604188483263e+04
C459_461	459	461	2.5256543613735847e-15
R459_535	459	535	3.8621859348682738e+04
C459_535	459	535	1.8340262154783055e-15
R459_536	459	536	1.8808417902642559e+04
C459_536	459	536	3.7660532056791437e-15
R459_537	459	537	2.2283345681367700e+04
C459_537	459	537	3.1787642461260978e-15
R459_547	459	547	3.0083090700559329e+04
C459_547	459	547	2.3545952522319464e-15
R460_461	460	461	1.1293319627742107e+04
C460_461	460	461	6.2721595483755814e-15
R460_466	460	466	2.1592175937464493e+04
C460_466	460	466	3.2805171068052068e-15
R460_474	460	474	3.5053027632315541e+04
C460_474	460	474	2.0207527657524880e-15
R460_490	460	490	1.1554853197290904e+04
C460_490	460	490	6.1301949342469639e-15
R460_547	460	547	2.0087529352019319e+04
C460_547	460	547	3.5262426401323170e-15
R461_489	461	489	9.5452849962999044e+03
C461_489	461	489	7.4207844567718651e-15
R461_490	461	490	1.2895866988963440e+04
C461_490	461	490	5.4927289957798764e-15
R461_535	461	535	9.7058372614342370e+03
C461_535	461	535	7.2980311361137452e-15
R461_547	461	547	1.3003142950977215e+04
C461_547	461	547	5.4474139677651334e-15
R461_548	461	548	2.1953859991078887e+04
C461_548	461	548	3.2264714526185254e-15
R462_463	462	463	8.4735412121164609e+03
C462_463	462	463	8.3593742878967746e-15
R462_464	462	464	1.0160126377526822e+04
C462_464	462	464	6.9717147114111299e-15
R462_465	462	465	1.2356363841508091e+04
C462_465	462	465	5.7325523466744086e-15
R462_470	462	470	2.4299471231322688e+04
C462_470	462	470	2.9150223830670720e-15
R462_549	462	549	4.2736292052992045e+04
C462_549	462	549	1.6574555052218395e-15
R463_464	463	464	3.5397216208915059e+04
C463_464	463	464	2.0011037624523720e-15
R463_465	463	465	1.5629966432311128e+04
C463_465	463	465	4.5319036891575844e-15
R463_466	463	466	7.8058655999234825e+03
C463_466	463	466	9.0743943293994673e-15
R463_474	463	474	2.6999441779473575e+04
C463_474	463	474	2.6235172976743337e-15
R463_549	463	549	3.5610599280490896e+04
C463_549	463	549	1.9891129036630906e-15
R464_470	464	470	1.5229916061911363e+04
C464_470	464	470	4.6509450379144345e-15
R464_474	464	474	2.2273833405511617e+04
C464_474	464	474	3.1801217709777964e-15
R464_475	464	475	2.5711415985057680e+04
C464_475	464	475	2.7549436630470012e-15
R464_476	464	476	6.8243766981543295e+03
C464_476	464	476	1.0379483089665479e-14
R464_549	464	549	1.5525526729342055e+04
C464_549	464	549	4.5623896548469512e-15
R465_466	465	466	9.0013566337593602e+03
C465_466	465	466	7.8692029899516196e-15
R465_470	465	470	2.5378386526699815e+04
C465_470	465	470	2.7910955829078529e-15
R465_545	465	545	1.6393860342629658e+04
C465_545	465	545	4.3207335585145020e-15
R465_546	465	546	6.5859545510765238e+03
C465_546	465	546	1.0755237071051719e-14
R465_549	465	549	9.4193919431314753e+03
C465_549	465	549	7.5199655098385713e-15
R466_474	466	474	1.2090177384325849e+04
C466_474	466	474	5.8587645395369613e-15
R466_490	466	490	9.0041497217941560e+03
C466_490	466	490	7.8667619624927576e-15
R466_545	466	545	3.2038248540679178e+04
C466_545	466	545	2.2109043334894612e-15
R466_549	466	549	1.7518540041755004e+04
C466_549	466	549	4.0433450714026458e-15
R466_550	466	550	2.0134924413165179e+04
C466_550	466	550	3.5179423117022318e-15
R467_488	467	488	5.1046402071053461e+04
C467_488	467	488	1.3876296793142074e-15
R467_492	467	492	3.3855715113716404e+04
C467_492	467	492	2.0922169949174197e-15
R467_493	467	493	2.3080009728891131e+04
C467_493	467	493	3.0690412771937410e-15
R467_530	467	530	3.2649024975000513e+04
C467_530	467	530	2.1695441928277336e-15
R467_531	467	531	3.6168763771943442e+04
C467_531	467	531	1.9584164662809522e-15
R467_468	467	468	3.2075212673919534e+04
C467_468	467	468	2.2083564419697511e-15
R467_545	467	545	2.0591954561306218e+04
C467_545	467	545	3.4398629972261750e-15
R467_551	467	551	4.0278230606054633e+04
C467_551	467	551	1.7586051191968770e-15
R467_552	467	552	3.1594591776324989e+04
C467_552	467	552	2.2419502374795106e-15
R467_553	467	553	5.5628399899404736e+04
C467_553	467	553	1.2733334531298998e-15
R468_545	468	545	2.8466637180885893e+04
C468_545	468	545	2.4882989193947232e-15
R468_546	468	546	1.0662467749291292e+04
C468_546	468	546	6.6432559705240968e-15
R468_469	468	469	3.0297223364149297e+04
C468_469	468	469	2.3379536033594843e-15
R468_552	468	552	1.1484867624297833e+04
C468_552	468	552	6.1675506286325756e-15
R468_531	468	531	6.3544571391499434e+04
C468_531	468	531	1.1147058038930393e-15
R468_555	468	555	3.7983622273470122e+04
C468_555	468	555	1.8648432744518434e-15
R468_556	468	556	4.1667279271379819e+04
C468_556	468	556	1.6999790668994728e-15
R469_470	469	470	7.1013878137200139e+04
C469_470	469	470	9.9745999506108292e-16
R469_546	469	546	7.2139950615321141e+04
C469_546	469	546	9.8189008908132419e-16
R469_555	469	555	2.8378325449990947e+05
C469_555	469	555	2.4960423637689516e-16
R469_556	469	556	1.0543997614138470e+05
C469_556	469	556	6.7178981946106645e-16
R470_476	470	476	4.8038627320013031e+04
C470_476	470	476	1.4745113773575829e-15
R470_546	470	546	2.4828019010086253e+04
C470_546	470	546	2.8529663404568950e-15
R470_549	470	549	1.8553947170536881e+04
C470_549	470	549	3.8177053046955694e-15
R470_556	470	556	5.2890856138484553e+04
C470_556	470	556	1.3392390992979219e-15
R470_557	470	557	7.6968603288484926e+04
C470_557	470	557	9.2029086549108825e-16
R471_475	471	475	2.1084255343374443e+04
C471_475	471	475	3.3595449012743461e-15
R471_472	471	472	4.3765694478392455e+04
C471_472	471	472	1.6184708909616685e-15
R471_478	471	478	7.2382080371136835e+04
C471_478	471	478	9.7860550805950114e-16
R471_538	471	538	1.6114911876268181e+04
C471_538	471	538	4.3955252799311813e-15
R471_477	471	477	2.8677517422698776e+04
C471_477	471	477	2.4700012031004467e-15
R471_473	471	473	6.3610511618680925e+04
C471_473	471	473	1.1135502723294850e-15
R471_558	471	558	3.5417255323109122e+04
C471_558	471	558	1.9999715361845789e-15
R472_475	472	475	1.6260249922337849e+04
C472_475	472	475	4.3562370119964181e-15
R472_476	472	476	5.3276246420865653e+04
C472_476	472	476	1.3295512971472790e-15
R472_473	472	473	9.5411236464049842e+04
C472_473	472	473	7.4240210232145446e-16
R472_558	472	558	2.7302743113880471e+04
C472_558	472	558	2.5943731089785220e-15
R473_558	473	558	4.5874426515355553e+04
C473_558	473	558	1.5440738537034333e-15
R473_477	473	477	3.2107963465480349e+04
C473_477	473	477	2.2061038723976979e-15
R473_560	473	560	4.6339208783645190e+04
C473_560	473	560	1.5285867928111828e-15
R473_561	473	561	1.7749860776973210e+05
C473_561	473	561	3.9906511620582348e-16
R474_475	474	475	1.9677525359411109e+04
C474_475	474	475	3.5997159826869541e-15
R474_476	474	476	8.8223906157978941e+04
C474_476	474	476	8.0288331837360896e-16
R474_490	474	490	6.2905441457676148e+04
C474_490	474	490	1.1260314035576396e-15
R474_537	474	537	5.1168807460866170e+04
C474_537	474	537	1.3843102087179454e-15
R474_538	474	538	8.6694082646580631e+04
C474_538	474	538	8.1705118012219723e-16
R474_547	474	547	3.5721211385826646e+04
C474_547	474	547	1.9829535390310175e-15
R474_549	474	549	3.1464631041106648e+04
C474_549	474	549	2.2512103333886330e-15
R474_550	474	550	3.3935823287618347e+04
C474_550	474	550	2.0872781525192571e-15
R474_562	474	562	1.4694169717635008e+04
C474_562	474	562	4.8205175179779051e-15
R475_476	475	476	1.1994359445646498e+04
C475_476	475	476	5.9055677676651514e-15
R475_537	475	537	3.1026106312222979e+04
C475_537	475	537	2.2830290666571527e-15
R475_538	475	538	1.0352633013199676e+04
C475_538	475	538	6.8420760637112135e-15
R475_558	475	558	1.7279574176050537e+04
C475_558	475	558	4.0992620428213530e-15
R475_562	475	562	2.0074213302563196e+04
C475_562	475	562	3.5285817415796596e-15
R476_549	476	549	3.2609894241875951e+04
C476_549	476	549	2.1721475700169329e-15
R476_557	476	557	5.6773621775989101e+04
C476_557	476	557	1.2476481210849433e-15
R476_558	476	558	4.5454534166376667e+04
C476_558	476	558	1.5583374427890744e-15
R476_559	476	559	5.2923944971421741e+04
C476_559	476	559	1.3384017872108591e-15
R476_562	476	562	3.3673943936347750e+04
C476_562	476	562	2.1035107342903825e-15
R477_478	477	478	5.6426749890464060e+04
C477_478	477	478	1.2553177823195988e-15
R477_538	477	538	5.5872129702925573e+04
C477_538	477	538	1.2677788176793093e-15
R477_558	477	558	7.2780073866795006e+04
C477_558	477	558	9.7325406217149904e-16
R477_560	477	560	4.2910632490081713e+04
C477_560	477	560	1.6507214745057030e-15
R477_561	477	561	7.9303530024691121e+04
C477_561	477	561	8.9319482391194974e-16
R477_563	477	563	3.0833748087859098e+04
C477_563	477	563	2.2972718832029043e-15
R477_480	477	480	4.9954372565247984e+04
C477_480	477	480	1.4179640119287000e-15
R477_564	477	564	6.1014231746646517e+04
C477_564	477	564	1.1609341051793737e-15
R478_537	478	537	4.4920678947191664e+04
C478_537	478	537	1.5768573449050316e-15
R478_538	478	538	2.5295121531324388e+04
C478_538	478	538	2.8002831474157122e-15
R478_542	478	542	1.8973876298766947e+04
C478_542	478	542	3.7332119921432848e-15
R478_479	478	479	5.7077238987808465e+04
C478_479	478	479	1.2410113697183187e-15
R478_563	478	563	4.6942694816847747e+04
C478_563	478	563	1.5089355822533189e-15
R478_480	478	480	6.0681937990107457e+04
C478_480	478	480	1.1672913700868864e-15
R478_565	478	565	6.9393329354592963e+04
C478_565	478	565	1.0207537697758803e-15
R479_542	479	542	5.2864152454404481e+04
C479_542	479	542	1.3399155996512788e-15
R479_543	479	543	6.9937089563142028e+04
C479_543	479	543	1.0128174188897103e-15
R479_480	479	480	2.0748430989331880e+05
C479_480	479	480	3.4139209163536322e-16
R479_565	479	565	7.3712548267636390e+04
C479_565	479	565	9.6094225746770954e-16
R480_563	480	563	8.3014197120786630e+04
C480_563	480	563	8.5326974171582296e-16
R480_564	480	564	5.4260583021452541e+04
C480_564	480	564	1.3054320206621296e-15
R480_561	480	561	2.5855034929066733e+05
C480_561	480	561	2.7396405663473932e-16
R480_565	480	565	9.2607309726214167e+04
C480_565	480	565	7.6488025346393721e-16
R481_482	481	482	1.7930660104137609e+04
C481_482	481	482	3.9504124290245607e-15
R481_483	481	483	3.7006343743277263e+04
C481_483	481	483	1.9140908117643463e-15
R481_484	481	484	9.4372588426330858e+03
C481_484	481	484	7.5057284871754994e-15
R481_495	481	495	1.6328676731537606e+04
C481_495	481	495	4.3379818034605616e-15
R481_512	481	512	5.1357059352864111e+04
C481_512	481	512	1.3792359498100767e-15
R481_518	481	518	4.7834717415844672e+04
C481_518	481	518	1.4807969266384182e-15
R481_567	481	567	3.1887910424185957e+04
C481_567	481	567	2.2213278196577935e-15
R482_512	482	512	2.3376209522647147e+04
C482_512	482	512	3.0301534757966500e-15
R482_517	482	517	1.0609036891919795e+04
C482_517	482	517	6.6767137542852002e-15
R482_518	482	518	2.3641967758717878e+04
C482_518	482	518	2.9960916645730746e-15
R482_567	482	567	3.8298308833559517e+04
C482_567	482	567	1.8495203755297675e-15
R483_484	483	484	1.1795439132673820e+04
C483_484	483	484	6.0051602775676625e-15
R483_489	483	489	1.9605978893600408e+04
C483_489	483	489	3.6128521264052152e-15
R483_494	483	494	1.9175166402070885e+04
C483_494	483	494	3.6940228340521784e-15
R483_495	483	495	1.0827175785976566e+04
C483_495	483	495	6.5421956691369172e-15
R483_510	483	510	3.2106653908174460e+04
C483_510	483	510	2.2061938543513423e-15
R483_535	483	535	1.8776722443160314e+04
C483_535	483	535	3.7724103740907179e-15
R483_539	483	539	8.8485489772796518e+03
C483_539	483	539	8.0050980921141545e-15
R483_540	483	540	2.0460768664249244e+04
C483_540	483	540	3.4619179610669356e-15
R483_568	483	568	2.2137180598784995e+04
C483_568	483	568	3.1997526613613888e-15
R484_495	484	495	1.9166110804272208e+04
C484_495	484	495	3.6957681847592641e-15
R484_510	484	510	1.3390957748696479e+04
C484_510	484	510	5.2896517086610324e-15
R484_514	484	514	1.1312927801876556e+04
C484_514	484	514	6.2612883045404356e-15
R484_518	484	518	3.0577026810650990e+04
C484_518	484	518	2.3165595194927964e-15
R484_567	484	567	1.7691949227364683e+04
C484_567	484	567	4.0037138715297494e-15
R484_568	484	568	1.3266977513668206e+04
C484_568	484	568	5.3390836355171576e-15
R485_486	485	486	1.7612982391862031e+04
C485_486	485	486	4.0216643019372002e-15
R485_509	485	509	6.3215343476691807e+04
C485_509	485	509	1.1205112341455064e-15
R485_541	485	541	4.9940807673714393e+04
C485_541	485	541	1.4183491584434702e-15
R485_543	485	543	6.1986747557157796e+04
C485_543	485	543	1.1427201027233225e-15
R485_570	485	570	5.9525488079322859e+04
C485_570	485	570	1.1899692857891102e-15
R486_508	486	508	5.9055021433390111e+03
C486_508	486	508	1.1994492731815395e-14
R486_509	486	509	2.1985834759646987e+04
C486_509	486	509	3.2217790823211540e-15
R486_541	486	541	2.9408641130014508e+04
C486_541	486	541	2.4085948828049463e-15
R486_570	486	570	3.1234053730726086e+04
C486_570	486	570	2.2678293104912763e-15
R487_488	487	488	5.0006203058714229e+04
C487_488	487	488	1.4164943187714461e-15
R487_491	487	491	2.2169642681235982e+04
C487_491	487	491	3.1950673970921638e-15
R487_492	487	492	8.1329542021750094e+04
C487_492	487	492	8.7094431832724305e-16
R487_493	487	493	8.3403806772502183e+04
C487_493	487	493	8.4928380702346399e-16
R487_496	487	496	2.7897983792826122e+04
C487_496	487	496	2.5390186997748065e-15
R487_500	487	500	5.2541645483995140e+04
C487_500	487	500	1.3481401635503936e-15
R487_573	487	573	3.2235590898737490e+04
C487_573	487	573	2.1973694466625770e-15
R488_490	488	490	1.4378844132924709e+04
C488_490	488	490	4.9262306400418722e-15
R488_489	488	489	4.0901358744663063e+04
C488_489	488	489	1.7318129448509480e-15
R488_491	488	491	1.2986407399878366e+04
C488_491	488	491	5.4544340366731028e-15
R488_493	488	493	1.5973385456808297e+04
C488_493	488	493	4.4344702459933948e-15
R488_545	488	545	2.1314115917536496e+04
C488_545	488	545	3.3233141271283377e-15
R488_572	488	572	2.8053788211403586e+04
C488_572	488	572	2.5249175620142061e-15
R488_573	488	573	2.8331318600522729e+04
C488_573	488	573	2.5001837554674597e-15
R488_574	488	574	2.2943126037238875e+04
C488_574	488	574	3.0873518465195418e-15
R489_490	489	490	4.4680578391955816e+04
C489_490	489	490	1.5853309219639086e-15
R489_491	489	491	1.5977057733538228e+04
C489_491	489	491	4.4334509968822301e-15
R489_494	489	494	1.6137575718767277e+04
C489_494	489	494	4.3893521412651726e-15
R489_535	489	535	3.4053804862983859e+04
C489_535	489	535	2.0800466444498632e-15
R489_539	489	539	3.0903978565555371e+04
C489_539	489	539	2.2920512446558859e-15
R489_548	489	548	1.9098229163535692e+04
C489_548	489	548	3.7089042093621231e-15
R489_574	489	574	1.8225852280806852e+04
C489_574	489	574	3.8864301896374327e-15
R490_545	490	545	3.8359325800956380e+04
C490_545	490	545	1.8465784019132575e-15
R490_547	490	547	2.4235880139767443e+04
C490_547	490	547	2.9226709377792663e-15
R490_548	490	548	2.2921216644649361e+04
C490_548	490	548	3.0903029116709261e-15
R490_550	490	550	1.2126864639108711e+04
C490_550	490	550	5.8410400910689199e-15
R490_572	490	572	2.7415051102908212e+04
C490_572	490	572	2.5837450482988865e-15
R490_574	490	574	4.4846202446101386e+04
C490_574	490	574	1.5794760464084239e-15
R491_494	491	494	8.9663208343995066e+03
C491_494	491	494	7.8999518134846990e-15
R491_496	491	496	2.0714453231178140e+04
C491_496	491	496	3.4195207445488211e-15
R491_573	491	573	1.8848998759406881e+04
C491_573	491	573	3.7579451004340206e-15
R491_574	491	574	2.0050491122808420e+04
C491_574	491	574	3.5327564847238786e-15
R492_493	492	493	5.5883318458965921e+04
C492_493	492	493	1.2675249875866213e-15
R492_500	492	500	7.5482111846413653e+04
C492_500	492	500	9.3841442433576373e-16
R492_501	492	501	1.1085728668697340e+05
C492_501	492	501	6.3896117840238905e-16
R492_529	492	529	8.2818400552409032e+04
C492_529	492	529	8.5528701428102604e-16
R492_530	492	530	3.8141687130798280e+04
C492_530	492	530	1.8571150849487207e-15
R492_531	492	531	2.1709060103792194e+05
C492_531	492	531	3.2628544118142926e-16
R492_532	492	532	1.2358678096800127e+05
C492_532	492	532	5.7314788831938266e-16
R492_573	492	573	1.6470258997374354e+05
C492_573	492	573	4.3006914795506315e-16
R492_575	492	575	1.0053795415418595e+05
C492_575	492	575	7.0454489681945444e-16
R493_530	493	530	1.7628662773381260e+04
C493_530	493	530	4.0180871031781497e-15
R493_545	493	545	2.0637618678085153e+04
C493_545	493	545	3.4322517360599011e-15
R493_551	493	551	9.1657921584587875e+03
C493_551	493	551	7.7280284465789759e-15
R493_572	493	572	2.4694657527182833e+04
C493_572	493	572	2.8683735523778570e-15
R493_573	493	573	1.6041122722222668e+04
C493_573	493	573	4.4157446933480765e-15
R493_575	493	575	1.2103071702962698e+04
C493_575	493	575	5.8525227540923140e-15
R494_495	494	495	4.1476943722508571e+04
C494_495	494	495	1.7077801828865301e-15
R494_496	494	496	2.7517806381794999e+04
C494_496	494	496	2.5740969884453235e-15
R494_499	494	499	1.9739120917385186e+04
C494_499	494	499	3.5884831362278933e-15
R494_539	494	539	3.7241474005899006e+04
C494_539	494	539	1.9020058799171072e-15
R494_573	494	573	3.2463895936171291e+04
C494_573	494	573	2.1819162640019825e-15
R494_574	494	574	1.8042039629694747e+04
C494_574	494	574	3.9260252160968358e-15
R494_576	494	576	2.3303975509337233e+04
C494_576	494	576	3.0395458709445972e-15
R495_499	495	499	1.2634869639349623e+04
C495_499	495	499	5.6061917976105168e-15
R495_512	495	512	9.6372451778935192e+03
C495_512	495	512	7.3499741086261954e-15
R495_539	495	539	1.8871152468787939e+04
C495_539	495	539	3.7535334767262109e-15
R495_566	495	566	8.7908177680460230e+03
C495_566	495	566	8.0576693096146958e-15
R495_567	495	567	9.8985192324001273e+03
C495_567	495	567	7.1559695822124277e-15
R495_568	495	568	1.0731574821337492e+04
C495_568	495	568	6.6004760452456989e-15
R495_576	495	576	2.8183923383738245e+04
C495_576	495	576	2.5132591219315479e-15
R496_498	496	498	1.7135573245909927e+04
C496_498	496	498	4.1337107034284476e-15
R496_497	496	497	4.0629978773273418e+04
C496_497	496	497	1.7433802496248068e-15
R496_499	496	499	7.3974124272637855e+03
C496_499	496	499	9.5754432015899478e-15
R496_500	496	500	2.1680071789652484e+04
C496_500	496	500	3.2672171579158524e-15
R496_573	496	573	1.9597890071482376e+04
C496_573	496	573	3.6143432929584852e-15
R496_578	496	578	5.1265770957871697e+04
C496_578	496	578	1.3816919401096755e-15
R497_498	497	498	1.5079207665904076e+04
C497_498	497	498	4.6974286783093501e-15
R497_500	497	500	4.3429076793712433e+04
C497_500	497	500	1.6310156182333383e-15
R497_503	497	503	4.0853922257143531e+04
C497_503	497	503	1.7338237951832003e-15
R497_504	497	504	4.5714835112868917e+04
C497_504	497	504	1.5494642463680262e-15
R497_505	497	505	2.6947907448254406e+04
C497_505	497	505	2.6285344296960753e-15
R497_578	497	578	3.0465643672673279e+04
C497_578	497	578	2.3250289177226683e-15
R498_499	498	499	2.0959621910251662e+04
C498_499	498	499	3.3795219608114339e-15
R498_504	498	504	1.9035527111915857e+04
C498_504	498	504	3.7211211499186517e-15
R498_511	498	511	1.4202235417530739e+04
C498_511	498	511	4.9874896770522218e-15
R498_578	498	578	2.2747041947334310e+04
C498_578	498	578	3.1139654421880055e-15
R499_511	499	511	1.1640285778411800e+04
C499_511	499	511	6.0852030512316625e-15
R499_512	499	512	2.8526563691151558e+04
C499_512	499	512	2.4830716837433643e-15
R499_566	499	566	1.7873715740513569e+04
C499_566	499	566	3.9629981568658835e-15
R499_573	499	573	1.1933173107552262e+04
C499_573	499	573	5.9358480680357284e-15
R499_500	499	500	3.0705601090702356e+04
C499_500	499	500	2.3068593357531885e-15
R499_576	499	576	1.7639976599615566e+04
C499_576	499	576	4.0155100056960227e-15
R499_577	499	577	9.1062136940207638e+03
C499_577	499	577	7.7785899734057469e-15
R499_578	499	578	1.5299262715822211e+04
C499_578	499	578	4.6298637948575995e-15
R499_579	499	579	3.2420970674186421e+04
C499_579	499	579	2.1848051141910336e-15
R500_501	500	501	2.7592392975584709e+04
C500_501	500	501	2.5671387979533863e-15
R500_503	500	503	7.9286475519956957e+03
C500_503	500	503	8.9338694993663461e-15
R500_529	500	529	2.1691131807616348e+04
C500_529	500	529	3.2655512475899678e-15
R500_573	500	573	1.2231821113789809e+04
C500_573	500	573	5.7909204097290387e-15
R500_575	500	575	1.6999442610829854e+04
C500_575	500	575	4.1668132395631625e-15
R500_578	500	578	1.6670591073591295e+04
C500_578	500	578	4.2490096615836754e-15
R500_579	500	579	1.3728180288959278e+04
C500_579	500	579	5.1597153479232040e-15
R501_503	501	503	1.0456479262449249e+04
C501_503	501	503	6.7741254736069256e-15
R501_502	501	502	3.4838121161562776e+04
C501_502	501	502	2.0332182153999531e-15
R501_529	501	529	1.3111885871277738e+04
C501_529	501	529	5.4022360499006815e-15
R501_532	501	532	5.4364340194520693e+04
C501_532	501	532	1.3029405356995251e-15
R501_528	501	528	3.6268515560741522e+04
C501_528	501	528	1.9530300989950915e-15
R501_581	501	581	3.7282757620909739e+04
C501_581	501	581	1.8998997675073692e-15
R502_503	502	503	2.7605821402191334e+04
C502_503	502	503	2.5658900528269477e-15
R502_505	502	505	3.6478934628454022e+04
C502_505	502	505	1.9417645624099174e-15
R502_506	502	506	1.6695439469811328e+04
C502_506	502	506	4.2426857145079089e-15
R502_507	502	507	3.3490068503182774e+04
C502_507	502	507	2.1150599476757788e-15
R502_528	502	528	1.0843833102932155e+05
C502_528	502	528	6.5321461390665217e-16
R502_581	502	581	2.3476059367376405e+04
C502_581	502	581	3.0172654374197940e-15
R503_505	503	505	2.7125858087797311e+04
C503_505	503	505	2.6112907583139196e-15
R503_506	503	506	5.4266209506005061e+03
C503_506	503	506	1.3052966695262109e-14
R503_529	503	529	2.5599732035977548e+04
C503_529	503	529	2.7669626555641860e-15
R503_578	503	578	1.3226707552263499e+04
C503_578	503	578	5.3553389803253193e-15
R503_579	503	579	3.1163349216144255e+04
C503_579	503	579	2.2729746422539372e-15
R503_581	503	581	2.6674809942802694e+04
C503_581	503	581	2.6554454441431569e-15
R503_582	503	582	1.8458447425228238e+04
C503_582	503	582	3.8374572305137492e-15
R504_505	504	505	1.1574797895416383e+04
C504_505	504	505	6.1196319085666343e-15
R504_511	504	511	1.7080859147082989e+04
C504_511	504	511	4.1469519727347391e-15
R504_513	504	513	2.9125378812843206e+04
C504_513	504	513	2.4320199572740008e-15
R504_521	504	521	3.3753815276355868e+04
C504_521	504	521	2.0985332163507464e-15
R504_578	504	578	2.9324393695500334e+04
C504_578	504	578	2.4155146487093108e-15
R504_584	504	584	2.8301469499613635e+04
C504_584	504	584	2.5028206587282341e-15
R505_506	505	506	9.6930890220996480e+03
C505_506	505	506	7.3076294228293980e-15
R505_507	505	507	7.8079709972754763e+03
C505_507	505	507	9.0719474445687281e-15
R505_513	505	513	3.6559862601841029e+04
C505_513	505	513	1.9374663222184285e-15
R505_578	505	578	1.8652185148640307e+04
C505_578	505	578	3.7975980814861031e-15
R505_584	505	584	3.9476963036313013e+04
C505_584	505	584	1.7942996899443246e-15
R505_585	505	585	4.3745934743494399e+04
C505_585	505	585	1.6192019430224630e-15
R506_507	506	507	1.1533699597468405e+04
C506_507	506	507	6.1414381341740187e-15
R506_578	506	578	2.0051298509532029e+04
C506_578	506	578	3.5326142345507958e-15
R506_581	506	581	1.4972693321609231e+04
C506_581	506	581	4.7308457479570529e-15
R506_582	506	582	1.8498171146448909e+04
C506_582	506	582	3.8292165195799846e-15
R506_585	506	585	2.3816958494450300e+04
C506_585	506	585	2.9740784303967792e-15
R507_513	507	513	6.3265723682509539e+04
C507_513	507	513	1.1196189407627477e-15
R507_581	507	581	6.7671677995434395e+04
C507_581	507	581	1.0467230107812449e-15
R507_585	507	585	3.5898476737108293e+04
C507_585	507	585	1.9731617877473714e-15
R508_509	508	509	2.0331350934098100e+04
C508_509	508	509	3.4839545471227783e-15
R508_510	508	510	1.4752537951843691e+04
C508_510	508	510	4.8014451999527055e-15
R508_514	508	514	3.4952857311060492e+04
C508_514	508	514	2.0265439790979676e-15
R508_535	508	535	4.3366635337817868e+04
C508_535	508	535	1.6333640362970390e-15
R508_540	508	540	1.8992390793480583e+04
C508_540	508	540	3.7295727171070347e-15
R508_541	508	541	1.3883582392011171e+04
C508_541	508	541	5.1019614776629060e-15
R508_569	508	569	1.1949477784264627e+04
C508_569	508	569	5.9277487949536469e-15
R508_570	508	570	1.3550345330784876e+04
C508_570	508	570	5.2274315382261283e-15
R508_587	508	587	2.5248347354269146e+04
C508_587	508	587	2.8054708509079127e-15
R509_514	509	514	6.2822529390408126e+04
C509_514	509	514	1.1275175199617961e-15
R509_516	509	516	5.3110246053333329e+04
C509_516	509	516	1.3337069172089501e-15
R509_570	509	570	5.3789160464701650e+04
C509_570	509	570	1.3168731752651810e-15
R509_587	509	587	5.7578943681358709e+04
C509_587	509	587	1.2301980204428877e-15
R510_514	510	514	9.4285647832606173e+03
C510_514	510	514	7.5126495033217690e-15
R510_540	510	540	9.4285647832606210e+03
C510_540	510	540	7.5126495033217659e-15
R510_568	510	568	9.0244917546347697e+03
C510_568	510	568	7.8490295588803182e-15
R510_569	510	569	1.9694983596652284e+04
C510_569	510	569	3.5965250840848710e-15
R510_586	510	586	1.2313684863452027e+04
C510_586	510	586	5.7524212550086722e-15
R510_587	510	587	2.1954045452337508e+04
C510_587	510	587	3.2264441963455155e-15
R510_588	510	588	2.5503766067326393e+04
C510_588	510	588	2.7773742257911806e-15
R511_512	511	512	6.4338002647531021e+03
C511_512	511	512	1.1009589919048916e-14
R511_521	511	521	2.6880323068934158e+04
C511_521	511	521	2.6351432739237778e-15
R511_566	511	566	1.7782079319091416e+04
C511_566	511	566	3.9834206824142814e-15
R511_577	511	577	2.4029454826548201e+04
C511_577	511	577	2.9477781767125992e-15
R511_578	511	578	6.9887432665159822e+03
C511_578	511	578	1.0135370528686171e-14
R511_580	511	580	1.0557614953356047e+04
C511_580	511	580	6.7092333684212934e-15
R511_584	511	584	1.4833237706043479e+04
C511_584	511	584	4.7753230912722740e-15
R511_590	511	590	1.6601550265361813e+04
C511_590	511	590	4.2666800029988809e-15
R512_517	512	517	2.5900813364367772e+04
C512_517	512	517	2.7347983841097047e-15
R512_521	512	521	3.5807973361614211e+04
C512_521	512	521	1.9781488837883469e-15
R512_566	512	566	1.4144599708055035e+04
C512_566	512	566	5.0078124512538818e-15
R512_567	512	567	1.0336829236191581e+04
C512_567	512	567	6.8525367806208782e-15
R512_590	512	590	1.9257250690163972e+04
C512_590	512	590	3.6782770124179589e-15
R513_521	513	521	1.2420439207629790e+04
C513_521	513	521	5.7029788843930319e-15
R513_522	513	522	5.6357890323110943e+04
C513_522	513	522	1.2568515629292991e-15
R513_584	513	584	1.1334883039583467e+04
C513_584	513	584	6.2491604270318965e-15
R513_585	513	585	3.7241756792752225e+04
C513_585	513	585	1.9019914374658397e-15
R513_592	513	592	2.4497365736804917e+04
C513_592	513	592	2.8914742628665387e-15
R514_515	514	515	2.8364362437305757e+04
C514_515	514	515	2.4972710982862575e-15
R514_516	514	516	1.8925258601748683e+04
C514_516	514	516	3.7428023588251017e-15
R514_518	514	518	1.2626085271324569e+04
C514_518	514	518	5.6100922030735709e-15
R514_567	514	567	3.0785460285547593e+04
C514_567	514	567	2.3008752144353414e-15
R514_568	514	568	2.8387887902622952e+04
C514_568	514	568	2.4952015725500738e-15
R514_587	514	587	1.8455174584869415e+04
C514_587	514	587	3.8381377651162017e-15
R514_588	514	588	9.8002642860458054e+03
C514_588	514	588	7.2277135053242331e-15
R514_593	514	593	2.5515168212211353e+04
C514_593	514	593	2.7761330807962177e-15
R515_516	515	516	2.1425168269516744e+04
C515_516	515	516	3.3060885051148170e-15
R515_518	515	518	2.1340599933144527e+04
C515_518	515	518	3.3191898427366624e-15
R515_519	515	519	1.7022171403684122e+04
C515_519	515	519	4.1612495172425221e-15
R515_520	515	520	2.3784607883191125e+04
C515_520	515	520	2.9781236202787650e-15
R515_593	515	593	4.8006151612562804e+04
C515_593	515	593	1.4755088703561794e-15
R516_519	516	519	5.3539075013850575e+04
C516_519	516	519	1.3230243988652279e-15
R516_587	516	587	6.2739558454400394e+04
C516_587	516	587	1.1290086236020032e-15
R516_593	516	593	3.6833706259007908e+04
C516_593	516	593	1.9230620464286628e-15
R517_518	517	518	2.0212535788698315e+04
C517_518	517	518	3.5044342420215287e-15
R517_520	517	520	1.8078844480784159e+04
C517_520	517	520	3.9180326271011569e-15
R517_521	517	521	2.2255954302781236e+04
C517_521	517	521	3.1826764906301158e-15
R517_523	517	523	1.7184091379483012e+04
C517_523	517	523	4.1220394475189910e-15
R517_524	517	524	2.9325854204696891e+04
C517_524	517	524	2.4153943493538606e-15
R517_567	517	567	3.4223696010120424e+04
C517_567	517	567	2.0697210060261627e-15
R517_590	517	590	6.4176753366090677e+04
C517_590	517	590	1.1037252403831726e-15
R517_591	517	591	2.6463028942775480e+04
C517_591	517	591	2.6766967110670776e-15
R517_594	517	594	4.6699515793859995e+04
C517_594	517	594	1.5167930830090774e-15
R518_520	518	520	9.7328797995194182e+03
C518_520	518	520	7.2777537578854683e-15
R518_567	518	567	6.6479717382824228e+03
C518_567	518	567	1.0654904281271904e-14
R518_588	518	588	1.7119140401778834e+04
C518_588	518	588	4.1376786961008728e-15
R518_591	518	591	2.7369703475838236e+04
C518_591	518	591	2.5880259389193342e-15
R518_593	518	593	3.1977296551221792e+04
C518_593	518	593	2.2151185426991202e-15
R518_594	518	594	2.4917291065058689e+04
C518_594	518	594	2.8427449176178397e-15
R519_520	519	520	3.1194632926942781e+04
C519_520	519	520	2.2706951770162094e-15
R519_524	519	524	6.0500848854786396e+04
C519_524	519	524	1.1707852679226692e-15
R519_526	519	526	6.9735687258645863e+04
C519_526	519	526	1.0157425175044509e-15
R519_593	519	593	8.0867441220431865e+04
C519_593	519	593	8.7592115525108647e-16
R519_595	519	595	7.2211977624441832e+04
C519_595	519	595	9.8091071407002654e-16
R520_524	520	524	1.6400701612763260e+04
C520_524	520	524	4.3189312389462877e-15
R520_523	520	523	2.2605959745499411e+04
C520_523	520	523	3.1333994810860509e-15
R520_593	520	593	2.6036323336154197e+04
C520_593	520	593	2.7205647134378674e-15
R520_594	520	594	1.2259644653711357e+04
C520_594	520	594	5.7777777853093488e-15
R520_595	520	595	2.1961694572749009e+04
C520_595	520	595	3.2253204460776527e-15
R521_522	521	522	3.1056684336968916e+04
C521_522	521	522	2.2807812246615780e-15
R521_523	521	523	3.0357885406495498e+04
C521_523	521	523	2.3332818339463189e-15
R521_584	521	584	3.8913585315547971e+04
C521_584	521	584	1.8202769537069207e-15
R521_590	521	590	2.5010073607099152e+04
C521_590	521	590	2.8321988830890041e-15
R521_591	521	591	7.3442224015309752e+04
C521_591	521	591	9.6447926905418967e-16
R521_592	521	592	3.3700037371359911e+04
C521_592	521	592	2.1018820173831052e-15
R521_596	521	596	6.2616211703416870e+04
C521_596	521	596	1.1312326410212187e-15
R522_523	522	523	2.2417155631115882e+04
C522_523	522	523	3.1597899261439020e-15
R522_525	522	525	6.5816125188711405e+04
C522_525	522	525	1.0762332533691787e-15
R522_592	522	592	6.7967452718256973e+04
C522_592	522	592	1.0421679745689981e-15
R522_597	522	597	7.6268239225588593e+04
C522_597	522	597	9.2874180989659991e-16
R523_524	523	524	2.1018781797628471e+04
C523_524	523	524	3.3700098901065744e-15
R523_525	523	525	4.3046954870458729e+04
C523_525	523	525	1.6454939205144560e-15
R523_591	523	591	4.0826510789993983e+04
C523_591	523	591	1.7349879077435225e-15
R523_592	523	592	6.9750584224598293e+04
C523_592	523	592	1.0155255805157803e-15
R523_594	523	594	1.9011849092472086e+04
C523_594	523	594	3.7257555638839543e-15
R523_595	523	595	4.9713060366242593e+04
C523_595	523	595	1.4248469519711796e-15
R523_596	523	596	2.0872915459032181e+04
C523_596	523	596	3.3935605533892361e-15
R523_597	523	597	1.3009680832178195e+04
C523_597	523	597	5.4446764259427580e-15
R523_598	523	598	8.3240314346303363e+04
C523_598	523	598	8.5095188662205797e-16
R524_525	524	525	3.9410988323053105e+04
C524_525	524	525	1.7973033803510727e-15
R524_526	524	526	2.5833896418246528e+04
C524_526	524	526	2.7418822692952410e-15
R524_595	524	595	7.0053776446961667e+04
C524_595	524	595	1.0111303933718501e-15
R524_598	524	598	9.4817229482132432e+04
C524_598	524	598	7.4705307171359622e-16
R525_526	525	526	6.2241454574476193e+04
C525_526	525	526	1.1380438169426591e-15
R525_527	525	527	6.1295835807677642e+04
C525_527	525	527	1.1556005657259958e-15
R525_597	525	597	9.5284099264853823e+04
C525_597	525	597	7.4339268652904628e-16
R525_598	525	598	3.9064935174870508e+04
C525_598	525	598	1.8132246276339765e-15
R526_527	526	527	4.2988573677248620e+04
C526_527	526	527	1.6477286049964504e-15
R526_595	526	595	6.9819034410084598e+04
C526_595	526	595	1.0145299649943150e-15
R526_598	526	598	4.0804546619310247e+04
C526_598	526	598	1.7359218127540454e-15
R527_598	527	598	1.9937229163308788e+05
C527_598	527	598	3.5528258192646702e-16
R528_532	528	532	3.6634992715953980e+04
C528_532	528	532	1.9334930154129143e-15
R528_529	528	529	4.3521558035789254e+04
C528_529	528	529	1.6275497875731201e-15
R528_581	528	581	4.3067371491696846e+04
C528_581	528	581	1.6447138537269757e-15
R528_534	528	534	1.4219018907192216e+05
C528_534	528	534	4.9816026688150223e-16
R528_601	528	601	3.6749403796715109e+04
C528_601	528	601	1.9274735157018128e-15
R529_532	529	532	2.4818224604921856e+04
C529_532	529	532	2.8540922513028024e-15
R529_530	529	530	2.5853859611145672e+04
C529_530	529	530	2.7397651105625833e-15
R529_575	529	575	2.1589878982005237e+04
C529_575	529	575	3.2808661222713864e-15
R529_579	529	579	3.1394035947252840e+04
C529_579	529	579	2.2562725816779973e-15
R529_581	529	581	3.6172805124983563e+04
C529_581	529	581	1.9581976651038671e-15
R529_582	529	582	2.2315723569710564e+04
C529_582	529	582	3.1741521763669493e-15
R529_599	529	599	4.4250545515155216e+04
C529_599	529	599	1.6007373855253490e-15
R529_600	529	600	2.1880303366901495e+04
C529_600	529	600	3.2373181188680602e-15
R529_601	529	601	3.2027267834263028e+04
C529_601	529	601	2.2116623529223361e-15
R529_603	529	603	5.7749205809687868e+04
C529_603	529	603	1.2265710245337636e-15
R530_531	530	531	4.3360877358098653e+04
C530_531	530	531	1.6335809340529917e-15
R530_532	530	532	6.5461145801869854e+04
C530_532	530	532	1.0820693965606802e-15
R530_551	530	551	2.5248773463652291e+04
C530_551	530	551	2.8054235045504580e-15
R530_553	530	553	3.0902101183688759e+04
C530_553	530	553	2.2921904926448327e-15
R530_575	530	575	4.9537013295648714e+04
C530_575	530	575	1.4299106430427845e-15
R530_599	530	599	3.2633815247883340e+04
C530_599	530	599	2.1705553579302790e-15
R530_603	530	603	6.0863613336642775e+04
C530_603	530	603	1.1638070540474286e-15
R531_532	531	532	7.0369040235420442e+04
C531_532	531	532	1.0066003785048894e-15
R531_552	531	552	4.9971966650785704e+04
C531_552	531	552	1.4174647764215280e-15
R531_553	531	553	1.6403528321203044e+04
C531_553	531	553	4.3181869869082559e-15
R531_554	531	554	7.7103769013376645e+04
C531_554	531	554	9.1867756197120762e-16
R531_555	531	555	6.8708219366519537e+04
C531_555	531	555	1.0309320076851837e-15
R531_603	531	603	5.2358361391290520e+04
C531_603	531	603	1.3528594221396451e-15
R531_533	531	533	8.3750611858435746e+04
C531_533	531	533	8.4576698562788268e-16
R532_534	532	534	5.8177586170049741e+04
C532_534	532	534	1.2175393858548505e-15
R532_601	532	601	5.7338849403468688e+04
C532_601	532	601	1.2353492138911836e-15
R532_603	532	603	3.9408160980262553e+04
C532_603	532	603	1.7974323280773417e-15
R532_533	532	533	6.2257085637409364e+04
C532_533	532	533	1.1377580850562205e-15
R533_603	533	603	3.9579230595864319e+04
C533_603	533	603	1.7896634540288784e-15
R533_534	533	534	7.5329822663523955e+04
C533_534	533	534	9.4031155300062672e-16
R533_554	533	554	1.0633350585970044e+05
C533_554	533	554	6.6614471105147068e-16
R533_604	533	604	1.5569182820008800e+05
C533_604	533	604	4.5495966843531467e-16
R534_601	534	601	5.4074195467332735e+04
C534_601	534	601	1.3099316952166564e-15
R534_603	534	603	4.9148798210729699e+04
C534_603	534	603	1.4412051792659358e-15
R534_604	534	604	9.9950086637370128e+04
C534_604	534	604	7.0868875574857399e-16
R534_606	534	606	4.9259902952180004e+04
C534_606	534	606	1.4379545693535569e-15
R535_536	535	536	1.5914511283460488e+04
C535_536	535	536	4.4508751336659214e-15
R535_539	535	539	4.0260729673206333e+04
C535_539	535	539	1.7593695670930666e-15
R535_540	535	540	1.5476026033978922e+04
C535_540	535	540	4.5769826427326426e-15
R535_541	535	541	3.8491165715379939e+04
C535_541	535	541	1.8402535028368093e-15
R535_547	535	547	3.9339875738758048e+04
C535_547	535	547	1.8005522693152313e-15
R535_548	535	548	2.5742141261355875e+04
C535_548	535	548	2.7516554204577900e-15
R535_607	535	607	4.6249950002214551e+04
C535_607	535	607	1.5315368456097435e-15
R536_537	536	537	3.2799785186601126e+04
C536_537	536	537	2.1595721475924743e-15
R536_541	536	541	1.9277246906161974e+04
C536_541	536	541	3.6744615494527939e-15
R536_542	536	542	2.9939555362888732e+04
C536_542	536	542	2.3658835836887860e-15
R536_544	536	544	1.4193906828829366e+04
C536_544	536	544	4.9904161969084843e-15
R536_547	536	547	2.6489280827067036e+04
C536_547	536	547	2.6740440028715906e-15
R536_607	536	607	4.6144131334335478e+04
C536_607	536	607	1.5350489972988907e-15
R537_538	537	538	8.3041308651397758e+03
C537_538	537	538	8.5299116411272691e-15
R537_542	537	542	9.5103115597482101e+03
C537_542	537	542	7.4480738187167620e-15
R537_544	537	544	2.9522022774370944e+04
C537_544	537	544	2.3993444852123393e-15
R537_547	537	547	9.7498625237163833e+03
C537_547	537	547	7.2650770576199071e-15
R537_562	537	562	3.8991182473896064e+04
C537_562	537	562	1.8166543829087984e-15
R537_608	537	608	2.8114430825278690e+04
C537_608	537	608	2.5194713339994444e-15
R538_542	538	542	2.9225223630269127e+04
C538_542	538	542	2.4237112239796986e-15
R538_558	538	558	2.6958990708142195e+04
C538_558	538	558	2.6274537983577689e-15
R538_562	538	562	1.4661655794838482e+04
C538_562	538	562	4.8312075748590671e-15
R538_563	538	563	1.0751751895620318e+04
C538_563	538	563	6.5880893852148647e-15
R538_608	538	608	2.8217515313450367e+04
C538_608	538	608	2.5102671779976310e-15
R539_540	539	540	1.1500382852878931e+04
C539_540	539	540	6.1592299527896162e-15
R539_548	539	548	1.5289349519935533e+04
C539_548	539	548	4.6328656718614063e-15
R539_568	539	568	1.8882536169825933e+04
C539_568	539	568	3.7512705866911622e-15
R539_566	539	566	5.0991363162048772e+04
C539_566	539	566	1.3891274549945567e-15
R539_574	539	574	2.7673097822363390e+04
C539_574	539	574	2.5596520848763635e-15
R539_576	539	576	1.1156555156542598e+04
C539_576	539	576	6.3490478505330346e-15
R539_583	539	583	3.0642653076622461e+04
C539_583	539	583	2.3115982274406744e-15
R539_586	539	586	4.9631603955838800e+04
C539_586	539	586	1.4271854401285566e-15
R539_609	539	609	1.1363064674501124e+04
C539_609	539	609	6.2336618302412203e-15
R540_541	540	541	4.6291144193096232e+04
C540_541	540	541	1.5301739408412372e-15
R540_548	540	548	5.4257398638861625e+04
C540_548	540	548	1.3055086368491287e-15
R540_568	540	568	5.3736114293201907e+04
C540_568	540	568	1.3181731404974526e-15
R540_569	540	569	1.3503280950905470e+04
C540_569	540	569	5.2456512453182905e-15
R540_586	540	586	2.5336374647614346e+04
C540_586	540	586	2.7957236787493444e-15
R540_607	540	607	2.2541332555240977e+04
C540_607	540	607	3.1423831027918030e-15
R540_609	540	609	4.6099980159613449e+04
C540_609	540	609	1.5365191544714529e-15
R541_542	541	542	4.4659265455621084e+04
C541_542	541	542	1.5860874963648668e-15
R541_543	541	543	2.1913107312415468e+04
C541_543	541	543	3.2324718501180963e-15
R541_544	541	544	2.0854023772587458e+04
C541_544	541	544	3.3966347841758199e-15
R541_569	541	569	1.7575435235134664e+04
C541_569	541	569	4.0302559560174271e-15
R541_570	541	570	1.9158648849618858e+04
C541_570	541	570	3.6972076210587874e-15
R541_571	541	571	2.9702153885946453e+04
C541_571	541	571	2.3847934667631909e-15
R541_607	541	607	1.9902342722742895e+04
C541_607	541	607	3.5590535005236769e-15
R541_610	541	610	4.8614073202374071e+04
C541_610	541	610	1.4570575528845185e-15
R542_543	542	543	3.1460113293890099e+04
C542_543	542	543	2.2515336125555735e-15
R542_544	542	544	1.1573562829596796e+04
C542_544	542	544	6.1202849614173409e-15
R542_563	542	563	6.1639486984128685e+04
C542_563	542	563	1.1491578856624593e-15
R542_565	542	565	2.8326534321370422e+04
C542_565	542	565	2.5006060301051723e-15
R542_608	542	608	2.6547263969780211e+04
C542_608	542	608	2.6682034960978483e-15
R542_610	542	610	3.5184934230759114e+04
C542_610	542	610	2.0131770624165743e-15
R543_544	543	544	9.0689388146165948e+04
C543_544	543	544	7.8105612998332478e-16
R543_565	543	565	7.7360614782271019e+04
C543_565	543	565	9.1562745119539990e-16
R543_570	543	570	1.0036275455222135e+05
C543_570	543	570	7.0577479516211856e-16
R543_571	543	571	4.4742030929724133e+04
C543_571	543	571	1.5831534926802378e-15
R543_610	543	610	5.2589932411662980e+04
C543_610	543	610	1.3469023306881281e-15
R544_547	544	547	4.6364312900244906e+04
C544_547	544	547	1.5277591342376142e-15
R544_607	544	607	1.7961972376310190e+04
C544_607	544	607	3.9435258585199356e-15
R544_608	544	608	2.3523663745309605e+04
C544_608	544	608	3.0111594564058305e-15
R544_610	544	610	1.4039691067931482e+04
C544_610	544	610	5.0452322770686265e-15
R545_546	545	546	1.6566439791400255e+04
C545_546	545	546	4.2757226916534078e-15
R545_549	545	549	4.4381775868241675e+04
C545_549	545	549	1.5960042416122975e-15
R545_550	545	550	4.4424319347337390e+04
C545_550	545	550	1.5944758091211023e-15
R545_551	545	551	1.8184177749385039e+04
C545_551	545	551	3.8953371173681751e-15
R545_552	545	552	1.3527452112633853e+04
C545_552	545	552	5.2362781953480836e-15
R545_572	545	572	3.3915876326291967e+04
C545_572	545	572	2.0885057444642558e-15
R545_612	545	612	2.0957848908979813e+04
C545_612	545	612	3.3798078630889446e-15
R546_549	546	549	1.6551309467778348e+04
C546_549	546	549	4.2796313291040081e-15
R546_552	546	552	1.6232461906934892e+04
C546_552	546	552	4.3636943639299872e-15
R546_556	546	556	2.2026659385658626e+04
C546_556	546	556	3.2158077761950187e-15
R546_612	546	612	2.8305725875631008e+04
C546_612	546	612	2.5024443056937129e-15
R547_548	547	548	2.1568231568817151e+04
C547_548	547	548	3.2841590331591874e-15
R547_550	547	550	2.7290972502176879e+04
C547_550	547	550	2.5954920635514154e-15
R547_562	547	562	3.4384828050958713e+04
C547_562	547	562	2.0600220082829538e-15
R547_607	547	607	2.9425644819086505e+04
C547_607	547	607	2.4072030696861706e-15
R547_608	547	608	3.1558609056632205e+04
C547_608	547	608	2.2445064802725831e-15
R547_614	547	614	3.1553891547564624e+04
C547_614	547	614	2.2448420483801475e-15
R548_550	548	550	5.3387644820297479e+04
C548_550	548	550	1.3267770618918515e-15
R548_572	548	572	2.4964610213736658e+04
C548_572	548	572	2.8373566392406242e-15
R548_574	548	574	1.2575035916508903e+04
C548_574	548	574	5.6328668169454345e-15
R548_607	548	607	3.7802232160899068e+04
C548_607	548	607	1.8737915325875124e-15
R548_609	548	609	1.3627247824423417e+04
C548_609	548	609	5.1979316329045379e-15
R548_611	548	611	3.6940198649362748e+04
C548_611	548	611	1.9175181814357126e-15
R548_614	548	614	3.0971491603972139e+04
C548_614	548	614	2.2870549291502488e-15
R549_550	549	550	1.5557898479156234e+04
C549_550	549	550	4.5528965644620656e-15
R549_556	549	556	5.0651588216328171e+04
C549_556	549	556	1.3984458341854315e-15
R549_557	549	557	1.7326322489873008e+04
C549_557	549	557	4.0882017853125618e-15
R549_562	549	562	3.1201369021492661e+04
C549_562	549	562	2.2702049543789976e-15
R549_612	549	612	1.5172804542740188e+04
C549_612	549	612	4.6684515269717950e-15
R549_615	549	615	4.5498550661624693e+04
C549_615	549	615	1.5568298661377766e-15
R550_562	550	562	2.6819412650211136e+04
C550_562	550	562	2.6411280313941688e-15
R550_572	550	572	1.5447971081540583e+04
C550_572	550	572	4.5852948689580259e-15
R550_612	550	612	3.6763792987913192e+04
C550_612	550	612	1.9267191108188404e-15
R550_614	550	614	2.3965891476801629e+04
C550_614	550	614	2.9555963985134883e-15
R550_615	550	615	2.6214869958215892e+04
C550_615	550	615	2.7020352436957393e-15
R551_552	551	552	2.4360172119138511e+04
C551_552	551	552	2.9077587050524095e-15
R551_553	551	553	1.9609332091350541e+04
C551_553	551	553	3.6122343283300240e-15
R551_572	551	572	3.4087378990459612e+04
C551_572	551	572	2.0779979169364975e-15
R551_575	551	575	3.5876557422831145e+04
C551_575	551	575	1.9743673201744529e-15
R551_599	551	599	1.7446931409010791e+04
C551_599	551	599	4.0599404488640752e-15
R551_612	551	612	3.3635617214961858e+04
C551_612	551	612	2.1059076182045415e-15
R551_613	551	613	2.0669455614234987e+04
C551_613	551	613	3.4269650762943747e-15
R551_617	551	617	2.4120036436266349e+04
C551_617	551	617	2.9367079408510475e-15
R552_553	552	553	1.4434329448116681e+04
C552_553	552	553	4.9072942938296311e-15
R552_555	552	555	4.7777067482565530e+04
C552_555	552	555	1.4825837220304085e-15
R552_556	552	556	2.2920659834870050e+04
C552_556	552	556	3.0903779841555156e-15
R552_612	552	612	2.1386253208862316e+04
C552_612	552	612	3.3121043618172022e-15
R552_617	552	617	4.0556335776078726e+04
C552_617	552	617	1.7465459139871214e-15
R552_618	552	618	6.5552547244097397e+04
C552_618	552	618	1.0805606420180433e-15
R553_554	553	554	5.6002269215357897e+04
C553_554	553	554	1.2648327206815192e-15
R553_555	553	555	4.7282849345247443e+04
C553_555	553	555	1.4980802450967290e-15
R553_599	553	599	3.0940424299020026e+04
C553_599	553	599	2.2893513628461622e-15
R553_603	553	603	1.8685595062054628e+04
C553_603	553	603	3.7908079620029661e-15
R553_617	553	617	1.5075518106494486e+04
C553_617	553	617	4.6985783198711524e-15
R553_618	553	618	2.1933193271804063e+04
C553_618	553	618	3.2295116200457283e-15
R554_555	554	555	7.5254933704247567e+04
C554_555	554	555	9.4124729169752765e-16
R554_603	554	603	3.4751824678975383e+04
C554_603	554	603	2.0382671468429053e-15
R554_604	554	604	7.5254933704247771e+04
C554_604	554	604	9.4124729169752509e-16
R554_605	554	605	4.7802156339685789e+04
C554_605	554	605	1.4818055912091434e-15
R554_618	554	618	5.6625403728737154e+04
C554_618	554	618	1.2509138632428383e-15
R555_556	555	556	6.1988592459425243e+04
C555_556	555	556	1.1426860931285742e-15
R555_618	555	618	7.4471681293388450e+04
C555_618	555	618	9.5114681588756561e-16
R556_557	556	557	5.0839463460609499e+04
C556_557	556	557	1.3932779324251119e-15
R556_612	556	612	2.4923353250402204e+04
C556_612	556	612	2.8420534678597839e-15
R556_617	556	617	7.4174918336289629e+04
C556_617	556	617	9.5495221464025720e-16
R556_618	556	618	5.6736469156263462e+04
C556_618	556	618	1.2484651158130853e-15
R556_619	556	619	3.8925274149835430e+04
C556_619	556	619	1.8197303444373939e-15
R557_562	557	562	6.9687156026263023e+04
C557_562	557	562	1.0164498965821617e-15
R557_559	557	559	8.6676441747312143e+04
C557_559	557	559	8.1721747118439572e-16
R557_612	557	612	4.0783339949114794e+04
C557_612	557	612	1.7368244637241260e-15
R557_615	557	615	3.8185426795670304e+04
C557_615	557	615	1.8549878443163437e-15
R557_616	557	616	3.4045809548430116e+04
C557_616	557	616	2.0805351223985282e-15
R557_619	557	619	4.4604053487369587e+04
C557_619	557	619	1.5880507935463255e-15
R557_620	557	620	4.6722068935735879e+04
C557_620	557	620	1.5160609140281940e-15
R558_560	558	560	3.8781304246860513e+04
C558_560	558	560	1.8264858263949244e-15
R558_559	558	559	6.1886531640960187e+04
C558_559	558	559	1.1445705658049543e-15
R558_562	558	562	4.5854362438256685e+04
C558_562	558	562	1.5447494800822486e-15
R558_563	558	563	5.3485760842216696e+04
C558_563	558	563	1.3243431788314510e-15
R558_621	558	621	6.9005870998032202e+04
C558_621	558	621	1.0264851600528299e-15
R559_562	559	562	3.0991992686606241e+04
C559_562	559	562	2.2855420512089894e-15
R559_620	559	620	4.1887658985894443e+04
C559_620	559	620	1.6910351222982647e-15
R559_621	559	621	7.2516935671370811e+04
C559_621	559	621	9.7678565538125178e-16
R560_561	560	561	6.3401543085438898e+04
C560_561	560	561	1.1172204821662767e-15
R560_563	560	563	2.7715571005418427e+04
C560_563	560	563	2.5557295039006039e-15
R560_564	560	564	4.5710101164735221e+04
C560_564	560	564	1.5496247160058174e-15
R560_621	560	621	7.8622437955091518e+04
C560_621	560	621	9.0093241036941034e-16
R560_622	560	622	4.1494752426213359e+04
C560_622	560	622	1.7070472383696542e-15
R561_564	561	564	5.3331931170941483e+04
C561_564	561	564	1.3281630906813004e-15
R561_622	561	622	1.7713826743017641e+05
C561_622	561	622	3.9987690725224489e-16
R562_563	562	563	4.5125961674435268e+04
C562_563	562	563	1.5696840556448149e-15
R562_608	562	608	2.4889164069439401e+04
C562_608	562	608	2.8459574752441843e-15
R562_614	562	614	3.5367289709289995e+04
C562_614	562	614	2.0027970228488850e-15
R562_615	562	615	3.1344117917514537e+04
C562_615	562	615	2.2598658773045109e-15
R562_620	562	620	4.1279830136825520e+04
C562_620	562	620	1.7159349324165414e-15
R562_621	562	621	5.0001583207802345e+04
C562_621	562	621	1.4166251944787824e-15
R562_623	562	623	2.6257058842470946e+04
C562_623	562	623	2.6976937120400712e-15
R563_564	563	564	1.4810857991099969e+04
C563_564	563	564	4.7825387684200852e-15
R563_565	563	565	2.6532854016618396e+04
C563_565	563	565	2.6696525934087104e-15
R563_608	563	608	2.1859357348972033e+04
C563_608	563	608	3.2404201736210268e-15
R563_621	563	621	3.1453705766579758e+04
C563_621	563	621	2.2519922791184161e-15
R563_622	563	622	4.7595088992560050e+04
C563_622	563	622	1.4882523393762860e-15
R563_623	563	623	3.2782304544271276e+04
C563_623	563	623	2.1607237050812588e-15
R563_624	563	624	2.5949013242495348e+04
C563_624	563	624	2.7297185397400648e-15
R564_565	564	565	6.5324532960290235e+04
C564_565	564	565	1.0843323224225514e-15
R564_622	564	622	2.7044989864539704e+04
C564_622	564	622	2.6190988752735317e-15
R564_624	564	624	5.9542547372333407e+04
C564_624	564	624	1.1896283525301939e-15
R565_608	565	608	5.7898533072769409e+04
C565_608	565	608	1.2234075507055311e-15
R565_610	565	610	2.2209021948210811e+04
C565_610	565	610	3.1894021583290140e-15
R565_571	565	571	9.0288091959601719e+04
C565_571	565	571	7.8452762705068118e-16
R565_624	565	624	4.9752894717608877e+04
C565_624	565	624	1.4237061569591476e-15
R565_625	565	625	9.9632774019624994e+04
C565_625	565	625	7.1094580305520446e-16
R566_567	566	567	9.6376645709573659e+03
C566_567	566	567	7.3496542668078876e-15
R566_568	566	568	1.0680333107602009e+04
C566_568	566	568	6.6321435691535127e-15
R566_576	566	576	1.6772863578235498e+04
C566_576	566	576	4.2231013330313922e-15
R566_577	566	577	5.0225795548876895e+03
C566_577	566	577	1.4103012557973096e-14
R566_580	566	580	1.6692340769916344e+04
C566_580	566	580	4.2434733098463462e-15
R566_583	566	583	1.0086523413289902e+04
C566_583	566	583	7.0225884215636176e-15
R566_589	566	589	1.1013779049482635e+04
C566_589	566	589	6.4313531457059123e-15
R566_590	566	590	1.1905584070633517e+04
C566_590	566	590	5.9496033219167242e-15
R566_591	566	591	2.8230792459082004e+04
C566_591	566	591	2.5090865812097483e-15
R566_626	566	626	1.4574660487878898e+04
C566_626	566	626	4.8600447739354968e-15
R567_568	567	568	5.6186140464211394e+03
C567_568	567	568	1.2606935082348018e-14
R567_588	567	588	1.0121760116907904e+04
C567_588	567	588	6.9981408092922612e-15
R567_590	567	590	2.4321519305755497e+04
C567_590	567	590	2.9123798413053015e-15
R567_591	567	591	9.1873213071888622e+03
C567_591	567	591	7.7099189380232580e-15
R567_626	567	626	2.2303000676501670e+04
C567_626	567	626	3.1759628923219217e-15
R568_583	568	583	5.8995871864385430e+04
C568_583	568	583	1.2006518472822282e-15
R568_586	568	586	3.3307555067966045e+04
C568_586	568	586	2.1266497163019029e-15
R568_588	568	588	2.6139881019303910e+04
C568_588	568	588	2.7097867233477663e-15
R568_626	568	626	3.0236026765252867e+04
C568_626	568	626	2.3426855349063790e-15
R569_570	569	570	1.8706845823446340e+04
C569_570	569	570	3.7865016478203087e-15
R569_571	569	571	3.9763399800486535e+04
C569_571	569	571	1.7813744018722793e-15
R569_586	569	586	1.3703664174416452e+04
C569_586	569	586	5.1689461763255999e-15
R569_587	569	587	3.1766879173862631e+04
C569_587	569	587	2.2297910395390963e-15
R569_607	569	607	1.4108266068625422e+04
C569_607	569	607	5.0207092913793750e-15
R569_628	569	628	2.5135826834709660e+04
C569_628	569	628	2.8180295401377914e-15
R570_571	570	571	1.9170750049041064e+04
C570_571	570	571	3.6948738236531937e-15
R570_587	570	587	2.4518838408113996e+04
C570_587	570	587	2.8889420190704927e-15
R570_628	570	628	4.5488844184454407e+04
C570_628	570	628	1.5571620648081233e-15
R571_607	571	607	1.8592136083753205e+04
C571_607	571	607	3.8098636013049661e-15
R571_610	571	610	4.7087134251142315e+03
C571_610	571	610	1.5043069335713848e-14
R571_625	571	625	2.2370872776474072e+04
C571_625	571	625	3.1663271810517283e-15
R571_628	571	628	1.5501068729685569e+04
C571_628	571	628	4.5695883149236782e-15
R572_573	572	573	3.7979373379332254e+04
C572_573	572	573	1.8650519014235877e-15
R572_574	572	574	1.3872447465431957e+04
C572_574	572	574	5.1060566430333506e-15
R572_575	572	575	4.2154264975018617e+04
C572_575	572	575	1.6803401169010355e-15
R572_611	572	611	1.0618399279698335e+04
C572_611	572	611	6.6708268045098746e-15
R572_612	572	612	3.8491343036183098e+04
C572_612	572	612	1.8402450252103241e-15
R572_613	572	613	2.0493839512716095e+04
C572_613	572	613	3.4563314742485891e-15
R572_614	572	614	3.4808315987731999e+04
C572_614	572	614	2.0349591908141975e-15
R572_615	572	615	3.6773678744468074e+04
C572_615	572	615	1.9262011567623111e-15
R572_630	572	630	2.6091709041419741e+04
C572_630	572	630	2.7147896837096462e-15
R573_574	573	574	5.8464650364006166e+03
C573_574	573	574	1.2115612099787523e-14
R573_575	573	575	3.6106040908414379e+03
C573_575	573	575	1.9618185974938209e-14
R573_576	573	576	1.2634820508107092e+04
C573_576	573	576	5.6062135976169926e-15
R573_577	573	577	1.8493574201301079e+04
C573_577	573	577	3.8301683473936943e-15
R573_579	573	579	1.3535851957341600e+04
C573_579	573	579	5.2330287564634016e-15
R573_630	573	630	1.7949375495593256e+04
C573_630	573	630	3.9462934269434786e-15
R574_576	574	576	8.7706567835551523e+03
C574_576	574	576	8.0761913599004076e-15
R574_609	574	609	2.8763691750415877e+04
C574_609	574	609	2.4626012248575802e-15
R574_611	574	611	4.2876057813575047e+04
C574_611	574	611	1.6520525941070385e-15
R574_630	574	630	3.6069690389205520e+04
C574_630	574	630	1.9637956902784557e-15
R575_579	575	579	1.6557842284965518e+04
C575_579	575	579	4.2779428211075952e-15
R575_599	575	599	2.4812476530029668e+04
C575_599	575	599	2.8547534322207912e-15
R575_600	575	600	4.8888281990717020e+04
C575_600	575	600	1.4488850835349459e-15
R575_613	575	613	5.7105400338902509e+04
C575_613	575	613	1.2403993688097019e-15
R575_630	575	630	2.9714053527229698e+04
C575_630	575	630	2.3838384241681738e-15
R576_577	576	577	7.8234554056192092e+03
C576_577	576	577	9.0539919848106685e-15
R576_583	576	583	7.8411135065469789e+03
C576_583	576	583	9.0336024949590655e-15
R576_609	576	609	1.0947568021422698e+04
C576_609	576	609	6.4702500498183527e-15
R576_630	576	630	1.5818076914240637e+04
C576_630	576	630	4.4780097429056181e-15
R577_578	577	578	7.8188578713029739e+04
C577_578	577	578	9.0593157852344943e-16
R577_579	577	579	3.6139991354015430e+04
C577_579	577	579	1.9599756359136448e-15
R577_580	577	580	2.3523370528185023e+04
C577_580	577	580	3.0111969902922440e-15
R577_583	577	583	2.8211847353839683e+04
C577_583	577	583	2.5107715084230190e-15
R577_589	577	589	6.3401335744832708e+04
C577_589	577	589	1.1172241357986379e-15
R577_630	577	630	6.8513040846000396e+04
C577_630	577	630	1.0338689052674717e-15
R577_631	577	631	4.8246685861202022e+04
C577_631	577	631	1.4681527087638028e-15
R578_579	578	579	1.1970861478090643e+04
C578_579	578	579	5.9171599859910800e-15
R578_580	578	580	1.5052673459157777e+04
C578_580	578	580	4.7057091039802078e-15
R578_582	578	582	2.9111966899425679e+04
C578_582	578	582	2.4331403913968244e-15
R578_584	578	584	1.9641548682296350e+04
C578_584	578	584	3.6063094454382218e-15
R578_585	578	585	4.1622921256835842e+04
C578_585	578	585	1.7017907536791842e-15
R578_632	578	632	3.5235593239330257e+04
C578_632	578	632	2.0102826722649036e-15
R579_580	579	580	4.8698708193102000e+04
C579_580	579	580	1.4545252875112883e-15
R579_582	579	582	2.7338322753598350e+04
C579_582	579	582	2.5909966450548506e-15
R579_600	579	600	4.6021132914681046e+04
C579_600	579	600	1.5391516472947073e-15
R579_630	579	630	8.0282076069607880e+04
C579_630	579	630	8.8230780771768314e-16
R579_631	579	631	4.9294491394615470e+04
C579_631	579	631	1.4369456004517635e-15
R579_632	579	632	4.5419595926647482e+04
C579_632	579	632	1.5595361669530464e-15
R580_584	580	584	1.6050720986214073e+04
C580_584	580	584	4.4131040964975174e-15
R580_589	580	589	1.4833408225872236e+04
C580_589	580	589	4.7752681957780380e-15
R580_590	580	590	1.2063024676398933e+04
C580_590	580	590	5.8719520548262115e-15
R580_631	580	631	2.3338274976182551e+04
C580_631	580	631	3.0350787540333573e-15
R580_632	580	632	9.3473500626074874e+03
C580_632	580	632	7.5779233752416739e-15
R581_582	581	582	1.6400146559016655e+04
C581_582	581	582	4.3190774107476725e-15
R581_585	581	585	9.0059848141023671e+04
C581_585	581	585	7.8651590023872386e-16
R581_601	581	601	8.9537695152967353e+04
C581_601	581	601	7.9110258997606695e-16
R581_634	581	634	1.2798097120305966e+05
C581_634	581	634	5.5346901863725332e-16
R582_585	582	585	2.0415003888606898e+04
C582_585	582	585	3.4696786208074345e-15
R582_600	582	600	1.7870043701538209e+04
C582_600	582	600	3.9638124964351837e-15
R582_601	582	601	4.8084987992786417e+04
C582_601	582	601	1.4730897415764408e-15
R582_632	582	632	1.5965560666048439e+04
C582_632	582	632	4.4366435991584680e-15
R582_634	582	634	1.8147212750445771e+04
C582_634	582	634	3.9032717315919510e-15
R583_586	583	586	4.3909329643368168e+04
C583_586	583	586	1.6131765871014234e-15
R583_589	583	589	2.3162478386027808e+04
C583_589	583	589	3.0581141342253157e-15
R583_609	583	609	1.7427274944411980e+04
C583_609	583	609	4.0645197118848830e-15
R583_626	583	626	1.5167243911220792e+04
C583_626	583	626	4.6701630797667255e-15
R583_627	583	627	1.3888733330258494e+04
C583_627	583	627	5.1000693044973073e-15
R583_630	583	630	1.8343879441537647e+04
C583_630	583	630	3.8614243383875237e-15
R583_631	583	631	2.9866186661491869e+04
C583_631	583	631	2.3716955679289844e-15
R583_635	583	635	1.4282220089239794e+04
C583_635	583	635	4.9595582544877516e-15
R584_585	584	585	9.6455630919109662e+03
C584_585	584	585	7.3436358106871865e-15
R584_590	584	590	1.0777729349749325e+04
C584_590	584	590	6.5722101787281846e-15
R584_592	584	592	1.5745615988395177e+04
C584_592	584	592	4.4986174302869862e-15
R584_632	584	632	1.7978916698039196e+04
C584_632	584	632	3.9398092624638056e-15
R584_637	584	637	3.6329053242753478e+04
C584_637	584	637	1.9497756262098321e-15
R585_592	585	592	1.0829639107753315e+05
C585_592	585	592	6.5407075740213575e-16
R585_632	585	632	1.8413102931901409e+04
C585_632	585	632	3.8469074331452441e-15
R585_634	585	634	8.0494770301259676e+04
C585_634	585	634	8.7997645400935469e-16
R585_637	585	637	4.5082576870891244e+04
C585_637	585	637	1.5711946266704094e-15
R586_587	586	587	2.0819324088971778e+04
C586_587	586	587	3.4022959743213418e-15
R586_588	586	588	2.3347296401131214e+04
C586_588	586	588	3.0339059957523828e-15
R586_607	586	607	3.0514728638866483e+04
C586_607	586	607	2.3212889544028146e-15
R586_609	586	609	2.3554038080069495e+04
C586_609	586	609	3.0072763869706298e-15
R586_626	586	626	2.2807779512959594e+04
C586_626	586	626	3.1056728909428364e-15
R586_627	586	627	1.9505686065015678e+04
C586_627	586	627	3.6314284101518007e-15
R586_628	586	628	2.0523328005637894e+04
C586_628	586	628	3.4513653203097265e-15
R586_629	586	629	9.4069210965127113e+03
C586_629	586	629	7.5299348011177729e-15
R586_638	586	638	2.0521289415534298e+04
C586_638	586	638	3.4517081798174029e-15
R587_588	587	588	3.9887510505062484e+04
C587_588	587	588	1.7758316234604285e-15
R587_593	587	593	6.3822222509556559e+04
C587_593	587	593	1.1098564066049816e-15
R587_628	587	628	7.0452946458293140e+04
C587_628	587	628	1.0054015636937507e-15
R587_638	587	638	6.2248050843812547e+04
C587_638	587	638	1.1379232213026130e-15
R588_591	588	591	2.9734998733125060e+04
C588_591	588	591	2.3821592585807250e-15
R588_593	588	593	2.2951929626903406e+04
C588_593	588	593	3.0861676419995465e-15
R588_594	588	594	4.9976218154878596e+04
C588_594	588	594	1.4173441919211200e-15
R588_626	588	626	1.6433368684495068e+04
C588_626	588	626	4.3103458515375257e-15
R588_638	588	638	4.2621442240096061e+04
C588_638	588	638	1.6619217655043001e-15
R588_639	588	639	3.8221673633213526e+04
C588_639	588	639	1.8532286999187743e-15
R589_590	589	590	1.3971049477347920e+04
C589_590	589	590	5.0700201621106915e-15
R589_591	589	591	3.1992029048331093e+04
C589_591	589	591	2.2140984689964550e-15
R589_626	589	626	1.4879156297167096e+04
C589_626	589	626	4.7605859580550455e-15
R589_631	589	631	1.3078379377317382e+04
C589_631	589	631	5.4160764489559600e-15
R589_632	589	632	2.6246612511606771e+04
C589_632	589	632	2.6987674125442294e-15
R589_635	589	635	2.1607084002067404e+04
C589_635	589	635	3.2782536750087391e-15
R589_636	589	636	1.6958691644083072e+04
C589_636	589	636	4.1768259027643781e-15
R589_637	589	637	4.4514318351304777e+04
C589_637	589	637	1.5912520995376261e-15
R589_639	589	639	4.2529053933795309e+04
C589_639	589	639	1.6655320535995472e-15
R589_640	589	640	2.1526266757388199e+04
C589_640	589	640	3.2905614026960186e-15
R589_641	589	641	1.2871540752222927e+04
C589_641	589	641	5.5031098373958830e-15
R590_591	590	591	9.9836068522356800e+03
C590_591	590	591	7.0949811610558270e-15
R590_592	590	592	2.2281470256568733e+04
C590_592	590	592	3.1790318017778834e-15
R590_596	590	596	2.2500460458283127e+04
C590_596	590	596	3.1480912431693797e-15
R590_632	590	632	3.7920990884269188e+04
C590_632	590	632	1.8679233027474491e-15
R590_637	590	637	3.8527448524917956e+04
C590_637	590	637	1.8385204639281483e-15
R590_641	590	641	2.0337432040806281e+04
C590_641	590	641	3.4829128079629374e-15
R591_594	591	594	6.9521231708982423e+03
C591_594	591	594	1.0188758282147642e-14
R591_596	591	596	9.2331106185640656e+03
C591_596	591	596	7.6716835162336706e-15
R591_626	591	626	2.7727922351279372e+04
C591_626	591	626	2.5545910594607435e-15
R591_639	591	639	9.7786084702660119e+03
C591_639	591	639	7.2437200805599998e-15
R591_641	591	641	3.2252233577095205e+04
C591_641	591	641	2.1962355682027658e-15
R592_596	592	596	2.1797482823343835e+04
C592_596	592	596	3.2496184587030145e-15
R592_597	592	597	7.1437098717686153e+04
C592_597	592	597	9.9155066215564682e-16
R592_637	592	637	4.4076631616711944e+04
C592_637	592	637	1.6070534416505417e-15
R592_641	592	641	4.5919905839905558e+04
C592_641	592	641	1.5425445945589005e-15
R592_642	592	642	5.9710197164468445e+04
C592_642	592	642	1.1862882036864327e-15
R593_594	593	594	3.2262943498014443e+04
C593_594	593	594	2.1955065116845059e-15
R593_595	593	595	6.6211613872493064e+04
C593_595	593	595	1.0698048030124676e-15
R593_638	593	638	7.4636734513883377e+04
C593_638	593	638	9.4904343011984366e-16
R593_639	593	639	6.4268021884423062e+04
C593_639	593	639	1.1021578144008234e-15
R593_643	593	643	6.6256968223144548e+04
C593_643	593	643	1.0690724981173647e-15
R594_595	594	595	1.5357682921264875e+04
C594_595	594	595	4.6122519197164215e-15
R594_596	594	596	1.3406297553978473e+04
C594_596	594	596	5.2835991630649260e-15
R594_597	594	597	4.2730858270632649e+04
C594_597	594	597	1.6576662721675611e-15
R594_639	594	639	9.6554261398073995e+03
C594_639	594	639	7.3361342638174829e-15
R594_643	594	643	3.6856333239254716e+04
C594_643	594	643	1.9218814328647619e-15
R594_644	594	644	4.4735967182906847e+04
C594_644	594	644	1.5833680815794406e-15
R595_597	595	597	7.1665887292508763e+04
C595_597	595	597	9.8838520266816301e-16
R595_598	595	598	4.9917024499118190e+04
C595_598	595	598	1.4190249368179247e-15
R595_643	595	643	1.0703397156710783e+05
C595_643	595	643	6.6178523975996749e-16
R595_644	595	644	6.1212409274907848e+04
C595_644	595	644	1.1571755363832090e-15
R596_597	596	597	2.5386767128942345e+04
C596_597	596	597	2.7901741949350383e-15
R596_639	596	639	1.9506666366697009e+04
C596_639	596	639	3.6312459138036703e-15
R596_641	596	641	2.2058153351144578e+04
C596_641	596	641	3.2112163429276600e-15
R596_642	596	642	2.6297535327311358e+04
C596_642	596	642	2.6935414917927966e-15
R596_644	596	644	7.8190301692035908e+04
C596_644	596	644	9.0591161567566594e-16
R597_598	597	598	7.9166939961531069e+04
C597_598	597	598	8.9473589064348762e-16
R597_642	597	642	1.1779525710516091e+05
C597_642	597	642	6.0132728835392649e-16
R597_644	597	644	4.9887664941657808e+04
C597_644	597	644	1.4198600519554834e-15
R598_644	598	644	2.3836573911009528e+05
C598_644	598	644	2.9716310238395355e-16
R599_600	599	600	1.1901931843357057e+04
C599_600	599	600	5.9514290174275379e-15
R599_602	599	602	1.3805571560626229e+04
C599_602	599	602	5.1307910161444247e-15
R599_603	599	603	1.9699248153992899e+04
C599_603	599	603	3.5957464966317792e-15
R599_613	599	613	9.5935865216415095e+03
C599_613	599	613	7.3834224954568963e-15
R599_617	599	617	1.3339081323479695e+04
C599_617	599	617	5.3102234567921546e-15
R599_630	599	630	3.3552482303427045e+04
C599_630	599	630	2.1111255464030180e-15
R599_645	599	645	2.0123131498478499e+04
C599_645	599	645	3.5200039586957783e-15
R600_601	600	601	4.2596742747375290e+04
C600_601	600	601	1.6628854219226565e-15
R600_602	600	602	1.7040947094665757e+04
C600_602	600	602	4.1566646585137678e-15
R600_603	600	603	5.4434812599556084e+04
C600_603	600	603	1.3012537226329618e-15
R600_630	600	630	3.7249190493397931e+04
C600_630	600	630	1.9016118631773915e-15
R600_631	600	631	4.7653728084089256e+04
C600_631	600	631	1.4864210080480582e-15
R600_632	600	632	4.6130283886673125e+04
C600_632	600	632	1.5355097902717125e-15
R600_633	600	633	1.2828336237440068e+04
C600_633	600	633	5.5216437443594059e-15
R600_634	600	634	2.2687665467202492e+04
C600_634	600	634	3.1221150822413882e-15
R600_645	600	645	4.2171844308510910e+04
C600_645	600	645	1.6796396671156436e-15
R600_646	600	646	4.8475747259832802e+04
C600_646	600	646	1.4612152785665861e-15
R601_603	601	603	2.7700099503769365e+04
C601_603	601	603	2.5571569707307783e-15
R601_606	601	606	4.7254230382139351e+04
C601_606	601	606	1.4989875395954579e-15
R601_634	601	634	6.3565211680701526e+04
C601_634	601	634	1.1143438472573377e-15
R601_646	601	646	5.0698601002528216e+04
C601_646	601	646	1.3971490560946193e-15
R602_603	602	603	3.4872537834529598e+04
C602_603	602	603	2.0312115760575101e-15
R602_617	602	617	4.6933683890699474e+04
C602_617	602	617	1.5092252869167296e-15
R602_645	602	645	1.1599896722198297e+04
C602_645	602	645	6.1063907922946024e-15
R602_633	602	633	4.9602081463471266e+04
C602_633	602	633	1.4280348817249595e-15
R602_646	602	646	3.0505624067495392e+04
C602_646	602	646	2.3219817558649820e-15
R602_647	602	647	1.6950954656503709e+04
C602_647	602	647	4.1787323470199221e-15
R602_648	602	648	1.9503174769465168e+04
C602_648	602	648	3.6318960053057290e-15
R603_604	603	604	5.8440010588216457e+04
C603_604	603	604	1.2120720346050469e-15
R603_605	603	605	2.6355876808029425e+04
C603_605	603	605	2.6875790569191116e-15
R603_606	603	606	2.1892525418164514e+04
C603_606	603	606	3.2355108048534465e-15
R603_617	603	617	3.9042609703286093e+04
C603_617	603	617	1.8142614716156685e-15
R603_618	603	618	3.8864830511244370e+04
C603_618	603	618	1.8225604384279111e-15
R603_646	603	646	2.8423390090549408e+04
C603_646	603	646	2.4920849451927861e-15
R603_647	603	647	4.2081968886095878e+04
C603_647	603	647	1.6832269119281586e-15
R603_649	603	649	4.9428202531021212e+04
C603_649	603	649	1.4330584344341634e-15
R603_650	603	650	4.7971236320124088e+04
C603_650	603	650	1.4765828018963340e-15
R604_605	604	605	5.0789797505142975e+04
C604_605	604	605	1.3946403808526193e-15
R604_606	604	606	5.6440793281050028e+04
C604_606	604	606	1.2550054387662609e-15
R604_650	604	650	5.6582165667065208e+04
C604_650	604	650	1.2518697667528495e-15
R605_618	605	618	5.5221448811165996e+04
C605_618	605	618	1.2827172061026619e-15
R605_649	605	649	5.4964427901534575e+04
C605_649	605	649	1.2887153608310798e-15
R605_650	605	650	3.3721994212147554e+04
C605_650	605	650	2.1005134539310221e-15
R606_646	606	646	3.3412036903640786e+04
C606_646	606	646	2.1199995301178884e-15
R606_650	606	650	3.0646104783848623e+04
C606_650	606	650	2.3113378693833642e-15
R607_608	607	608	1.2126021309597183e+04
C607_608	607	608	5.8414463184176162e-15
R607_609	607	609	8.8280826407874065e+03
C607_609	607	609	8.0236564855811244e-15
R607_610	607	610	6.3999875537226508e+03
C607_610	607	610	1.1067756295056952e-14
R607_614	607	614	1.2825607002639859e+04
C607_614	607	614	5.5228187267410084e-15
R607_628	607	628	1.2700275267180057e+04
C607_628	607	628	5.5773202584866284e-15
R607_629	607	629	1.5456422177585360e+04
C607_629	607	629	4.5827877708155221e-15
R607_651	607	651	8.5151025629359447e+03
C607_651	607	651	8.3185730309720589e-15
R608_610	608	610	8.2613557318040203e+03
C608_610	608	610	8.5740772865293634e-15
R608_614	608	614	2.5872290227566427e+04
C608_614	608	614	2.7378133869466362e-15
R608_623	608	623	1.2649739811688369e+04
C608_623	608	623	5.5996015404640808e-15
R608_624	608	624	4.0294126006024024e+04
C608_624	608	624	1.7579113770927880e-15
R608_625	608	625	3.9979159820191249e+04
C608_625	608	625	1.7717606586676176e-15
R608_651	608	651	3.2099962171585725e+04
C608_651	608	651	2.2066537697885661e-15
R609_611	609	611	1.0681576112793682e+04
C609_611	609	611	6.6313717927039193e-15
R609_614	609	614	3.6060665504316872e+04
C609_614	609	614	1.9642871684528516e-15
R609_627	609	627	1.1602563281164455e+04
C609_627	609	627	6.1049873911044103e-15
R609_629	609	629	3.5919670770521290e+04
C609_629	609	629	1.9719975438675777e-15
R609_630	609	630	2.8757774165545608e+04
C609_630	609	630	2.4631079626762243e-15
R609_651	609	651	3.3149551750148064e+04
C609_651	609	651	2.1367861342403708e-15
R610_624	610	624	8.8332605952802915e+04
C610_624	610	624	8.0189531115890681e-16
R610_625	610	625	1.3977864832387242e+04
C610_625	610	625	5.0675481116311920e-15
R610_628	610	628	6.6160597815218338e+04
C610_628	610	628	1.0706297233563811e-15
R610_651	610	651	5.1811676210854821e+04
C610_651	610	651	1.3671339689481037e-15
R611_614	611	614	9.7812377534075367e+03
C611_614	611	614	7.2417729045921001e-15
R611_615	611	615	3.6697820974791692e+04
C611_615	611	615	1.9301827916337771e-15
R611_613	611	613	2.9526717791618943e+04
C611_613	611	613	2.3989629675705392e-15
R611_630	611	630	1.1766118648928847e+04
C611_630	611	630	6.0201247879179330e-15
R611_627	611	627	3.3194738878549455e+04
C611_627	611	627	2.1338773832552380e-15
R611_651	611	651	3.2426062453351089e+04
C611_651	611	651	2.1844620399995464e-15
R611_652	611	652	9.8527303567490162e+03
C611_652	611	652	7.1892257243678466e-15
R612_613	612	613	2.7558551360116457e+04
C612_613	612	613	2.5702912177928311e-15
R612_615	612	615	1.0043832631392632e+04
C612_615	612	615	7.0524375639838362e-15
R612_617	612	617	1.5218435238634847e+04
C612_617	612	617	4.6544537217713357e-15
R612_619	612	619	1.5535888470634896e+04
C612_619	612	619	4.5593467454330476e-15
R612_654	612	654	4.2120396163999969e+04
C612_654	612	654	1.6816912704287657e-15
R613_615	613	615	3.0400812453763079e+04
C613_615	613	615	2.3299871555647222e-15
R613_617	613	617	1.2199830745734884e+04
C613_617	613	617	5.8061053478765474e-15
R613_630	613	630	9.8962331916419917e+03
C613_630	613	630	7.1576226190611104e-15
R613_645	613	645	1.1578399415161248e+04
C613_645	613	645	6.1177283660855259e-15
R613_652	613	652	1.6193370074443234e+04
C613_652	613	652	4.3742286016047493e-15
R613_654	613	654	1.8760736792416283e+04
C613_654	613	654	3.7756247699521741e-15
R614_615	614	615	1.3481018336728865e+04
C614_615	614	615	5.2543139373243803e-15
R614_623	614	623	3.9359623165888661e+04
C614_623	614	623	1.7996489000277941e-15
R614_651	614	651	1.1255861397604565e+04
C614_651	614	651	6.2930325839899346e-15
R614_652	614	652	4.0133552457684724e+04
C614_652	614	652	1.7649447456883894e-15
R614_653	614	653	2.8987772128947898e+04
C614_653	614	653	2.4435649011213229e-15
R614_655	614	655	4.0702642311080977e+04
C614_655	614	655	1.7402679166289932e-15
R615_616	615	616	2.2594241724149804e+04
C615_616	615	616	3.1350245518657872e-15
R615_619	615	619	3.0403430816430871e+04
C615_619	615	619	2.3297864955990288e-15
R615_620	615	620	1.6809138038259483e+04
C615_620	615	620	4.2139877948991205e-15
R615_623	615	623	5.5362054540628211e+04
C615_623	615	623	1.2794594262035174e-15
R615_652	615	652	2.7524357854810805e+04
C615_652	615	652	2.5734842901564542e-15
R615_653	615	653	2.6936917853175310e+04
C615_653	615	653	2.6296068066172685e-15
R615_654	615	654	1.8878677038014510e+04
C615_654	615	654	3.7520374120161145e-15
R615_655	615	655	1.1019455232179456e+04
C615_655	615	655	6.4280403199197320e-15
R615_656	615	656	2.4401315056868818e+04
C615_656	615	656	2.9028559473502970e-15
R616_619	616	619	2.8770967293915252e+04
C616_619	616	619	2.4619784872850114e-15
R616_620	616	620	3.1627520903566856e+04
C616_620	616	620	2.2396160215014392e-15
R616_656	616	656	3.1726465550949168e+04
C616_656	616	656	2.2326313790689764e-15
R617_618	617	618	1.7180488859592930e+04
C617_618	617	618	4.1229037843384345e-15
R617_619	617	619	2.7933468844859439e+04
C617_619	617	619	2.5357932782857863e-15
R617_645	617	645	3.1812578310729990e+04
C617_645	617	645	2.2265879189084383e-15
R617_647	617	647	1.9216412201308282e+04
C617_647	617	647	3.6860940426318261e-15
R617_654	617	654	1.9827579799616746e+04
C617_654	617	654	3.5724734562596070e-15
R617_657	617	657	3.9593442187808781e+04
C617_657	617	657	1.7890210757631565e-15
R618_619	618	619	5.4906071541269310e+04
C618_619	618	619	1.2900850588583648e-15
R618_647	618	647	5.0520347132375435e+04
C618_647	618	647	1.4020786981213573e-15
R618_649	618	649	4.9696181677138964e+04
C618_649	618	649	1.4253308834908849e-15
R618_657	618	657	5.4151341570217017e+04
C618_657	618	657	1.3080655156835137e-15
R619_654	619	654	3.9170334238739531e+04
C619_654	619	654	1.8083456246320606e-15
R619_656	619	656	3.9448967152205332e+04
C619_656	619	656	1.7955730567724174e-15
R619_657	619	657	4.8318230116680999e+04
C619_657	619	657	1.4659788316945411e-15
R620_621	620	621	5.1016240628649794e+04
C620_621	620	621	1.3884500634141434e-15
R620_623	620	623	4.7714033167510475e+04
C620_623	620	623	1.4845423418163710e-15
R620_653	620	653	5.4639656349581281e+04
C620_653	620	653	1.2963753300864754e-15
R620_655	620	655	5.4286251269062610e+04
C620_655	620	655	1.3048147713299105e-15
R620_656	620	656	4.3078563361765249e+04
C620_656	620	656	1.6442865548034711e-15
R620_658	620	658	3.8328016228382759e+04
C620_658	620	658	1.8480868436792770e-15
R621_622	621	622	7.0859486324527708e+04
C621_622	621	622	9.9963330543480498e-16
R621_623	621	623	2.0333916449113745e+04
C621_623	621	623	3.4835149791857886e-15
R621_624	621	624	6.3390488021567602e+04
C621_624	621	624	1.1174153212371553e-15
R621_658	621	658	1.0209799021317525e+05
C621_658	621	658	6.9377959730748252e-16
R621_660	621	660	6.4513472142443330e+04
C621_660	621	660	1.0979645054540279e-15
R622_624	622	624	4.0790775452827002e+04
C622_624	622	624	1.7365078684987562e-15
R622_660	622	660	1.5146354185613553e+05
C622_660	622	660	4.6766041298096496e-16
R623_624	623	624	2.7098669119754570e+04
C623_624	623	624	2.6139107504863897e-15
R623_625	623	625	7.5048731810628116e+04
C623_625	623	625	9.4383343764869374e-16
R623_651	623	651	5.7047564405318924e+04
C623_651	623	651	1.2416569098854593e-15
R623_653	623	653	1.7915422035774456e+04
C623_653	623	653	3.9537724757226454e-15
R623_658	623	658	5.4816090643552154e+04
C623_658	623	658	1.2922027401881483e-15
R623_660	623	660	7.3735841363665240e+04
C623_660	623	660	9.6063869654174147e-16
R623_661	623	661	4.5967723639408185e+04
C623_661	623	661	1.5409399667394964e-15
R624_625	624	625	4.8262639193183102e+04
C624_625	624	625	1.4676674073390697e-15
R624_660	624	660	5.5531913250898157e+04
C624_660	624	660	1.2755458688406414e-15
R624_661	624	661	1.0401077748665435e+05
C624_661	624	661	6.8102079657166950e-16
R625_628	625	628	2.7291420671289106e+04
C625_628	625	628	2.5954494413886513e-15
R625_651	625	651	1.2812718747290712e+04
C625_651	625	651	5.5283741049086826e-15
R625_661	625	661	2.3563583995547979e+04
C625_661	625	661	3.0060581000489154e-15
R625_662	625	662	2.4678002484185341e+04
C625_662	625	662	2.8703094013136995e-15
R626_627	626	627	1.2724554637105613e+04
C626_627	626	627	5.5666783283278912e-15
R626_635	626	635	1.1204835749034302e+04
C626_635	626	635	6.3216903953371066e-15
R626_638	626	638	1.6074326417368395e+04
C626_638	626	638	4.4066233754880106e-15
R626_639	626	639	1.5450511790862953e+04
C626_639	626	639	4.5845408550083872e-15
R626_640	626	640	9.7404879649482409e+03
C626_640	626	640	7.2720692013479030e-15
R626_664	626	664	2.4173975543452059e+04
C626_664	626	664	2.9301552989775609e-15
R627_629	627	629	5.6767869562805945e+03
C627_629	627	629	1.2477745436198261e-14
R627_630	627	630	2.0340060546063407e+04
C627_630	627	630	3.4824627181215081e-15
R627_635	627	635	5.3494323524066531e+03
C627_635	627	635	1.3241311950441388e-14
R627_638	627	638	3.2697551773216288e+04
C627_638	627	638	2.1663243482963828e-15
R627_651	627	651	1.9183285598599909e+04
C627_651	627	651	3.6924593637478752e-15
R627_652	627	652	2.1777582495066919e+04
C627_652	627	652	3.2525879560803078e-15
R627_663	627	663	1.0207530126792710e+04
C627_663	627	663	6.9393380823904055e-15
R627_664	627	664	7.3062448262067228e+03
C627_664	627	664	9.6949259463531472e-15
R628_629	628	629	6.9372345889764192e+03
C628_629	628	629	1.0210625232215394e-14
R628_638	628	638	4.1337065151383911e+04
C628_638	628	638	1.7135590607749907e-15
R628_651	628	651	2.9192815378574680e+04
C628_651	628	651	2.4264018943505685e-15
R628_662	628	662	3.0388817334223411e+04
C628_662	628	662	2.3309068515880815e-15
R628_665	628	665	6.1401492458018904e+04
C628_665	628	665	1.1536120654466160e-15
R629_638	629	638	3.4632709803434125e+04
C629_638	629	638	2.0452775118675892e-15
R629_651	629	651	2.5887538696857704e+04
C629_651	629	651	2.7362007398794534e-15
R629_662	629	662	4.6718883697044512e+04
C629_662	629	662	1.5161642772830425e-15
R629_663	629	663	3.1409863183755097e+04
C629_663	629	663	2.2551356598278490e-15
R629_664	629	664	3.0514226771161859e+04
C629_664	629	664	2.3213271326587495e-15
R629_665	629	665	3.0351056638903421e+04
C629_665	629	665	2.3338068054344751e-15
R630_631	630	631	1.0085050365011130e+04
C630_631	630	631	7.0236141588095921e-15
R630_633	630	633	3.2466313541196290e+04
C630_633	630	633	2.1817537875410414e-15
R630_635	630	635	1.8348036505335149e+04
C630_635	630	635	3.8605494661733100e-15
R630_645	630	645	1.3255177350381346e+04
C630_645	630	645	5.3438366506625551e-15
R630_652	630	652	1.0474104609769807e+04
C630_652	630	652	6.7627262830590283e-15
R630_666	630	666	1.5683999088362214e+04
C630_666	630	666	4.5162909113250099e-15
R631_632	631	632	1.4978412171018035e+04
C631_632	631	632	4.7290394821059108e-15
R631_633	631	633	2.2774180640052145e+04
C631_633	631	633	3.1102547070970206e-15
R631_635	631	635	2.4432637967357241e+04
C631_635	631	635	2.8991344541115768e-15
R631_636	631	636	1.9831114187233532e+04
C631_636	631	636	3.5718367544673689e-15
R631_666	631	666	3.4786935184296446e+04
C631_666	631	666	2.0362099207858853e-15
R632_633	632	633	2.1548564195290361e+04
C632_633	632	633	3.2871564849541729e-15
R632_634	632	634	1.6417530133215507e+04
C632_634	632	634	4.3145041891953992e-15
R632_636	632	636	1.9527689139946473e+04
C632_636	632	636	3.6273366514781669e-15
R632_637	632	637	7.5585238365664527e+03
C632_637	632	637	9.3713407627721318e-15
R632_667	632	667	3.6669874588746265e+04
C632_667	632	667	1.9316537983944545e-15
R633_634	633	634	1.0328095928904891e+04
C633_634	633	634	6.8583311990509981e-15
R633_636	633	636	2.0582186969505285e+04
C633_636	633	636	3.4414954368526261e-15
R633_645	633	645	2.1021018479555049e+04
C633_645	633	645	3.3696513137502057e-15
R633_646	633	646	3.7448881372117685e+04
C633_646	633	646	1.8914717860902145e-15
R633_648	633	648	1.7441380977707358e+04
C633_648	633	648	4.0612324578274852e-15
R633_666	633	666	7.3772113777892919e+03
C633_666	633	666	9.6016636786712853e-15
R633_667	633	667	1.0582807476718421e+04
C633_667	633	667	6.6932619431875438e-15
R633_668	633	668	9.9175847435312589e+03
C633_668	633	668	7.1422129850920727e-15
R634_637	634	637	8.7874268611836378e+04
C634_637	634	637	8.0607786164218443e-16
R634_646	634	646	7.6748496219978144e+04
C634_646	634	646	9.2293016833809427e-16
R634_667	634	667	4.3326603010270883e+04
C634_667	634	667	1.6348732098661973e-15
R634_668	634	668	6.4090315579208349e+04
C634_668	634	668	1.1052138204633717e-15
R635_636	635	636	1.8391930557965625e+04
C635_636	635	636	3.8513359058612649e-15
R635_640	635	640	1.1855093819279871e+04
C635_640	635	640	5.9749423847497421e-15
R635_652	635	652	4.6029603902181021e+04
C635_652	635	652	1.5388683918838523e-15
R635_663	635	663	2.1675925953501272e+04
C635_663	635	663	3.2678420607244412e-15
R635_664	635	664	1.0121900011263853e+04
C635_664	635	664	6.9980440882813558e-15
R635_666	635	666	1.4521625617877891e+04
C635_666	635	666	4.8777942910740877e-15
R635_669	635	669	1.5353717724247987e+04
C635_669	635	669	4.6134430636388021e-15
R636_637	636	637	1.5127241924514354e+04
C636_637	636	637	4.6825127071717703e-15
R636_640	636	640	1.9342363873585502e+04
C636_640	636	640	3.6620913037796946e-15
R636_641	636	641	2.3640698054825891e+04
C636_641	636	641	2.9962525798404001e-15
R636_666	636	666	2.2721481721929875e+04
C636_666	636	666	3.1174684557492704e-15
R636_667	636	667	9.2481133768379968e+03
C636_667	636	667	7.6592381223832408e-15
R636_669	636	669	1.9595745989330240e+04
C636_669	636	669	3.6147387588392096e-15
R636_670	636	670	1.3723304249781109e+04
C636_670	636	670	5.1615486508746486e-15
R637_641	637	641	9.6999473335775310e+03
C637_641	637	641	7.3024625907814309e-15
R637_642	637	642	4.1646182810283826e+04
C637_642	637	642	1.7008402152647918e-15
R637_667	637	667	1.8223948476142265e+04
C637_667	637	667	3.8868361940734811e-15
R637_670	637	670	2.5116672669363605e+04
C637_670	637	670	2.8201785908688501e-15
R638_639	638	639	4.5576896483949582e+04
C638_639	638	639	1.5541537050673215e-15
R638_640	638	640	3.2946882747111522e+04
C638_640	638	640	2.1499303311846716e-15
R638_643	638	643	5.1348202923601413e+04
C638_643	638	643	1.3794738375048854e-15
R638_664	638	664	2.6008684793520555e+04
C638_664	638	664	2.7234557648084727e-15
R638_665	638	665	5.1098252100518301e+04
C638_665	638	665	1.3862216342872038e-15
R638_671	638	671	4.9058660121464774e+04
C638_671	638	671	1.4438531823050758e-15
R639_640	639	640	1.0691449650811903e+04
C639_640	639	640	6.6252477306125605e-15
R639_641	639	641	6.9361995050013693e+03
C639_641	639	641	1.0212148956344937e-14
R639_642	639	642	1.8511330575576496e+04
C639_642	639	642	3.8264943866032190e-15
R639_643	639	643	6.7084258935468361e+03
C639_643	639	643	1.0558885744588491e-14
R639_644	639	644	2.5793730600731677e+04
C639_644	639	644	2.7461519092546743e-15
R639_672	639	672	2.7427555147529452e+04
C639_672	639	672	2.5825671356777986e-15
R640_641	640	641	1.5128714807531347e+04
C640_641	640	641	4.6820568327944025e-15
R640_643	640	643	3.3029477838222076e+04
C640_643	640	643	2.1445541126305878e-15
R640_664	640	664	1.5701819450968445e+04
C640_664	640	664	4.5111652670054867e-15
R640_669	640	669	1.8165468385873122e+04
C640_669	640	669	3.8993490853825509e-15
R640_670	640	670	2.4863002213812772e+04
C640_670	640	670	2.8489521067028694e-15
R640_671	640	671	1.3026995803140211e+04
C640_671	640	671	5.4374395759707923e-15
R640_672	640	672	3.7420705506836828e+04
C640_672	640	672	1.8928959669950261e-15
R641_642	641	642	5.2292349227697587e+03
C641_642	641	642	1.3545672279431991e-14
R641_670	641	670	1.7092490272066210e+04
C641_670	641	670	4.1441300482564128e-15
R641_672	641	672	3.4954485204584620e+04
C641_672	641	672	2.0264495992837424e-15
R642_644	642	644	8.5992556236789867e+04
C642_644	642	644	8.2371667544051434e-16
R642_670	642	670	1.0851857037184005e+05
C642_670	642	670	6.5273162273782486e-16
R642_672	642	672	6.9114889028667763e+04
C642_672	642	672	1.0248660387289257e-15
R643_644	643	644	5.8107177310987121e+04
C643_644	643	644	1.2190146865489978e-15
R643_671	643	671	9.2880980980657085e+04
C643_671	643	671	7.6262655484605010e-16
R643_672	643	672	5.2202695805597636e+04
C643_672	643	672	1.3568935749943514e-15
R644_672	644	672	1.1082411907479352e+05
C644_672	644	672	6.3915240768298408e-16
R645_647	645	647	1.6941247078838111e+04
C645_647	645	647	4.1811268206152633e-15
R645_648	645	648	1.3836522658982636e+04
C645_648	645	648	5.1193138826694344e-15
R645_652	645	652	2.2075243982320695e+04
C645_652	645	652	3.2087302225392442e-15
R645_654	645	654	2.1308600504597765e+04
C645_654	645	654	3.3241743173474124e-15
R645_666	645	666	1.5157827722146663e+04
C645_666	645	666	4.6730642302067615e-15
R645_673	645	673	2.4204146185205827e+04
C645_673	645	673	2.9265028393893601e-15
R646_647	646	647	3.0460681871028472e+04
C646_647	646	647	2.3254076463524816e-15
R646_648	646	648	1.4656268738083205e+04
C646_648	646	648	4.8329833330596981e-15
R646_649	646	649	5.1096734205443274e+04
C646_649	646	649	1.3862628138072704e-15
R646_650	646	650	5.8103843771850217e+04
C646_650	646	650	1.2190846239731388e-15
R646_668	646	668	5.4567392110729597e+04
C646_668	646	668	1.2980921351759451e-15
R646_675	646	675	9.0062757705569791e+04
C646_675	646	675	7.8649049108141431e-16
R646_676	646	676	4.3186652327535310e+04
C646_676	646	676	1.6401711806413248e-15
R647_648	647	648	1.7203738679578633e+04
C647_648	647	648	4.1173319273956158e-15
R647_649	647	649	1.5253782076971433e+04
C647_649	647	649	4.6436681852782615e-15
R647_654	647	654	3.3623820952304915e+04
C647_654	647	654	2.1066464348735585e-15
R647_657	647	657	2.6505865657383270e+04
C647_657	647	657	2.6723708424240492e-15
R647_673	647	673	6.6420903214784790e+04
C647_673	647	673	1.0664338951692092e-15
R647_674	647	674	2.8219786614379427e+04
C647_674	647	674	2.5100651363503471e-15
R647_676	647	676	5.9221177596668662e+04
C647_676	647	676	1.1960839924261243e-15
R648_666	648	666	3.1439444739274433e+04
C648_666	648	666	2.2530137896333189e-15
R648_668	648	668	1.3093646002438154e+04
C648_668	648	668	5.4097615379864533e-15
R648_673	648	673	1.8390735642136009e+04
C648_673	648	673	3.8515861417587637e-15
R648_674	648	674	4.8357915758621784e+04
C648_674	648	674	1.4647757543886913e-15
R648_675	648	675	1.4744483853638058e+04
C648_675	648	675	4.8040679646119005e-15
R648_676	648	676	4.8122811052982121e+04
C648_676	648	676	1.4719319380161299e-15
R649_650	649	650	4.7479831353094196e+04
C649_650	649	650	1.4918650828649981e-15
R649_657	649	657	6.0086919948317744e+04
C649_657	649	657	1.1788506150244625e-15
R649_674	649	674	6.9591027036371132e+04
C649_674	649	674	1.0178539612438757e-15
R649_676	649	676	3.6071107125859868e+04
C649_676	649	676	1.9637185598115038e-15
R650_676	650	676	1.5130652414192513e+05
C650_676	650	676	4.6814572562355846e-16
R651_652	651	652	2.1336094395662392e+04
C651_652	651	652	3.3198907551890283e-15
R651_653	651	653	1.4867742868061599e+04
C651_653	651	653	4.7642404879198055e-15
R651_655	651	655	3.3874966186779093e+04
C651_655	651	655	2.0910279923362786e-15
R651_661	651	661	3.1855084416990201e+04
C651_661	651	661	2.2236168521412022e-15
R651_662	651	662	1.4135465413412932e+04
C651_662	651	662	5.0110484843878679e-15
R651_663	651	663	1.7121918092915283e+04
C651_663	651	663	4.1370074399146636e-15
R651_677	651	677	2.6370320898012757e+04
C651_677	651	677	2.6861069613050468e-15
R652_654	652	654	2.0222908419860589e+04
C652_654	652	654	3.5026367654632497e-15
R652_655	652	655	2.3577531335443473e+04
C652_655	652	655	3.0042798598476639e-15
R652_663	652	663	2.1141242989383314e+04
C652_663	652	663	3.3504890214625082e-15
R652_666	652	666	3.6744037654815489e+04
C652_666	652	666	1.9277550061708290e-15
R652_673	652	673	5.0908361272087321e+04
C652_673	652	673	1.3913923128937464e-15
R652_677	652	677	3.8676972182427540e+04
C652_677	652	677	1.8314128159231256e-15
R653_655	653	655	8.8507979541260847e+03
C653_655	653	655	8.0030640065598498e-15
R653_658	653	658	3.2369149469334370e+04
C653_658	653	658	2.1883028654523561e-15
R653_659	653	659	2.5016008739616129e+04
C653_659	653	659	2.8315269343436814e-15
R653_661	653	661	4.1745335546911512e+04
C653_661	653	661	1.6968004115429987e-15
R653_677	653	677	6.2987199786951474e+04
C653_677	653	677	1.1245697979206560e-15
R654_655	654	655	1.5364909137749850e+04
C654_655	654	655	4.6100827477052940e-15
R654_656	654	656	1.7999688473647580e+04
C654_656	654	656	3.9352626930018093e-15
R654_657	654	657	1.2765617892047825e+04
C654_657	654	657	5.5487719540880832e-15
R654_673	654	673	2.9228556501636111e+04
C654_673	654	673	2.4234348532413840e-15
R654_674	654	674	4.9727752481729513e+04
C654_674	654	674	1.4244259794774551e-15
R654_677	654	677	5.2980332999529819e+04
C654_677	654	677	1.3369772994184202e-15
R654_678	654	678	2.7092298664389091e+04
C654_678	654	678	2.6145253827836187e-15
R655_656	655	656	2.2973470077209673e+04
C655_656	655	656	3.0832739807239142e-15
R655_658	655	658	4.4090462132833229e+04
C655_658	655	658	1.6065493331096617e-15
R655_659	655	659	1.4350827764680391e+04
C655_659	655	659	4.9358478617053866e-15
R655_677	655	677	3.0481332950363099e+04
C655_677	655	677	2.3238321844831333e-15
R655_678	655	678	6.2061267546312163e+04
C655_678	655	678	1.1413479829934462e-15
R656_657	656	657	5.3890808139320521e+04
C656_657	656	657	1.3143893176156979e-15
R656_658	656	658	4.3350132690636041e+04
C656_658	656	658	1.6339858297896419e-15
R656_659	656	659	4.6417704608610453e+04
C656_659	656	659	1.5260018377311238e-15
R656_678	656	678	3.5132585637304823e+04
C656_678	656	678	2.0161767558829169e-15
R657_674	657	674	3.0104848472574911e+04
C657_674	657	674	2.3528935081845151e-15
R657_678	657	678	7.6452861333006047e+04
C657_678	657	678	9.2649903876677980e-16
R658_659	658	659	1.0785523878807731e+04
C658_659	658	659	6.5674605454427099e-15
R658_660	658	660	6.7858550406251321e+04
C658_660	658	660	1.0438404904310280e-15
R658_661	658	661	5.3563071798154910e+04
C658_661	658	661	1.3224316708893460e-15
R658_678	658	678	1.1229823428294582e+05
C658_678	658	678	6.3076238899294202e-16
R658_679	658	679	6.0455484664190160e+04
C658_679	658	679	1.1716637941033181e-15
R659_661	659	661	4.0568990594122013e+04
C659_661	659	661	1.7460011082026524e-15
R659_677	659	677	1.9897699048908740e+04
C659_677	659	677	3.5598841032769959e-15
R659_678	659	678	2.1738460002640564e+04
C659_678	659	678	3.2584416065993585e-15
R659_679	659	679	3.4671803923101739e+04
C659_679	659	679	2.0429713635062358e-15
R660_661	660	661	4.1551713737013422e+04
C660_661	660	661	1.7047071267460858e-15
R660_679	660	679	1.4985868386644745e+05
C660_679	660	679	4.7266865495179527e-16
R661_662	661	662	4.3073131777240225e+04
C661_662	661	662	1.6444939017280445e-15
R661_677	661	677	4.2796359926954705e+04
C661_677	661	677	1.6551291431537502e-15
R661_679	661	679	4.5437308418003959e+04
C661_679	661	679	1.5589282244529504e-15
R661_680	661	680	1.1265122789258731e+05
C661_680	661	680	6.2878588952034857e-16
R662_663	662	663	5.4328885750772686e+04
C662_663	662	663	1.3037908206131872e-15
R662_665	662	665	4.1130038462794597e+04
C662_665	662	665	1.7221842036465529e-15
R662_677	662	677	5.4514525336850376e+04
C662_677	662	677	1.2993509912874253e-15
R662_680	662	680	1.2018804791167927e+05
C662_680	662	680	5.8935562867326314e-16
R663_664	663	664	1.2019489431299779e+04
C663_664	663	664	5.8932205848564169e-15
R663_665	663	665	2.6602989631685003e+04
C663_665	663	665	2.6626143721694753e-15
R663_666	663	666	5.9407952518554222e+04
C663_666	663	666	1.1923235784616104e-15
R663_669	663	669	3.1680051857274389e+04
C663_669	663	669	2.2359023544254453e-15
R663_673	663	673	7.7196281261100492e+04
C663_673	663	673	9.1757661611211957e-16
R663_677	663	677	1.6163669907377844e+04
C663_677	663	677	4.3822660906771141e-15
R663_681	663	681	7.7183751236243173e+04
C663_681	663	681	9.1772557567451752e-16
R664_665	664	665	1.3121647016462166e+04
C664_665	664	665	5.3982173462777694e-15
R664_669	664	669	1.8002664622339700e+04
C664_669	664	669	3.9346121267016178e-15
R664_671	664	671	2.6525284983053603e+04
C664_671	664	671	2.6704143831538059e-15
R664_681	664	681	5.3746143261421479e+04
C664_681	664	681	1.3179271709128138e-15
R665_671	665	671	7.5436560221539272e+04
C665_671	665	671	9.3898107665538865e-16
R665_677	665	677	6.4605386444894415e+04
C665_677	665	677	1.0964024276275771e-15
R665_680	665	680	1.0604186586164126e+05
C665_680	665	680	6.6797676521856402e-16
R665_681	665	681	4.4181387577700050e+04
C665_681	665	681	1.6032430491556641e-15
R666_667	666	667	4.8499988414225394e+04
C666_667	666	667	1.4604849372546251e-15
R666_668	666	668	4.6218479150892199e+04
C666_668	666	668	1.5325796918748820e-15
R666_669	666	669	2.3985312232421627e+04
C666_669	666	669	2.9532032708022180e-15
R666_673	666	673	2.7475596070802832e+04
C666_673	666	673	2.5780515317471793e-15
R666_682	666	682	8.2138021015950711e+04
C666_682	666	682	8.6237167221553305e-16
R667_668	667	668	3.0293738299567438e+04
C667_668	667	668	2.3382225671703069e-15
R667_669	667	669	6.1848168314827082e+04
C667_669	667	669	1.1452805227057766e-15
R667_670	667	670	4.4344206735726424e+04
C667_670	667	670	1.5973564023399741e-15
R667_682	667	682	5.7505318371961672e+04
C667_682	667	682	1.2317730697155288e-15
R668_673	668	673	5.3857581578350109e+04
C668_673	668	673	1.3152002087756935e-15
R668_675	668	675	3.6759329268338952e+04
C668_675	668	675	1.9269530741141503e-15
R668_682	668	682	4.3790410776311961e+04
C668_682	668	682	1.6175573893980637e-15
R669_670	669	670	2.5948892019766488e+04
C669_670	669	670	2.7297312918810878e-15
R669_671	669	671	2.9578559775145146e+04
C669_671	669	671	2.3947583342283416e-15
R669_673	669	673	4.0391241492109002e+04
C669_673	669	673	1.7536847078552494e-15
R669_677	669	677	1.0119251794773673e+05
C669_677	669	677	6.9998754821560670e-16
R669_681	669	681	1.9037232194224151e+04
C669_681	669	681	3.7207878652386634e-15
R669_682	669	682	2.2719634660438634e+04
C669_682	669	682	3.1177218997865912e-15
R669_683	669	683	5.1017756443870814e+04
C669_683	669	683	1.3884088104487751e-15
R670_671	670	671	5.4304583829418923e+04
C670_671	670	671	1.3043742818930642e-15
R670_672	670	672	3.7935214363879444e+04
C670_672	670	672	1.8672229411057486e-15
R670_682	670	682	8.1028645800494429e+04
C670_682	670	682	8.7417853076803824e-16
R670_683	670	683	4.7700840951358965e+04
C670_683	670	683	1.4849529090740695e-15
R671_672	671	672	4.9152931643424636e+04
C671_672	671	672	1.4410839835527016e-15
R671_681	671	681	4.5235563332788995e+04
C671_681	671	681	1.5658808538514729e-15
R671_683	671	683	4.3347597308713339e+04
C671_683	671	683	1.6340814009029677e-15
R672_683	672	683	1.1755582582059504e+05
C672_683	672	683	6.0255203892745251e-16
R673_674	673	674	2.4711223601116963e+04
C673_674	673	674	2.8664506330960595e-15
R673_675	673	675	2.0759291914285557e+04
C673_675	673	675	3.4121348082809976e-15
R673_677	673	677	2.0077600405541954e+04
C673_677	673	677	3.5279864677677357e-15
R673_678	673	678	5.6206577893111382e+04
C673_678	673	678	1.2602351039891594e-15
R673_681	673	681	6.6870840608510392e+04
C673_681	673	681	1.0592584434625052e-15
R673_682	673	682	2.4588987104541444e+04
C673_682	673	682	2.8807003002949022e-15
R673_684	673	684	4.5231713984486945e+04
C673_684	673	684	1.5660141147932989e-15
R673_685	673	685	3.0472065097072536e+04
C673_685	673	685	2.3245389608597620e-15
R673_686	673	686	3.0037709036398363e+04
C673_686	673	686	2.3581526290892264e-15
R673_687	673	687	6.1943023096183613e+04
C673_687	673	687	1.1435267282000666e-15
R674_675	674	675	4.3590850564001586e+04
C674_675	674	675	1.6249626153084539e-15
R674_676	674	676	2.9368907633470921e+04
C674_676	674	676	2.4118534955407414e-15
R674_678	674	678	5.5626311699306920e+04
C674_678	674	678	1.2733812538012034e-15
R674_685	674	685	6.4209114746752020e+04
C674_685	674	685	1.1031689630884231e-15
R674_687	674	687	4.2329572811882892e+04
C674_687	674	687	1.6733809918373517e-15
R675_676	675	676	3.7723170561912513e+04
C675_676	675	676	1.8777186933358560e-15
R675_682	675	682	6.5961031224438149e+04
C675_682	675	682	1.0738689377821101e-15
R675_686	675	686	4.1932736124767143e+04
C675_686	675	686	1.6892172818210858e-15
R675_687	675	687	3.3102774535551092e+04
C675_687	675	687	2.1398056063224424e-15
R676_687	676	687	1.4231943250449421e+05
C676_687	676	687	4.9770787649650872e-16
R677_678	677	678	2.5050240293871258e+04
C677_678	677	678	2.8276576074733305e-15
R677_679	677	679	4.7781415909615745e+04
C677_679	677	679	1.4824487970383727e-15
R677_680	677	680	8.7274937039006600e+03
C677_680	677	680	8.1161333298174400e-15
R677_681	677	681	4.1644418322548809e+04
C677_681	677	681	1.7009122804255008e-15
R677_684	677	684	4.6499282185507829e+04
C677_684	677	684	1.5233246451721851e-15
R677_685	677	685	7.9154691079442317e+04
C677_685	677	685	8.9487434755963009e-16
R677_688	677	688	5.4259858546898991e+04
C677_688	677	688	1.3054494507164214e-15
R678_679	678	679	6.5492579173481005e+04
C678_679	678	679	1.0815500539133086e-15
R678_685	678	685	4.1520613454816805e+04
C678_685	678	685	1.7059840075118789e-15
R678_688	678	688	8.8450790031982586e+04
C678_688	678	688	8.0082385369749210e-16
R679_680	679	680	7.3785551861668195e+04
C679_680	679	680	9.5999149899694953e-16
R679_688	679	688	6.9672973905190869e+04
C679_688	679	688	1.0166567976901396e-15
R680_681	680	681	6.5279883983066458e+04
C680_681	680	681	1.0850739648124094e-15
R680_684	680	684	5.2982180338121601e+04
C680_684	680	684	1.3369306828060844e-15
R680_688	680	688	6.9556369617366247e+04
C680_688	680	688	1.0183611209966729e-15
R681_682	681	682	3.3027055798132948e+04
C681_682	681	682	2.1447113835682654e-15
R681_683	681	683	3.6049529154201322e+04
C681_683	681	683	1.9648939722072584e-15
R681_684	681	684	2.4610935984422249e+04
C681_684	681	684	2.8781311926061983e-15
R681_689	681	689	5.4297707622359965e+04
C681_689	681	689	1.3045394665396622e-15
R682_683	682	683	4.8623603093157370e+04
C682_683	682	683	1.4567719796554558e-15
R682_684	682	684	6.9212597923044159e+04
C682_684	682	684	1.0234192135766684e-15
R682_686	682	686	3.9638117015381737e+04
C682_686	682	686	1.7870047285170677e-15
R682_689	682	689	4.8130133840115035e+04
C682_689	682	689	1.4717079900775671e-15
R683_689	683	689	2.2552406492263195e+05
C683_689	683	689	3.1408400943952511e-16
R684_685	684	685	2.3109211008349885e+04
C684_685	684	685	3.0651631728320908e-15
R684_686	684	686	2.1137592270671532e+04
C684_686	684	686	3.3510676915781796e-15
R684_688	684	688	2.5352089617414840e+04
C684_688	684	688	2.7939906968198431e-15
R684_689	684	689	2.1149156901324226e+04
C684_689	684	689	3.3492352847202550e-15
R684_690	684	690	3.6149807809542450e+04
C684_690	684	690	1.9594434058734366e-15
R685_686	685	686	2.8715531461080958e+04
C685_686	685	686	2.4667313795672852e-15
R685_687	685	687	2.3415135087635932e+04
C685_687	685	687	3.0251161170282021e-15
R685_688	685	688	2.8016035530578298e+04
C685_688	685	688	2.5283199851273853e-15
R685_690	685	690	3.9498022774205194e+04
C685_690	685	690	1.7933429969628495e-15
R686_687	686	687	2.6350690802599343e+04
C686_687	686	687	2.6881079918031106e-15
R686_689	686	689	4.0890442543391386e+04
C686_689	686	689	1.7322752733926563e-15
R686_690	686	690	4.1981762113928038e+04
C686_690	686	690	1.6872446264588785e-15
R687_690	687	690	1.2211517454619631e+05
C687_690	687	690	5.8005487687530276e-16
R688_690	688	690	1.4254763277808993e+05
C688_690	688	690	4.9691111073215504e-16
R689_690	689	690	1.5321607216872738e+05
C689_690	689	690	4.6231117619302669e-16
.control
quit 13

.endc
.end
.END
