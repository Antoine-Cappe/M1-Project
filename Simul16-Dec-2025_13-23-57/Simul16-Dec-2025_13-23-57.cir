Simul16-Dec-2025_13-23-57.cir
********************************************************************************
*
*                        Spice Netlist Generated by
*
*                              BIOCAD Program
*                               Release 1.0
*
*   Authors: Vincent Senez
*
*   Release 1.0 : January 2019
*
********************************************************************************
.CONTROL
  DESTROY ALL
  AC DEC 9.000000 1000.000000 10000000000.000000
  WRITE Simul16-Dec-2025_13-23-57.spi vdb(85,1246)-vdb(1246)-66 vp(85,1246)-vp(1246)
  DESTROY ALL
  AC DEC 1 1000.000000 1000.000000
  WRITE Simul16-Dec-2025_13-23-57_1000Hz.spi_cou all
  DESTROY ALL
  AC DEC 1 50000000.000000 50000000.000000
  WRITE Simul16-Dec-2025_13-23-57_50000000Hz.spi_cou all
  DESTROY ALL
  AC DEC 1 10000000000.000000 10000000000.000000
  WRITE Simul16-Dec-2025_13-23-57_10000000000Hz.spi_cou all
.ENDC
Vin	85	0	DC 0 AC 0.025000
Rg	1246	0	50e-5
R1_7	1	7	1.8719475537765800e-05
C1_7	1	7	4.7299336988031673e-12
R1_9	1	9	3.3398976277265971e-06
C1_9	1	9	2.6510356914822182e-11
R1_8	1	8	1.3015885334852781e-05
C1_8	1	8	6.8026012746832076e-12
R1_12	1	12	9.2067448107248967e-06
C1_12	1	12	9.6170666169499950e-12
R1_14	1	14	2.4374317106465883e-06
C1_14	1	14	3.6325890806808322e-11
R1_2	1	2	1.8719475537765800e-05
C1_2	1	2	4.7299336988031673e-12
R2_14	2	14	1.3083607705574742e-05
C2_14	2	14	6.7673901696298607e-12
R2_12	2	12	5.7212329957908881e-06
C2_12	2	12	1.5476013341029858e-11
R2_20	2	20	2.4501138025420866e-06
C2_20	2	20	3.6137863505823457e-11
R2_16	2	16	6.8625025115837923e-06
C2_16	2	16	1.2902272606901457e-11
R2_3	2	3	1.8816874003523228e-05
C2_3	2	3	4.7054509773207619e-12
R3_4	3	4	3.4130632381223660e-06
C3_4	3	4	2.5942056150916703e-11
R3_18	3	18	1.8280737829849412e-06
C3_18	3	18	4.8434521075744438e-11
R3_5	3	5	9.3597377688828999e-06
C3_5	3	5	9.4598673976063347e-12
R3_20	3	20	1.3015885334852781e-05
C3_20	3	20	6.8026012746832076e-12
R3_16	3	16	2.9803742948902308e-06
C3_16	3	16	2.9708308222159412e-11
R3_21	3	21	6.0262952960063723e-06
C3_21	3	21	1.4692588700171519e-11
R3_22	3	22	6.4209287291753046e-06
C3_22	3	22	1.3789574982772344e-11
R4_18	4	18	2.4467203739573085e-06
C4_18	4	18	3.6187984173603374e-11
R4_5	4	5	1.0109279748577868e-06
C4_5	4	5	8.7584754178412868e-11
R4_13	4	13	8.7118216815778903e-07
C4_13	4	13	1.0163417182566031e-10
R4_21	4	21	8.4279151534861815e-07
C4_21	4	21	1.0505786610034266e-10
R4_22	4	22	1.3962949173423715e-06
C4_22	4	22	6.3412017812487337e-11
R4_23	4	23	8.2397900301760032e-07
C4_23	4	23	1.0745647382486607e-10
R4_28	4	28	2.7281656544492672e-06
C4_28	4	28	3.2454729435362641e-11
R5_18	5	18	2.3026772669745846e-05
C5_18	5	18	3.8451709859598515e-12
R5_13	5	13	4.3121297134355523e-06
C5_13	5	13	2.0533213065025604e-11
R5_22	5	22	1.0390873344791599e-05
C5_22	5	22	8.5211199513254991e-12
R5_23	5	23	2.9301030916035144e-06
C5_23	5	23	3.0218007831780758e-11
R5_25	5	25	6.1922955047500000e-06
C5_25	5	25	1.4298716542529518e-11
R5_6	5	6	3.3117156199185044e-05
C5_6	5	6	2.6735954511752088e-12
R5_29	5	29	1.5351181779830567e-05
C5_29	5	29	5.7677564789397769e-12
R6_25	6	25	1.3301531052691900e-05
C6_25	6	25	6.6565177962788973e-12
R6_29	6	29	6.4681945701533297e-06
C6_29	6	29	1.3688808710017069e-11
R6_26	6	26	2.6400794163891134e-05
C6_26	6	26	3.3537581339541822e-12
R7_9	7	9	3.9781534872529789e-06
C7_9	7	9	2.2257029160315416e-11
R7_8	7	8	2.8081035084780310e-06
C7_8	7	8	3.1530845605470213e-11
R7_10	7	10	1.1461646973379715e-05
C7_10	7	10	7.7250571733402033e-12
R7_31	7	31	8.5389269951678882e-06
C7_31	7	31	1.0369204259517052e-11
R8_9	8	9	4.4626385426146195e-06
C8_9	8	9	1.9840701263276438e-11
R8_14	8	14	9.1394730289446225e-06
C8_14	8	14	5.8127122545458241e-11
R8_31	8	31	7.2859319427173319e-06
C8_31	8	31	7.2914662521022818e-11
R8_33	8	33	7.7539185663751020e-06
C8_33	8	33	1.8270375636112438e-10
R8_34	8	34	5.1693606413096722e+03
C8_34	8	34	1.7128206815837030e-10
R8_35	8	35	5.3593459201955238e+03
C8_35	8	35	1.6521023178658665e-10
R8_15	8	15	1.6065479941724458e+04
C8_15	8	15	5.5113123598656702e-11
R9_12	9	12	5.0366521570257299e-06
C9_12	9	12	1.7579510240049259e-11
R9_14	9	14	3.3848221177308728e-06
C9_14	9	14	2.6158502600827063e-11
R9_10	9	10	4.4102775403320846e-06
C9_10	9	10	2.0076259908879337e-11
R9_31	9	31	3.1921536776194527e-06
C9_31	9	31	2.7737348233193485e-11
R9_33	9	33	1.4291768631229206e-06
C9_33	9	33	6.1953058753362082e-11
R9_37	9	37	5.3755459954651292e-06
C9_37	9	37	1.6471234409433928e-11
R9_38	9	38	2.3855750115503916e-06
C9_38	9	38	3.7115528852080158e-11
R10_31	10	31	2.0539888105477114e-06
C10_31	10	31	4.3107283601213813e-11
R10_38	10	38	5.9654360201314124e-06
C10_38	10	38	1.4842482237878318e-11
R10_11	10	11	1.2575441697230888e-05
C10_11	10	11	7.0408563215315863e-12
R11_31	11	31	6.8849179255657719e-06
C11_31	11	31	1.2860266328116619e-11
R11_38	11	38	4.1873170749671274e-06
C11_38	11	38	2.1145252815777057e-11
R11_39	11	39	4.5136943288831473e-06
C11_39	11	39	1.9616276982563972e-11
R11_40	11	40	2.2641676399511594e-06
C11_40	11	40	3.9105707814068900e-11
R11_42	11	42	4.6235042985175439e-06
C11_42	11	42	1.9150383011083087e-11
R11_43	11	43	1.3862250856843839e-05
C11_43	11	43	6.3872656096312516e-12
R12_14	12	14	4.2196538313713193e-06
C12_14	12	14	2.0983208980729428e-11
R12_20	12	20	4.0000856447563149e-06
C12_20	12	20	2.2134995605923828e-11
R12_16	12	16	5.3880493387091063e-06
C12_16	12	16	1.6433011764367640e-11
R12_19	12	19	3.9614712289489102e-06
C12_19	12	19	2.2350756335921352e-11
R12_36	12	36	3.9584882369546777e-06
C12_36	12	36	2.2367599161571987e-11
R12_37	12	37	8.5809566448729756e-07
C12_37	12	37	1.0318415747141990e-10
R12_38	12	38	7.0310548965035469e-06
C12_38	12	38	1.2592972103521869e-11
R12_41	12	41	4.9709238737584009e-06
C12_41	12	41	1.7811956171249017e-11
R12_46	12	46	4.3580912464315299e-06
C12_46	12	46	2.0316664604601710e-11
R13_18	13	18	8.8961857649873830e-06
C13_18	13	18	1.0948070157541509e-10
R13_21	13	21	8.8319833879030916e-06
C13_21	13	21	1.1027655013822203e-10
R13_23	13	23	1.9759269885517785e-06
C13_23	13	23	4.4810298499386994e-11
R13_28	13	28	3.1677426365369315e-06
C13_28	13	28	3.0746205441765362e-10
R13_29	13	29	8.8961857694354749e-06
C13_29	13	29	5.9716746313862772e-11
R13_30	13	30	2.7931398618397143e+03
C13_30	13	30	3.1699765335661173e-10
R13_45	13	45	3.4055577966587994e+03
C13_45	13	45	2.5999229335314362e-10
R13_52	13	52	6.6689009498988298e+03
C13_52	13	52	1.3276832095001087e-10
R14_20	14	20	7.9945231355314133e-06
C14_20	14	20	1.2182848712605524e-10
R14_33	14	33	4.4772928601771962e-06
C14_33	14	33	3.1641219210729233e-10
R14_34	14	34	3.0039135670539649e+03
C14_34	14	34	2.9475507931087343e-10
R14_32	14	32	1.5241086694822864e+03
C14_32	14	32	5.8094202823527118e-10
R14_37	14	37	5.1534083516990563e-06
C14_37	14	37	1.3172273943586258e-10
R14_57	14	57	7.9797956325620289e+03
C14_57	14	57	1.1095757616736402e-10
R15_35	15	35	3.8928705460242186e+03
C15_35	15	35	2.2744624339082548e-10
R15_34	15	34	7.1743264886205552e+03
C15_34	15	34	1.2341489937827518e-10
R15_59	15	59	7.2375523539671376e+03
C15_59	15	59	1.2233677055402210e-10
R15_55	15	55	1.0115179947029605e+04
C15_55	15	55	8.7533665870176604e-11
R15_60	15	60	2.5756917610383287e+04
C15_60	15	60	3.4375960473743361e-11
R16_18	16	18	8.4599667351024737e-06
C16_18	16	18	1.0465984198568781e-11
R16_20	16	20	7.3775921441021113e-06
C16_20	16	20	1.2001460156723802e-11
R16_19	16	19	2.1797693433069801e-06
C16_19	16	19	4.0619838260350530e-11
R16_21	16	21	6.8182250154293085e-06
C16_21	16	21	1.2986059857167238e-11
R16_22	16	22	1.7045756217331332e-05
C16_22	16	22	5.1943649223361962e-12
R16_17	16	17	6.9915463608083993e-06
C16_17	16	17	1.2664133741045859e-11
R16_36	16	36	7.3302279853162490e-06
C16_36	16	36	1.2079007412506838e-11
R16_68	16	68	8.3041978157098359e-06
C16_68	16	68	1.0662303588493157e-11
R17_22	17	22	4.2494401958935805e-06
C17_22	17	22	2.0836127604657641e-11
R17_21	17	21	4.3794310018344444e-06
C17_21	17	21	2.0217667119977869e-11
R17_62	17	62	4.4663807415279426e-06
C17_62	17	62	1.9824077545997556e-11
R17_63	17	63	2.8529964552969744e-06
C17_63	17	63	3.1034696172022928e-11
R17_61	17	61	4.3315777400867212e-06
C17_61	17	61	2.0441022528716598e-11
R17_68	17	68	1.2737564019235034e-06
C17_68	17	68	6.9512410721777429e-11
R17_36	17	36	3.1909682013670581e-06
C17_36	17	36	2.7747652932444557e-11
R18_20	18	20	8.7926362682035024e-06
C18_20	18	20	6.0420021089183424e-11
R18_19	18	19	6.6281192026096436e-06
C18_19	18	19	2.1373635646703819e-10
R18_21	18	21	3.9438535180801045e-06
C18_21	18	21	1.9083010066938783e-10
R18_45	18	45	3.8905663911670313e+03
C18_45	18	45	2.2758094649411856e-10
R18_52	18	52	4.2532648590642093e+03
C18_52	18	52	2.0817391134555571e-10
R18_53	18	53	2.9132266289746090e+03
C18_53	18	53	3.0393062211285909e-10
R18_70	18	70	4.3300811898281781e+03
C18_70	18	70	2.0448087296375484e-10
R18_71	18	71	5.6827193201719519e+03
C18_71	18	71	1.5580899421814283e-10
R19_20	19	20	5.8169976237472710e-06
C19_20	19	20	1.6743356657392274e-10
R19_21	19	21	1.2197661531485322e-05
C19_21	19	21	7.9848146005854891e-11
R19_36	19	36	6.0162423009010209e-06
C19_36	19	36	1.4717139659873664e-11
R19_37	19	37	1.1812625601026774e-05
C19_37	19	37	8.2450819300611805e-11
R19_46	19	46	4.9350498481031641e-06
C19_46	19	46	1.9735578948009831e-10
R19_53	19	53	5.8175923770388335e+03
C19_53	19	53	1.5219677218957713e-10
R19_68	19	68	5.0369056283205381e-06
C19_68	19	68	1.3476946276315141e-10
R19_70	19	70	2.0653460493329112e+03
C19_70	19	70	4.2870238717912797e-10
R19_72	19	72	3.6330077379542304e+03
C19_72	19	72	2.4371508280865508e-10
R20_37	20	37	1.3191549335492726e-05
C20_37	20	37	1.0739224124215279e-10
R20_32	20	32	7.6720409640660546e+03
C20_32	20	32	1.1540850548727295e-10
R20_53	20	53	6.9463632962800330e+03
C20_53	20	53	1.2746508409287577e-10
R20_57	20	57	8.7820377401426649e+03
C20_57	20	57	1.0082156418581006e-10
R20_72	20	72	6.7732590102896420e+03
C20_72	20	72	1.3072271123175865e-10
R21_22	21	22	2.5010909574905686e-06
C21_22	21	22	3.5401302741439339e-11
R21_23	21	23	7.7956922084827642e-06
C21_23	21	23	1.1357795536572686e-11
R21_28	21	28	1.1710662517028824e-05
C21_28	21	28	5.7966068489324068e-11
R21_45	21	45	3.0608689857429567e+03
C21_45	21	45	2.8927039537599958e-10
R21_63	21	63	1.4865884622802859e-05
C21_63	21	63	4.5663011838273363e-11
R21_68	21	68	1.1713912898340021e-05
C21_68	21	68	8.3145629248622777e-11
R21_69	21	69	4.9033239837767696e+03
C21_69	21	69	1.8057521481948029e-10
R21_70	21	70	4.9611141796983566e+03
C21_70	21	70	1.7847176050155630e-10
R21_74	21	74	1.3685106686378648e-05
C21_74	21	74	7.1169387365131972e-11
R22_23	22	23	4.2272475248332415e-06
C22_23	22	23	2.0945515409224320e-11
R22_25	22	25	1.5732749614917798e-05
C22_25	22	25	5.6278705462931018e-12
R22_24	22	24	1.1912326894703894e-05
C22_24	22	24	7.4327945289484017e-12
R22_62	22	62	1.4202932174865229e-05
C22_62	22	62	6.2340562554182702e-12
R22_63	22	63	1.4653179391735633e-05
C22_63	22	63	6.0425028454874080e-12
R22_74	22	74	9.8887913424618763e-06
C22_74	22	74	8.9537613954706970e-12
R23_25	23	25	1.4140268928363831e-06
C23_25	23	25	6.2616827599646771e-11
R23_24	23	24	7.3300729981391379e-06
C23_24	23	24	1.2079262811226828e-11
R23_28	23	28	9.1264864090852267e-07
C23_28	23	28	9.7016391852464056e-11
R23_29	23	29	1.0695170756955449e-05
C23_29	23	29	8.2786783102474614e-12
R23_74	23	74	9.9297512630615997e-06
C23_74	23	74	8.9168274032576576e-12
R23_75	23	75	1.0889891982390553e-05
C23_75	23	75	8.1306479727417165e-12
R24_25	24	25	6.9285199688223659e-06
C24_25	24	25	1.2779335062672753e-11
R24_74	24	74	2.4027746920664571e-06
C24_74	24	74	3.6849846330723322e-11
R24_62	24	62	2.2097156690658795e-05
C24_62	24	62	4.0069353450993806e-12
R24_66	24	66	1.6827295890349772e-05
C24_66	24	66	5.2618007520018454e-12
R24_27	24	27	9.2215113213597735e-06
C24_27	24	27	9.6016666991353753e-12
R24_28	24	28	1.2249208310891932e-05
C24_28	24	28	7.2283755752009724e-12
R24_26	24	26	1.4072519154991264e-05
C24_26	24	26	6.2918285770174861e-12
R24_75	24	75	7.4365422827695554e-06
C24_75	24	75	1.1906323504022997e-11
R25_29	25	29	9.3006662891909421e-06
C25_29	25	29	9.5199500140007945e-12
R25_26	25	26	5.8003465619412518e-06
C25_26	25	26	1.5264928952860178e-11
R25_75	25	75	8.1539621286982483e-06
C25_75	25	75	1.0858755139219100e-11
R26_29	26	29	5.1622805821657687e-05
C26_29	26	29	1.7151698122703240e-12
R26_27	26	27	6.9292356807594240e-05
C26_27	26	27	1.2778015101413907e-12
R26_75	26	75	1.1317751611907056e-05
C26_75	26	75	7.8232745518860674e-12
R27_74	27	74	1.2154513784097180e-05
C27_74	27	74	7.2846910820774372e-12
R27_66	27	66	1.0182192085687535e-05
C27_66	27	66	8.6957579885433257e-12
R27_75	27	75	1.7184360345530477e-05
C27_75	27	75	5.1524686627645752e-12
R27_67	27	67	3.4599383246034549e-05
C27_67	27	67	2.5590594358397369e-12
R27_76	27	76	5.6512325968523077e-06
C27_76	27	76	1.5667710831671863e-11
R28_29	28	29	3.9055775423030464e-05
C28_29	28	29	3.6272997610479163e-11
R28_30	28	30	1.4319310478402958e+04
C28_30	28	30	6.1833897870671160e-11
R28_45	28	45	1.6721756647647704e+04
C28_45	28	45	5.2950105683098453e-11
R28_74	28	74	1.6483505841834167e-05
C28_74	28	74	5.9086984785978271e-11
R28_75	28	75	1.5096900994468386e-05
C28_75	28	75	6.4513946223327917e-11
R28_77	28	77	1.4151930003417307e+04
C28_77	28	77	6.2565231843727007e-11
R28_79	28	79	1.9787130801901720e+04
C28_79	28	79	4.4747204158316045e-11
R29_30	29	30	1.0440895359611315e+04
C29_30	29	30	8.4802955225955048e-11
R29_75	29	75	9.7298731161097561e-06
C29_75	29	75	3.9433347934090171e-11
R29_79	29	79	9.2525018613098327e+03
C29_79	29	79	9.5695066585445219e-11
R29_80	29	80	3.2181555342260184e+04
C29_80	29	80	2.7513237700394354e-11
R30_45	30	45	3.5162056605216253e+03
C30_45	30	45	2.5181086295408819e-10
R30_52	30	52	4.2050773819005590e+03
C30_52	30	52	2.1055945022819517e-10
R30_73	30	73	4.3210573790722929e+03
C30_73	30	73	2.0490789730963825e-10
R30_77	30	77	3.4838227749724115e+03
C30_77	30	77	2.5415149934169995e-10
R30_78	30	78	2.9943435499850116e+03
C30_78	30	78	2.9569712590408404e-10
R30_79	30	79	3.0026779544972019e+03
C30_79	30	79	2.9487637206443713e-10
R30_80	30	80	5.4257193855725700e+03
C30_80	30	80	1.6318919552942613e-10
R31_33	31	33	3.3893530772250067e-06
C31_33	31	33	2.8735886663464934e-10
R31_35	31	35	4.4360541300721461e+03
C31_35	31	35	1.9959602740140591e-10
R31_38	31	38	4.9631825709840984e-06
C31_38	31	38	1.7839738293657807e-11
R31_39	31	39	5.4282948223487059e-06
C31_39	31	39	1.2505235764326841e-10
R31_40	31	40	1.7248319832791742e-05
C31_40	31	40	1.0780061222637299e-10
R31_54	31	54	1.0791882896061861e+04
C31_54	31	54	8.2044884125188587e-11
R31_96	31	96	6.4192036905445029e+03
C31_96	31	96	1.3793280668196015e-10
R32_33	32	33	2.9986962613467526e+03
C32_33	32	33	2.9526791129634024e-10
R32_34	32	34	3.4573019205675769e+03
C32_34	32	34	2.5610108750775317e-10
R32_37	32	37	2.0069921469062813e+03
C32_37	32	37	4.4116703847837498e-10
R32_39	32	39	8.9949815995759436e+03
C32_39	32	39	9.8434751855606014e-11
R32_56	32	56	1.3067698676739549e+03
C32_56	32	56	6.7756290040268660e-10
R32_57	32	57	2.5631845267989902e+03
C32_57	32	57	3.4543700324445509e-10
R32_58	32	58	6.6176449486815654e+03
C32_58	32	58	1.3379665856452486e-10
R32_72	32	72	6.2233174689963525e+03
C32_72	32	72	1.4227440366187736e-10
R32_96	32	96	6.2216184033900181e+03
C32_96	32	96	1.4231325746650669e-10
R33_34	33	34	3.7393132190797101e+03
C33_34	33	34	2.3678647115790749e-10
R33_35	33	35	5.0826148588247343e+03
C33_35	33	35	1.7420536599634025e-10
R33_37	33	37	5.6266188610629034e-06
C33_37	33	37	1.2064457932542797e-10
R33_38	33	38	4.7791320765601281e-06
C33_38	33	38	1.8526769453446394e-11
R33_39	33	39	5.9253591104939940e-06
C33_39	33	39	2.3908593929539712e-10
R33_96	33	96	5.3575897787593794e+03
C33_96	33	96	1.6526438534176657e-10
R34_35	34	35	2.8878342785078712e+03
C34_35	34	35	3.0660304446468839e-10
R34_57	34	57	5.1156369911983320e+03
C34_57	34	57	1.7308084667137258e-10
R34_58	34	58	4.8509233894585368e+03
C34_58	34	58	1.8252582253186875e-10
R34_59	34	59	2.5771242032164887e+03
C34_59	34	59	3.4356853293873687e-10
R34_96	34	96	5.9810463202281726e+03
C34_96	34	96	1.4803743931985163e-10
R35_59	35	59	6.9249239263687950e+03
C35_59	35	59	1.2785971241192899e-10
R35_55	35	55	3.6003278403217905e+03
C35_55	35	55	2.4592726578501339e-10
R35_54	35	54	6.9252653271115623e+03
C35_54	35	54	1.2785340920205533e-10
R35_96	35	96	3.1316561748516310e+03
C35_96	35	96	2.8273179821279354e-10
R36_46	36	46	1.6244787227099313e-06
C36_46	36	46	5.4504794019275151e-11
R36_41	36	41	3.6544367084655436e-06
C36_41	36	41	2.4228598066807877e-11
R36_61	36	61	5.4521927417582655e-06
C36_61	36	61	1.6239682337687561e-11
R36_68	36	68	2.4346423658069647e-06
C36_68	36	68	3.6367509008105468e-11
R36_98	36	98	5.6112243377769116e-06
C36_98	36	98	1.5779422250845001e-11
R37_38	37	38	3.8345722599229270e-06
C37_38	37	38	2.3090418479108184e-11
R37_39	37	39	8.7578328138599457e-06
C37_39	37	39	2.1231045138343244e-10
R37_41	37	41	6.1785640815648524e-06
C37_41	37	41	1.4330494432223304e-11
R37_46	37	46	4.6857344847094697e-06
C37_46	37	46	2.0785656167123343e-10
R37_56	37	56	2.9537610475601500e+03
C37_56	37	56	2.9975978674082965e-10
R37_72	37	72	2.2014550312742194e+03
C37_72	37	72	4.0219707835118154e-10
R37_99	37	99	3.1066351894038035e+03
C37_99	37	99	2.8500893336945728e-10
R37_100	37	100	6.5418027011639942e-06
C37_100	37	100	1.0376666746563128e-10
R38_39	38	39	1.3668321368769591e-06
C38_39	38	39	6.4778896969972579e-11
R38_41	38	41	6.8339194897538015e-06
C38_41	38	41	1.2956236652005070e-11
R38_42	38	42	5.3033411220461688e-06
C38_42	38	42	1.6695489905774382e-11
R38_100	38	100	6.6029166178234926e-06
C38_100	38	100	1.3409510265659827e-11
R39_40	39	40	3.7258125885547523e-06
C39_40	39	40	2.6140892375744526e-10
R39_42	39	42	3.7571369940447502e-06
C39_42	39	42	2.3566316136553795e-11
R39_44	39	44	6.4586593931748184e-06
C39_44	39	44	1.5079919834838653e-10
R39_56	39	56	5.9875658059616399e+03
C39_56	39	56	1.4787625061563667e-10
R39_96	39	96	2.3472568273662591e+03
C39_96	39	96	3.7721427471295711e-10
R39_99	39	99	3.9839515123846413e+03
C39_99	39	99	2.2224637497408253e-10
R39_100	39	100	5.0744077376669771e-06
C39_100	39	100	1.9193582960754154e-10
R39_101	39	101	3.4707964319242037e+03
C39_101	39	101	2.5510536243381049e-10
R40_42	40	42	7.3651543211359937e-06
C40_42	40	42	1.2021727489933082e-11
R40_43	40	43	9.8162791846366827e-06
C40_43	40	43	9.0199021955870625e-12
R40_44	40	44	6.5912939033819563e-06
C40_44	40	44	1.4776471405656872e-10
R40_48	40	48	1.9764320486215582e-05
C40_48	40	48	4.9278732328557317e-11
R40_95	40	95	6.2947697579861342e+03
C40_95	40	95	1.4065943882644396e-10
R40_54	40	54	1.1019303566030241e+04
C40_54	40	54	8.0351609917483795e-11
R40_96	40	96	8.3521194361768084e+03
C40_96	40	96	1.0601126917137355e-10
R40_101	40	101	8.4187202088789581e+03
C40_101	40	101	1.0517261053125117e-10
R41_46	41	46	2.3764919787063217e-06
C41_46	41	46	3.7257385660606812e-11
R41_61	41	61	6.5666230703965715e-06
C41_61	41	61	1.3483624264831266e-11
R41_98	41	98	2.8497334373281648e-06
C41_98	41	98	3.1070231696131739e-11
R41_87	41	87	2.9255355882760909e-06
C41_87	41	87	3.0265185808993847e-11
R41_100	41	100	9.0332635164798219e-07
C41_100	41	100	9.8017596861276916e-11
R41_42	41	42	3.9079260313620231e-06
C41_42	41	42	2.2656999508033332e-11
R41_103	41	103	3.3573188312568575e-06
C41_103	41	103	2.6372794071766241e-11
R42_43	42	43	5.5882159840391529e-06
C42_43	42	43	1.5844390843677109e-11
R42_44	42	44	1.3682779674199099e-06
C42_44	42	44	6.4710446472333986e-11
R42_88	42	88	4.7400420643766447e-06
C42_88	42	88	1.8679555364166163e-11
R42_100	42	100	4.4423768096571325e-06
C42_100	42	100	1.9931194935450277e-11
R42_103	42	103	4.6242595881185629e-06
C42_103	42	103	1.9147255140584436e-11
R42_87	42	87	8.6329023242713313e-06
C42_87	42	87	1.0256328039420218e-11
R43_44	43	44	4.0820754030458237e-06
C43_44	43	44	2.1690407311911689e-11
R43_48	43	48	2.3408781524856678e-06
C43_48	43	48	3.7824214846886227e-11
R43_88	43	88	4.6149938801966223e-06
C43_88	43	88	1.9185697851072269e-11
R43_104	43	104	5.1146920757782383e-06
C43_104	43	104	1.7311282254763638e-11
R43_47	43	47	7.1659535280173503e-06
C43_47	43	47	1.2355910183316170e-11
R44_48	44	48	6.4572650744930512e-06
C44_48	44	48	2.1939165145798437e-10
R44_88	44	88	4.4233635806512111e-06
C44_88	44	88	2.0016866476294674e-11
R44_95	44	95	5.5640918973537309e+03
C44_95	44	95	1.5913086951728875e-10
R44_100	44	100	6.2511539383413398e-06
C44_100	44	100	1.5580493913647995e-10
R44_101	44	101	7.5671646105162563e+02
C44_101	44	101	1.1700799801150276e-09
R44_103	44	103	4.1651052295460461e-06
C44_103	44	103	1.6297813094903180e-10
R44_104	44	104	3.8637589933690971e-06
C44_104	44	104	2.5207593448958139e-10
R44_105	44	105	2.2335522516509654e+03
C44_105	44	105	3.9641731284572762e-10
R45_52	45	52	1.2143463597486705e+03
C45_52	45	52	7.2913199318459068e-10
R45_70	45	70	1.7385088194369480e+03
C45_70	45	70	5.0929783720439297e-10
R45_69	45	69	1.8739561111569717e+03
C45_69	45	69	4.7248640265824941e-10
R45_71	45	71	1.2995828253237066e+03
C45_71	45	71	6.8131000536995820e-10
R45_73	45	73	1.1976839580383810e+03
C45_73	45	73	7.3927581291994374e-10
R45_74	45	74	4.9230841573921889e+03
C45_74	45	74	1.7985042574795554e-10
R45_77	45	77	1.5353852290306597e+03
C45_77	45	77	5.7667532874404070e-10
R45_107	45	107	1.7875560947894421e+03
C45_107	45	107	4.9532363447553468e-10
R46_68	46	68	2.7885972389626688e-06
C46_68	46	68	5.0802246692390133e-10
R46_70	46	70	3.6596710434863558e+03
C46_70	46	70	2.4193944515201926e-10
R46_72	46	72	2.6651140407747648e+03
C46_72	46	72	3.3222547634119380e-10
R46_98	46	98	3.8038820365470115e-06
C46_98	46	98	1.7845481510611069e-10
R46_99	46	99	3.7529761227305989e+03
C46_99	46	99	2.3592443776481713e-10
R46_100	46	100	5.5065398286980345e-06
C46_100	46	100	2.5727046251655863e-10
R46_108	46	108	1.5853284182943546e+03
C46_108	46	108	5.5850811193595876e-10
R47_88	47	88	8.4624825243048764e-06
C47_88	47	88	1.0462872793615958e-11
R47_104	47	104	4.6066711470264451e-06
C47_104	47	104	1.9220360070015585e-11
R47_89	47	89	4.6084852833761124e-06
C47_89	47	89	1.9212793949758576e-11
R47_48	47	48	1.1215653412263812e-05
C47_48	47	48	7.8944912895742149e-12
R47_110	47	110	2.4589128286394944e-06
C47_110	47	110	3.6008547004486461e-11
R47_82	47	82	1.5054568338609177e-05
C47_82	47	82	5.8813960107327780e-12
R48_95	48	95	5.0618940614938392e+03
C48_95	48	95	1.7491847339031426e-10
R48_104	48	104	4.6187710222692699e-06
C48_104	48	104	1.4697006243533976e-10
R48_105	48	105	1.7036745023650594e+03
C48_105	48	105	5.1971123619614667e-10
R48_110	48	110	1.4780099173560339e-05
C48_110	48	110	1.2580290673403783e-10
R48_111	48	111	8.5229613233200889e+03
C48_111	48	111	1.0388628413429059e-10
R49_51	49	51	6.4077836867906877e-06
C49_51	49	51	1.3817863164220801e-11
R49_113	49	113	3.6914307044201223e-06
C49_113	49	113	2.3985789050294215e-11
R49_50	49	50	1.0699693181994674e-05
C49_50	49	50	8.2751791723333985e-12
R49_91	49	91	6.7241926689194932e-06
C49_91	49	91	1.3167659305667658e-11
R49_115	49	115	7.2336065831898890e-06
C49_115	49	115	1.2240350252910032e-11
R49_82	49	82	1.0699693181994632e-05
C49_82	49	82	8.2751791723334341e-12
R49_116	49	116	3.4952331061182568e-06
C49_116	49	116	2.5332181139796144e-11
R50_51	50	51	8.8585598671634117e-06
C50_51	50	51	9.9950646039209834e-12
R50_113	50	113	4.0187929475435202e-06
C50_113	50	113	2.2031958183892267e-11
R50_114	50	114	1.0153233797373260e-05
C50_114	50	114	8.7205593741874281e-12
R50_116	50	116	1.2060202772709000e-05
C50_116	50	116	7.3416575026716118e-12
R50_117	50	117	3.9661069520989299e-06
C50_117	50	117	2.2324631997919814e-11
R51_113	51	113	4.1323148881644913e-07
C51_113	51	113	2.1426701634862314e-10
R51_91	51	91	5.2402707114684717e-06
C51_91	51	91	1.6896432082454009e-11
R51_114	51	114	5.6041212861707286e-06
C51_114	51	114	1.5799422183901426e-11
R51_119	51	119	7.5130942292002930e-06
C51_119	51	119	1.1785008342617921e-11
R52_53	52	53	8.6682098663286088e+03
C52_53	52	53	1.0214551739677897e-10
R52_71	52	71	2.6340009914301140e+03
C52_71	52	71	3.3614975263136394e-10
R52_73	52	73	1.9618534724406354e+03
C52_73	52	73	4.5131748835375490e-10
R52_78	52	78	8.8772131973979249e+03
C52_78	52	78	9.9740623775886407e-11
R52_127	52	127	4.4038438089423880e+03
C52_127	52	127	2.0105590028013259e-10
R53_70	53	70	7.1258000675127196e+03
C53_70	53	70	1.2425535003945991e-10
R53_71	53	71	2.7405596475986658e+03
C53_71	53	71	3.2307955146162276e-10
R53_72	53	72	3.5968926106559757e+03
C53_72	53	72	2.4616213980837299e-10
R53_57	53	57	8.7147161207881982e+03
C53_57	53	57	1.0160041582856733e-10
R53_125	53	125	7.4303952938150715e+03
C53_125	53	125	1.1916173321720943e-10
R53_127	53	127	7.2980870672672618e+03
C53_127	53	127	1.2132203597175518e-10
R53_129	53	129	3.9485016289838582e+03
C53_129	53	129	2.2424171619953502e-10
R53_130	53	130	5.2539186528037353e+03
C53_130	53	130	1.6852540745515720e-10
R54_96	54	96	1.7423703963366413e+03
C54_96	54	96	5.0816909169348024e-10
R54_55	54	55	1.1066727621776952e+04
C54_55	54	55	8.0007280558499112e-11
R54_95	54	95	1.1041682043247753e+04
C54_95	54	95	8.0188759124924678e-11
R54_134	54	134	1.0181982649791391e+04
C54_134	54	134	8.6959368538910314e-11
R54_136	54	136	1.2550720597075868e+04
C54_136	54	136	7.0547246658195037e-11
R55_59	55	59	3.5351256088908845e+03
C55_59	55	59	2.5046317434185670e-10
R55_60	55	60	3.7806468859034685e+03
C55_60	55	60	2.3419769378657789e-10
R55_96	55	96	3.6845604214846921e+03
C55_96	55	96	2.4030513288291276e-10
R55_133	55	133	2.0061154293048212e+03
C55_133	55	133	4.4135983840512306e-10
R55_136	55	136	4.0615768838970848e+03
C55_136	55	136	2.1799877412401464e-10
R55_137	55	137	7.4876883946227654e+03
C55_137	55	137	1.1824995045678686e-10
R56_58	56	58	2.5479461646168129e+03
C56_58	56	58	3.4750293942460862e-10
R56_57	56	57	4.4178743391872003e+03
C56_57	56	57	2.0041737580587214e-10
R56_72	56	72	1.6830320513967688e+03
C56_72	56	72	5.2608551391827634e-10
R56_96	56	96	3.2770062694279945e+03
C56_96	56	96	2.7019136031575281e-10
R56_99	56	99	2.0149461009650856e+03
C56_99	56	99	4.3942554159434683e-10
R56_125	56	125	4.7018084515227592e+03
C56_125	56	125	1.8831451575047517e-10
R56_138	56	138	2.7212614955024515e+03
C56_138	56	138	3.2537070882874383e-10
R57_58	57	58	2.2610829341126550e+03
C57_58	57	58	3.9159058181449511e-10
R57_59	57	59	8.9470347615954943e+03
C57_59	57	59	9.8962260155800088e-11
R57_72	57	72	3.7389947599111479e+03
C57_72	57	72	2.3680663883065753e-10
R57_125	57	125	2.2670718862006383e+03
C57_125	57	125	3.9055611208864845e-10
R57_130	57	130	8.4961275185185623e+03
C57_130	57	130	1.0421439411897941e-10
R57_140	57	140	6.3699491223602681e+03
C57_140	57	140	1.3899934908301501e-10
R58_59	58	59	1.2571353939545616e+03
C58_59	58	59	7.0431457578705566e-10
R58_96	58	96	2.3263287620062224e+03
C58_96	58	96	3.8060776110441773e-10
R58_125	58	125	2.1355312945578621e+03
C58_125	58	125	4.1461288062431140e-10
R58_133	58	133	2.1755077619318736e+03
C58_133	58	133	4.0699408073531252e-10
R58_132	58	132	5.3205413522928493e+03
C58_132	58	132	1.6641516775702444e-10
R58_138	58	138	1.6231144153564474e+03
C58_138	58	138	5.4550607974580515e-10
R58_139	58	139	1.7933736791755503e+03
C58_139	58	139	4.9371683770169130e-10
R58_140	58	140	2.5761755527756700e+03
C58_140	58	140	3.4369504855599462e-10
R58_141	58	141	5.6651699747643934e+03
C58_141	58	141	1.5629165332092677e-10
R59_60	59	60	6.8440891708161553e+03
C59_60	59	60	1.2936984887273379e-10
R59_96	59	96	9.1960018549292708e+03
C59_96	59	96	9.6283014691367738e-11
R59_133	59	133	4.3999072074532996e+03
C59_133	59	133	2.0123578520022637e-10
R59_140	59	140	1.3947993110700694e+04
C59_140	59	140	6.3480012835733328e-11
R59_141	59	141	8.2151156426401958e+03
C59_141	59	141	1.0777922310725278e-10
R60_133	60	133	4.1810264743070775e+03
C60_133	60	133	2.1177067094432616e-10
R60_137	60	137	4.7582941555924353e+03
C60_137	60	137	1.8607903436557512e-10
R60_141	60	141	5.6529855461920415e+03
C60_141	60	141	1.5662852389503012e-10
R60_142	60	142	1.6748763825840328e+04
C60_142	60	142	5.2864724280962059e-11
R61_62	61	62	4.8002029308108304e-06
C61_62	61	62	1.8445444796027380e-11
R61_63	61	63	3.8216591405849480e-06
C61_63	61	63	2.3168439390554243e-11
R61_68	61	68	4.1234595485285873e-06
C61_68	61	68	2.1472716569171931e-11
R61_85	61	85	3.2216613504937874e-06
C61_85	61	85	2.7483297757670618e-11
R61_86	61	86	4.4963652638593553e-06
C61_86	61	86	1.9691878433826805e-11
R61_64	61	64	3.6457261096465240e-06
C61_64	61	64	2.4286486561818185e-11
R61_97	61	97	2.2645200466303939e-06
C61_97	61	97	3.9099622148079593e-11
R61_98	61	98	7.1405632141745217e-07
C61_98	61	98	1.2399845154264320e-10
R61_87	61	87	4.8163681356770126e-06
C61_87	61	87	1.8383536240539913e-11
R61_102	61	102	3.2640709909310224e-06
C61_102	61	102	2.7126210923722856e-11
R61_65	61	65	7.2902953464736102e-06
C61_65	61	65	1.2145170251960863e-11
R61_143	61	143	2.9595603781084609e-06
C61_143	61	143	2.9917240014744897e-11
R62_63	62	63	1.2787477966074879e-06
C62_63	62	63	6.9241079753882039e-11
R62_74	62	74	4.9311970966820419e-06
C62_74	62	74	1.7955453094660408e-11
R62_66	62	66	5.8333103566620380e-06
C62_66	62	66	1.5178667472900554e-11
R62_65	62	65	4.0728517849160085e-06
C62_65	62	65	2.1739528675685882e-11
R62_143	62	143	5.0967309857251541e-06
C62_143	62	143	1.7372287926905839e-11
R62_144	62	144	4.4594894573516648e-06
C62_144	62	144	1.9854711849141121e-11
R63_68	63	68	3.4526402575612119e-06
C63_68	63	68	3.6757384419027209e-10
R63_69	63	69	1.4750748964043962e+03
C63_69	63	69	6.0025344059360889e-10
R63_74	63	74	5.6524857849600616e-06
C63_74	63	74	1.7230660915371433e-10
R63_98	63	98	8.6482942097716245e-06
C63_98	63	98	1.1261881652864799e-10
R63_106	63	106	1.4981146601424969e+03
C63_106	63	106	5.9102203940503544e-10
R63_143	63	143	4.0466879258759302e-06
C63_143	63	143	3.1361455969035751e-10
R63_144	63	144	7.5372462264941550e-06
C63_144	63	144	1.2921969504889899e-10
R63_145	63	145	1.7678823558571430e+03
C63_145	63	145	5.0083580435459018e-10
R63_146	63	146	4.7462277077531207e+03
C63_146	63	146	1.8655210753028957e-10
R64_85	64	85	7.6785398395297668e-07
C64_85	64	85	1.1531082734529683e-10
R64_86	64	86	4.3784274936569096e-06
C64_86	64	86	2.0222300882742007e-11
R64_83	64	83	4.7187770528498576e-06
C64_83	64	83	1.8763734157884411e-11
R64_94	64	94	1.2095667283239289e-06
C64_94	64	94	7.3201317543423691e-11
R64_81	64	81	3.4287355050281421e-06
C64_81	64	81	2.5823478667326743e-11
R64_97	64	97	2.3292809494820711e-06
C64_97	64	97	3.8012536954671695e-11
R64_143	64	143	2.5913996584791243e-06
C64_143	64	143	3.4167588885909124e-11
R64_65	64	65	5.4288447634678827e-06
C64_65	64	65	1.6309524775108969e-11
R64_150	64	150	4.5558963410288212e-06
C64_150	64	150	1.9434568203982734e-11
R64_151	64	151	4.2315716202151517e-06
C64_151	64	151	2.0924111917902065e-11
R65_143	65	143	1.2774111349792198e-06
C65_143	65	143	6.9313532460667301e-11
R65_66	65	66	8.7262399269493890e-06
C65_66	65	66	1.0146624309120207e-11
R65_144	65	144	4.1850750239218239e-06
C65_144	65	144	2.1156580865073150e-11
R65_151	65	151	5.3448023179306028e-06
C65_151	65	151	1.6565978104178343e-11
R65_153	65	153	5.9113727324854765e-06
C65_153	65	153	1.4978226238962262e-11
R65_159	65	159	5.5643087228976918e-06
C65_159	65	159	1.5912466863249563e-11
R66_74	66	74	3.7690613661020199e-06
C66_74	66	74	2.3491758177864429e-11
R66_67	66	67	3.9161053233092979e-06
C66_67	66	67	2.2609677437168070e-11
R66_76	66	76	3.7144657012512458e-06
C66_76	66	76	2.3837042872727029e-11
R66_144	66	144	1.1433210985560394e-06
C66_144	66	144	7.7442704662604606e-11
R66_153	66	153	3.7035429530086216e-06
C66_153	66	153	2.3907344748917206e-11
R66_162	66	162	4.5942780880406249e-06
C66_162	66	162	1.9272206965547765e-11
R67_76	67	76	8.8340662710872749e-06
C67_76	67	76	1.0022777218661558e-11
R67_153	67	153	4.6410674924457542e-06
C67_153	67	153	1.9077912207508131e-11
R67_155	67	155	1.1857807075284909e-05
C67_155	67	155	7.4669690279028759e-12
R67_162	67	162	1.9367751556298690e-06
C67_162	67	162	4.5716136905527810e-11
R68_69	68	69	2.2485446830190167e+03
C68_69	68	69	3.9377415462840139e-10
R68_70	68	70	1.3521712512855690e+03
C68_70	68	70	6.5481260665628955e-10
R68_98	68	98	4.4851368019409414e-06
C68_98	68	98	2.1715294357901386e-10
R68_108	68	108	3.2447558428164939e+03
C68_108	68	108	2.7287685871965150e-10
R68_145	68	145	5.2410621222347663e+03
C68_145	68	145	1.6893880687727119e-10
R68_146	68	146	5.3094429003760151e+03
C68_146	68	146	1.6676302925063845e-10
R68_163	68	163	3.0080126707120203e+03
C68_163	68	163	2.9435340825556244e-10
R69_70	69	70	1.3960656636168251e+03
C69_70	69	70	6.3422430962603979e-10
R69_74	69	74	3.5290135279713304e+03
C69_74	69	74	2.5089696445821987e-10
R69_77	69	77	5.3405065240036884e+03
C69_77	69	77	1.6579303437236816e-10
R69_106	69	106	1.3960656636168267e+03
C69_106	69	106	6.3422430962603907e-10
R69_107	69	107	1.0692874749104301e+03
C69_107	69	107	8.2804559342114048e-10
R69_145	69	145	1.2165152392291977e+03
C69_145	69	145	7.2783205104854634e-10
R69_163	69	163	1.6348877173125700e+03
C69_163	69	163	5.4157773180622592e-10
R70_71	70	71	1.0849680853047369e+03
C70_71	70	71	8.1607818118568089e-10
R70_72	70	72	2.7792485716997289e+03
C70_72	70	72	3.1858207672244914e-10
R70_107	70	107	4.1142387810617283e+03
C70_107	70	107	2.1520840884969426e-10
R70_108	70	108	3.7664960700330976e+03
C70_108	70	108	2.3507758012667186e-10
R70_163	70	163	1.3460121422819100e+03
C70_163	70	163	6.5780891114320820e-10
R70_164	70	164	4.1788550832254150e+03
C70_164	70	164	2.1188070992320626e-10
R71_72	71	72	5.4448492571822335e+03
C71_72	71	72	1.6261584846119572e-10
R71_73	71	73	2.2468158975542506e+03
C71_73	71	73	3.9407713941485551e-10
R71_107	71	107	3.1348539945894677e+03
C71_107	71	107	2.8244338754792705e-10
R71_126	71	126	1.0975171164440658e+03
C71_126	71	126	8.0674712807098624e-10
R71_127	71	127	1.9702052846346662e+03
C71_127	71	127	4.4940432786636384e-10
R71_128	71	128	2.9494761135729764e+03
C71_128	71	128	3.0019527116204021e-10
R71_129	71	129	2.0205971664318802e+03
C71_129	71	129	4.3819658683553346e-10
R71_163	71	163	4.0527557137404474e+03
C71_163	71	163	2.1847326713970933e-10
R71_164	71	164	1.9566863418261855e+03
C71_164	71	164	4.5250930758459440e-10
R72_99	72	99	1.8093749573374462e+03
C72_99	72	99	4.8935063354857224e-10
R72_108	72	108	3.0488932460986694e+03
C72_108	72	108	2.9040661978997540e-10
R72_125	72	125	1.9776996937819142e+03
C72_125	72	125	4.4770132921790171e-10
R72_129	72	129	3.0394758885505594e+03
C72_129	72	129	2.9130640089473830e-10
R72_138	72	138	4.1905089030690960e+03
C72_138	72	138	2.1129146893150054e-10
R72_164	72	164	3.4017092176650062e+03
C72_164	72	164	2.6028643985853888e-10
R72_165	72	165	2.5824343302451912e+03
C72_165	72	165	3.4286207061688701e-10
R73_77	73	77	2.6925581912972552e+03
C73_77	73	77	3.2883923718410395e-10
R73_78	73	78	1.3417937076887549e+03
C73_78	73	78	6.5987698155563535e-10
R73_107	73	107	2.9731327456219838e+03
C73_107	73	107	2.9780667647746395e-10
R73_126	73	126	1.5478872796670094e+03
C73_126	73	126	5.7201760963529375e-10
R73_127	73	127	2.2367245791077753e+03
C73_127	73	127	3.9585507754074574e-10
R73_170	73	170	4.8769657025274100e+03
C73_170	73	170	1.8155116023086772e-10
R73_171	73	171	1.8900466047411662e+03
C73_171	73	171	4.6846399420994932e-10
R74_75	74	75	4.8803861821477318e-06
C74_75	74	75	1.9956630941599481e-10
R74_76	74	76	4.3255830481809559e-06
C74_76	74	76	2.2516286198819395e-10
R74_77	74	77	2.3174888911680969e+03
C74_77	74	77	3.8205955811668084e-10
R74_106	74	106	2.0010810995056738e+03
C74_106	74	106	4.4247021368535467e-10
R74_144	74	144	4.6808476102787855e-06
C74_144	74	144	2.0807356700895287e-10
R74_168	74	168	3.5244545278672381e+03
C74_168	74	168	2.5122150809413212e-10
R74_176	74	176	5.6942406820441092e+03
C74_176	74	176	1.5549374027902065e-10
R75_76	75	76	1.3390351950760404e-05
C75_76	75	76	7.2736001449217361e-11
R75_77	75	77	5.1521557679265397e+03
C75_77	75	77	1.7185403966470770e-10
R75_79	75	79	2.9880739597780994e+03
C75_79	75	79	2.9631755894213314e-10
R75_176	75	176	5.0199567081611185e+03
C75_176	75	176	1.7637976444309644e-10
R76_144	76	144	1.0070491880332216e-05
C76_144	76	144	1.4067535781065148e-10
R76_162	76	162	8.8375611687599373e-06
C76_162	76	162	6.0112881666075985e-11
R76_168	76	168	6.7935743084573778e+03
C76_168	76	168	1.3033180200851484e-10
R76_169	76	169	6.8294096019036979e+03
C76_169	76	169	1.2964792468344403e-10
R76_176	76	176	6.7083173284293189e+03
C76_176	76	176	1.3198820782488406e-10
R77_78	77	78	3.2741402285734789e+03
C77_78	77	78	2.7042787415546070e-10
R77_79	77	79	1.8507677798992861e+03
C77_79	77	79	4.7840620055973868e-10
R77_106	77	106	4.5274922464080073e+03
C77_106	77	106	1.9556494710785382e-10
R77_107	77	107	1.5863723827708327e+03
C77_107	77	107	5.5814056731968951e-10
R77_168	77	168	2.5457855262221460e+03
C77_168	77	168	3.4779786929417015e-10
R77_171	77	171	2.9866343622543741e+03
C77_171	77	171	2.9646038795042440e-10
R77_174	77	174	5.7078089223142915e+03
C77_174	77	174	1.5512411045130042e-10
R77_175	77	175	1.2067602934606514e+03
C77_175	77	175	7.3371554110457730e-10
R77_176	77	176	1.8067660202972475e+03
C77_176	77	176	4.9005724690036628e-10
R77_177	77	177	3.0056098758465537e+03
C77_177	77	177	2.9458872517532405e-10
R78_79	78	79	9.3513488628101422e+03
C78_79	78	79	9.4683536534634827e-11
R78_80	78	80	7.3325174337500948e+03
C78_80	78	80	1.2075235956816092e-10
R78_127	78	127	1.2484391660022156e+04
C78_127	78	127	7.0922060586685293e-11
R78_170	78	170	7.2552741704926075e+03
C78_170	78	170	1.2203794934463286e-10
R78_171	78	171	4.4442421536199008e+03
C78_171	78	171	1.9922829384506272e-10
R78_172	78	172	7.7832057483990220e+03
C78_172	78	172	1.1376016648180314e-10
R78_174	78	174	5.2477348984307573e+03
C78_174	78	174	1.6872399212939834e-10
R78_173	78	173	7.4380050513945580e+03
C78_173	78	173	1.1903981989552319e-10
R78_177	78	177	5.3687653414448114e+03
C78_177	78	177	1.6492037282108537e-10
R79_80	79	80	3.1331851450540780e+03
C79_80	79	80	2.8259382727435913e-10
R79_176	79	176	7.0809681621814452e+03
C79_176	79	176	1.2504205094847194e-10
R79_177	79	177	4.4721868552519318e+03
C79_177	79	177	1.9798340506730049e-10
R80_177	80	177	5.7660460742495197e+03
C80_177	80	177	1.5355735460633512e-10
R80_173	80	173	1.5613894807606428e+04
C80_173	80	173	5.6707105601138130e-11
R81_94	81	94	3.3648326443155285e-06
C81_94	81	94	2.6313902511490616e-11
R81_83	81	83	3.2116502311723505e-06
C81_83	81	83	2.7568966667232477e-11
R81_150	81	150	2.7335939137507603e-06
C81_150	81	150	3.2390282157349345e-11
R81_151	81	151	4.3574516556226097e-06
C81_151	81	151	2.0319646703538424e-11
R81_152	81	152	2.7467663849950690e-06
C81_152	81	152	3.2234950396103297e-11
R81_181	81	181	1.3717880467079124e-06
C81_181	81	181	6.4544867833254085e-11
R81_84	81	84	4.2911689154032636e-06
C81_84	81	84	2.0633510336117650e-11
R82_110	82	110	1.4058255373759494e-05
C82_110	82	110	6.2982123895165729e-12
R82_89	82	89	1.0305716544603304e-05
C82_89	82	89	8.5915305148156717e-12
R82_91	82	91	7.7564448963617451e-06
C82_91	82	91	1.1415265544080852e-11
R82_115	82	115	7.4237687430653043e-06
C82_115	82	115	1.1926809850146372e-11
R82_116	82	116	2.1087383060639164e-05
C82_116	82	116	4.1988082596777314e-12
R82_112	82	112	4.6231846531155321e-06
C82_112	82	112	1.9151707061999403e-11
R82_182	82	182	7.8348560116495912e-06
C82_182	82	182	1.1301021746710817e-11
R83_85	83	85	4.2776562367306589e-06
C83_85	83	85	2.0698689485546663e-11
R83_86	83	86	4.7926663659472494e-06
C83_86	83	86	1.8474450631303247e-11
R83_94	83	94	4.5922670587902739e-06
C83_94	83	94	1.9280646581848464e-11
R83_181	83	181	5.2837799308349627e-06
C83_181	83	181	1.6757298625041009e-11
R83_84	83	84	5.7902463523348165e-06
C83_84	83	84	1.5291556314231264e-11
R83_183	83	183	1.1483025395215026e-06
C83_183	83	183	7.7106751158884824e-11
R83_93	83	93	7.9727307501350762e-06
C83_93	83	93	1.1105589909517499e-11
R83_90	83	90	8.2785231421384745e-06
C83_90	83	90	1.0695371221385294e-11
R83_92	83	92	1.0970405589604335e-05
C83_92	83	92	8.0709758127724235e-12
R84_93	84	93	3.6685610882622556e-06
C84_93	84	93	2.4135315193004191e-11
R84_123	84	123	9.0477180631610572e-06
C84_123	84	123	9.7861004898582765e-12
R84_122	84	122	1.6580397836246606e-06
C84_122	84	122	5.3401540206977147e-11
R84_147	84	147	9.5858905990507859e-06
C84_147	84	147	9.2366877396626667e-12
R84_149	84	149	6.5659504374903906e-06
C84_149	84	149	1.3485005562095304e-11
R84_152	84	152	5.5396954844675146e-06
C84_152	84	152	1.5983167020327801e-11
R84_181	84	181	3.5435300606938867e-06
C84_181	84	181	2.4986913234386930e-11
R84_183	84	183	6.8002744160634083e-06
C84_183	84	183	1.3020338997033560e-11
R85_86	85	86	1.0550452537400057e-06
C85_86	85	86	8.3922351061369124e-11
R85_94	85	94	1.1913673527230143e-06
C85_94	85	94	7.4319543814615063e-11
R85_97	85	97	1.2241520314986784e-06
C85_97	85	97	7.2329151846933484e-11
R85_102	85	102	1.1317099688352675e-06
C85_102	85	102	7.8237252130177377e-11
R85_183	85	183	4.6914932084130114e-06
C85_183	85	183	1.8872856516390658e-11
R86_102	86	102	1.3506031305507003e-06
C86_102	86	102	6.5557287827326153e-11
R86_90	86	90	2.3044100294058035e-06
C86_90	86	90	3.8422796741962928e-11
R86_87	86	87	4.5796001283140288e-06
C86_87	86	87	1.9333975825220472e-11
R86_183	86	183	4.5141608334745684e-06
C86_183	86	183	1.9614249787783691e-11
R87_98	87	98	6.4178587868185517e-06
C87_98	87	98	1.3796171139173946e-11
R87_90	87	90	4.2134546145789236e-06
C87_90	87	90	2.1014081381970349e-11
R87_102	87	102	2.5951940425121652e-06
C87_102	87	102	3.4117633101643099e-11
R87_103	87	103	1.2324798958266509e-06
C87_103	87	103	7.1840423904531977e-11
R87_88	87	88	5.1295754738309862e-06
C87_88	87	88	1.7261053789286222e-11
R87_184	87	184	5.1341795193583947e-06
C87_184	87	184	1.7245575040014352e-11
R88_103	88	103	4.0996825423977492e-06
C88_103	88	103	2.1597252288274788e-11
R88_104	88	104	1.1606956192274485e-06
C88_104	88	104	7.6283460283009327e-11
R88_89	88	89	4.6499984791219249e-06
C88_89	88	89	1.9041270350419485e-11
R88_90	88	90	6.8913076018011334e-06
C88_90	88	90	1.2848342184995256e-11
R88_184	88	184	3.4718307153473382e-06
C88_184	88	184	2.5502936470547893e-11
R89_104	89	104	4.2219282175029524e-06
C89_104	89	104	2.0971905160047429e-11
R89_110	89	110	5.2345312450987066e-06
C89_110	89	110	1.6914958383886847e-11
R89_182	89	182	1.2400200878428811e-06
C89_182	89	182	7.1403583730668449e-11
R89_91	89	91	7.8736193726965150e-06
C89_91	89	91	1.1245384616512985e-11
R89_92	89	92	4.1603343993846374e-06
C89_92	89	92	2.1282394555374300e-11
R89_184	89	184	4.0383513036439850e-06
C89_184	89	184	2.1925254023864813e-11
R89_90	89	90	8.3702930060918501e-06
C89_90	89	90	1.0578109763369066e-11
R90_102	90	102	3.9537130370837382e-06
C90_102	90	102	2.2394614211887407e-11
R90_183	90	183	4.0439482204542404e-06
C90_183	90	183	2.1894908970930009e-11
R90_92	90	92	5.2833663504759362e-06
C90_92	90	92	1.6758610381433037e-11
R90_184	90	184	1.2078729479255340e-06
C90_184	90	184	7.3303966548854832e-11
R91_113	91	113	3.1970542199929004e-06
C91_113	91	113	2.7694831578488723e-11
R91_115	91	115	1.1905951302762757e-06
C91_115	91	115	7.4367747623370505e-11
R91_119	91	119	4.2322817327164843e-06
C91_119	91	119	2.0920601170180021e-11
R91_182	91	182	4.0567551915038910e-06
C91_182	91	182	2.1825787850209510e-11
R91_92	91	92	4.7725566808683725e-06
C91_92	91	92	1.8552294732283770e-11
R91_185	91	185	5.4041205549644490e-06
C91_185	91	185	1.6384141928266528e-11
R92_182	92	182	4.9551421824000394e-06
C92_182	92	182	1.7868685682620402e-11
R92_183	92	183	4.6239972937671615e-06
C92_183	92	183	1.9148341260785020e-11
R92_93	92	93	3.5884532036496626e-06
C92_93	92	93	2.4674106960611284e-11
R92_184	92	184	4.5532206978440657e-06
C92_184	92	184	1.9445988684871851e-11
R92_185	92	185	1.1799016201437934e-06
C92_185	92	185	7.5041746412052144e-11
R92_119	92	119	9.3323518348789443e-06
C92_119	92	119	9.4876275280451368e-12
R93_123	93	123	4.3490106818079935e-06
C93_123	93	123	2.0359085007625442e-11
R93_122	93	122	4.5800876596161104e-06
C93_122	93	122	1.9331917803822413e-11
R93_183	93	183	3.7801087450334839e-06
C93_183	93	183	2.3423103445458075e-11
R93_185	93	185	5.4009030147290662e-06
C93_185	93	185	1.6393902636009778e-11
R93_119	93	119	6.8723774732271992e-06
C93_119	93	119	1.2883733251692537e-11
R93_186	93	186	1.7828033371710520e-06
C93_186	93	186	4.9664411280774264e-11
R94_97	94	97	2.4138365377715809e-06
C94_97	94	97	4.0349072675616466e-10
R94_102	94	102	7.7192677828495751e-06
C94_102	94	102	1.2617267418290041e-10
R94_143	94	143	9.2366871363539293e-06
C94_143	94	143	1.5337425937263131e-10
R94_150	94	150	4.9102693675488907e-06
C94_150	94	150	1.3824517856467553e-10
R94_181	94	181	3.3959715072638527e-06
C94_181	94	181	2.8679883114825169e-10
R94_183	94	183	5.5677684449489799e-06
C94_183	94	183	1.2191977310645380e-10
R94_187	94	187	2.3686559153379135e+03
C94_187	94	187	3.7380641737222757e-10
R94_188	94	188	2.6848845035730201e+03
C94_188	94	188	3.2977909497473462e-10
R94_189	94	189	1.3552066624546833e+03
C94_189	94	189	6.5334594806097147e-10
R95_96	95	96	6.2952959063036660e+03
C95_96	95	96	1.4064768279016146e-10
R95_101	95	101	3.7589683643258527e+03
C95_101	95	101	2.3554834621727242e-10
R95_105	95	105	1.5987527359291728e+03
C95_105	95	105	5.5381846223106351e-10
R95_111	95	111	4.1842575604112008e+03
C95_111	95	111	2.1160714150994736e-10
R95_131	95	131	2.0272093885402355e+03
C95_131	95	131	4.3676730519563020e-10
R95_134	95	134	3.1386178986470118e+03
C95_134	95	134	2.8210467482572005e-10
R95_135	95	135	4.2427116466440784e+03
C95_135	95	135	2.0869171780749067e-10
R95_191	95	191	4.8185047061887444e+03
C95_191	95	191	1.8375384806884064e-10
R96_99	96	99	4.0423170530219691e+03
C96_99	96	99	2.1903744067726588e-10
R96_101	96	101	6.0395548010006887e+03
C96_101	96	101	1.4660331942899099e-10
R96_131	96	131	8.4944475146295499e+03
C96_131	96	131	1.0423500529906020e-10
R96_133	96	133	6.4619686459333816e+03
C96_133	96	133	1.3701997490458392e-10
R96_132	96	132	2.5110735713336817e+03
C96_132	96	132	3.5260567105954457e-10
R96_134	96	134	8.0615374661780979e+03
C96_134	96	134	1.0983249602383466e-10
R96_136	96	136	7.3580646136423175e+03
C96_136	96	136	1.2033310771128289e-10
R96_138	96	138	5.9592110836183647e+03
C96_138	96	138	1.4857986556877992e-10
R96_192	96	192	1.0898561972184241e+04
C96_192	96	192	8.1241799052003598e-11
R96_195	96	195	7.2067497582170727e+03
C96_195	96	195	1.2285965399179475e-10
R97_102	97	102	2.7853152753332281e-06
C97_102	97	102	3.4967698900064982e-10
R97_98	97	98	6.0058646177369850e-06
C97_98	97	98	2.3588111600304399e-10
R97_143	97	143	3.9018708852897878e-06
C97_143	97	143	2.4961375902209134e-10
R97_146	97	146	4.8056475745992884e+03
C97_146	97	146	1.8424546701675879e-10
R97_187	97	187	5.1160766245321784e+03
C97_187	97	187	1.7306597353415599e-10
R97_188	97	188	2.1016353414169612e+03
C97_188	97	188	4.2129991071763884e-10
R97_196	97	196	3.7324425668943263e+03
C97_196	97	196	2.3722234591187164e-10
R98_100	98	100	1.2646958990576295e-05
C98_100	98	100	1.1201665551778947e-10
R98_102	98	102	6.4770004156544121e-06
C98_102	98	102	1.0480485131308535e-10
R98_103	98	103	8.6502528328405489e-06
C98_103	98	103	1.1259331694888884e-10
R98_108	98	108	3.0256471841846301e+03
C98_108	98	108	2.9263781525095711e-10
R98_143	98	143	1.1443818814909417e-05
C98_143	98	143	8.5108011114884892e-11
R98_146	98	146	2.5672542876128605e+03
C98_146	98	146	3.4488939641553756e-10
R98_196	98	196	3.7443007323638890e+03
C98_196	98	196	2.3647106495663583e-10
R98_197	98	197	7.9848177235636113e+03
C98_197	98	197	1.1088778884545898e-10
R99_100	99	100	2.3279782726684521e+03
C99_100	99	100	3.8033807793450150e-10
R99_101	99	101	4.0312036016542534e+03
C99_101	99	101	2.1964129555169520e-10
R99_108	99	108	2.1714620545957437e+03
C99_108	99	108	4.0775236197476936e-10
R99_138	99	138	3.3267935252387456e+03
C99_138	99	138	2.6614780117334105e-10
R99_165	99	165	6.1261979645796500e+03
C99_165	99	165	1.4452990040793646e-10
R99_192	99	192	2.2107390769110930e+03
C99_192	99	192	4.0050804319120826e-10
R99_195	99	195	4.3927912584890664e+03
C99_195	99	195	2.0156177009069772e-10
R99_197	99	197	3.6701102917574335e+03
C99_197	99	197	2.4125127348039912e-10
R100_101	100	101	5.2811149275946691e+03
C100_101	100	101	1.6765754842288042e-10
R100_103	100	103	6.4549667019200991e-06
C100_103	100	103	1.5088546600965799e-10
R100_108	100	108	9.9772021467582872e+03
C100_108	100	108	8.8744195885384899e-11
R100_197	100	197	7.2920990959200471e+03
C100_197	100	197	1.2142166062929599e-10
R101_103	101	103	3.5598491472558649e+03
C101_103	101	103	2.4872368043531600e-10
R101_104	101	104	4.9090650809931494e+03
C101_104	101	104	1.8036403410664734e-10
R101_105	101	105	2.2588494831627208e+03
C101_105	101	105	3.9197776934666925e-10
R101_131	101	131	3.6813069517596509e+03
C101_131	101	131	2.4051751003180358e-10
R101_194	101	194	1.9582337209375110e+03
C101_194	101	194	4.5215173869853639e-10
R101_195	101	195	2.6251041478791367e+03
C101_195	101	195	3.3728901095803905e-10
R101_197	101	197	2.8496693824293270e+03
C101_197	101	197	3.1070930093131907e-10
R101_198	101	198	6.9936104647175043e+03
C101_198	101	198	1.2660396031018652e-10
R102_103	102	103	4.3608084694547787e-06
C102_103	102	103	3.2486408392343772e-10
R102_183	102	183	3.7232591416153431e-06
C102_183	102	183	1.4268447307803832e-10
R102_184	102	184	3.7094340986691707e-06
C102_184	102	184	2.6256313847049238e-10
R102_187	102	187	1.4495294901092857e+03
C102_187	102	187	6.1083185112242507e-10
R102_196	102	196	1.9939561105301909e+03
C102_196	102	196	4.4405128930574503e-10
R102_198	102	198	2.5391720678484376e+03
C102_198	102	198	3.4870373414679922e-10
R103_104	103	104	1.2257753004776393e-05
C103_104	103	104	1.1557338837248322e-10
R103_184	103	184	7.3519874143030408e-06
C103_184	103	184	9.2331641400368732e-11
R103_196	103	196	7.9022573490054456e+03
C103_196	103	196	1.1204631064203905e-10
R103_197	103	197	4.7237765833598542e+03
C103_197	103	197	1.8743875076967193e-10
R103_198	103	198	2.8647927947231578e+03
C103_198	103	198	3.0906904797125606e-10
R104_105	104	105	1.0890353595403865e+03
C104_105	104	105	8.1303033362817532e-10
R104_110	104	110	4.9723406949224877e-06
C104_110	104	110	1.9587568886633223e-10
R104_109	104	109	2.0356375434052445e+03
C104_109	104	109	4.3495895650404365e-10
R104_182	104	182	7.7611945060946454e-06
C104_182	104	182	1.2549107719581254e-10
R104_184	104	184	3.6175360874434283e-06
C104_184	104	184	3.5081896113848037e-10
R104_194	104	194	4.5832398443824759e+03
C104_194	104	194	1.9318622017680970e-10
R104_198	104	198	3.8591739028983825e+03
C104_198	104	198	2.2943220595346008e-10
R104_199	104	199	3.6659706638699522e+03
C104_199	104	199	2.4152369532747840e-10
R105_110	105	110	8.3272874711912518e+03
C105_110	105	110	1.0632739469643137e-10
R105_109	105	109	4.3441752153796006e+03
C105_109	105	109	2.0381746541101033e-10
R105_111	105	111	3.1502522245864493e+03
C105_111	105	111	2.8106282245899652e-10
R105_131	105	131	6.2649559544231843e+03
C105_131	105	131	1.4132881190886533e-10
R105_191	105	191	3.6776416667177928e+03
C105_191	105	191	2.4075721941942620e-10
R105_194	105	194	2.6276631337635067e+03
C105_194	105	194	3.3696053741555790e-10
R105_199	105	199	7.6548923430099931e+03
C105_199	105	199	1.1566704559973512e-10
R106_107	106	107	2.4838364777692864e+03
C106_107	106	107	3.5647225154499203e-10
R106_143	106	143	5.4878313363513234e+03
C106_143	106	143	1.6134220012102003e-10
R106_144	106	144	2.0461426232695214e+03
C106_144	106	144	4.3272583818482483e-10
R106_145	106	145	1.0289268412327729e+03
C106_145	106	145	8.6052646915029083e-10
R106_158	106	158	1.2721384326470720e+03
C106_158	106	158	6.9600820081947853e-10
R106_168	106	168	1.3995031576765559e+03
C106_168	106	168	6.3266651228566362e-10
R106_201	106	201	3.6775892647955338e+03
C106_201	106	201	2.4076064996595739e-10
R107_126	107	126	2.5461868985056003e+03
C107_126	107	126	3.4774304361540274e-10
R107_145	107	145	2.4074190839295734e+03
C107_145	107	145	3.6778755623003194e-10
R107_163	107	163	1.4508681266817257e+03
C107_163	107	163	6.1026827002191951e-10
R107_167	107	167	3.2087064682285763e+03
C107_167	107	167	2.7594259258897284e-10
R107_168	107	168	4.6147702399040636e+03
C107_168	107	168	1.9186627625439637e-10
R107_171	107	171	2.6854579906233489e+03
C107_171	107	171	3.2970866972842736e-10
R107_175	107	175	3.3397500768895152e+03
C107_175	107	175	2.6511528147777965e-10
R107_201	107	201	9.8536852924569291e+02
C107_201	107	201	8.9856612568882704e-10
R107_202	107	202	4.0616746132716858e+03
C107_202	107	202	2.1799352877920314e-10
R108_146	108	146	3.0790905810763275e+03
C108_146	108	146	2.8755853664769185e-10
R108_163	108	163	2.1239212026710079e+03
C108_163	108	163	4.1687929881132698e-10
R108_164	108	164	3.1161472304035865e+03
C108_164	108	164	2.8413894345593082e-10
R108_165	108	165	4.9856013064191438e+03
C108_165	108	165	1.7759518406736437e-10
R108_166	108	166	5.2556397018940697e+03
C108_166	108	166	1.6847022092874933e-10
R108_192	108	192	3.6360321346707010e+03
C108_192	108	192	2.4351236427677728e-10
R108_196	108	196	5.8329929070668259e+03
C108_196	108	196	1.5179493543139608e-10
R108_197	108	197	2.5447469505110594e+03
C108_197	108	197	3.4793981441737538e-10
R108_203	108	203	1.7911182726148243e+03
C108_203	108	203	4.9433853433218107e-10
R109_110	109	110	1.1011873117849711e+03
C109_110	109	110	8.0405828529278908e-10
R109_111	109	111	2.4233451181578930e+03
C109_111	109	111	3.6537048522954571e-10
R109_182	109	182	1.3142598284460730e+03
C109_182	109	182	6.7370147252152030e-10
R109_112	109	112	5.1089463334995535e+03
C109_112	109	112	1.7330751272415525e-10
R109_184	109	184	7.6727224739819058e+03
C109_184	109	184	1.1539825462245542e-10
R109_191	109	191	3.7061374090269260e+03
C109_191	109	191	2.3890608576557700e-10
R109_199	109	199	9.4387483867282356e+02
C109_199	109	199	9.3806799950826267e-10
R109_205	109	205	4.3908845622421877e+03
C109_205	109	205	2.0164929620647201e-10
R109_206	109	206	1.5145440868655044e+03
C109_206	109	206	5.8461076793905668e-10
R110_111	110	111	3.1717081355032988e+03
C110_111	110	111	2.7916149401921519e-10
R110_112	110	112	8.9948182248466051e-06
C110_112	110	112	2.0671673305359660e-10
R110_182	110	182	2.6030253663545216e-06
C110_182	110	182	2.6078157911619837e-10
R110_206	110	206	4.8937543929862095e+03
C110_206	110	206	1.8092832426755897e-10
R111_191	111	191	9.6359617612290265e+02
C111_191	111	191	9.1886913173788765e-10
R111_135	111	135	6.3622616191863699e+03
C111_135	111	135	1.3916730161329498e-10
R111_206	111	206	3.6045906666264650e+03
C111_206	111	206	2.4563642965004486e-10
R111_207	111	207	7.1469639239062753e+03
C111_207	111	207	1.2388740045802016e-10
R112_115	112	115	4.6360598341791273e-06
C112_115	112	115	3.0557630817244059e-10
R112_116	112	116	1.1288487402821456e-05
C112_116	112	116	8.6279111110369542e-11
R112_182	112	182	5.0459272310392443e-06
C112_182	112	182	2.8075514840574138e-10
R112_205	112	205	3.0645061275535427e+03
C112_205	112	205	2.8892707171933371e-10
R112_206	112	206	4.4974912192743050e+03
C112_206	112	206	1.9686948534896025e-10
R112_208	112	208	3.3669049966254402e+03
C112_208	112	208	2.6297706130331331e-10
R113_114	113	114	1.3656182228573408e-06
C113_114	113	114	6.4836479689572431e-11
R113_115	113	115	1.5911769898407151e-06
C113_115	113	115	5.5645524498731901e-11
R113_116	113	116	2.0228603922489930e-06
C113_116	113	116	4.3770632174749411e-11
R113_117	113	117	2.9111735770774327e-06
C113_117	113	117	3.0414496362284389e-11
R113_118	113	118	3.1996857772926879e-07
C113_118	113	118	2.7672054174306107e-10
R113_119	113	119	1.8996849355835751e-06
C113_119	113	119	4.6608717325433911e-11
R113_120	113	120	3.2887240587402879e-06
C113_120	113	120	2.6922866311841032e-11
R113_210	113	210	2.2383096788088216e-06
C113_210	113	210	3.9557474556925474e-11
R113_211	113	211	1.6387678821696112e-06
C113_211	113	211	5.4029542031771394e-11
R114_117	114	117	1.2825150469252502e-05
C114_117	114	117	6.9037691512683325e-12
R114_119	114	119	6.0135794638933784e-06
C114_119	114	119	1.4723656468102151e-11
R114_120	114	120	3.2814135173695802e-06
C114_120	114	120	2.6982846782741428e-11
R114_121	114	121	9.2225801127209024e-06
C114_121	114	121	9.6005539759825244e-12
R114_211	114	211	2.4017135710210683e-06
C114_211	114	211	3.6866127267772896e-11
R115_116	115	116	2.5377338136120546e-06
C115_116	115	116	2.9656615671969658e-10
R115_118	115	118	3.7185387839635451e-06
C115_118	115	118	3.8097492883615535e-10
R115_119	115	119	4.8650536142005883e-06
C115_119	115	119	1.8199568841657868e-11
R115_182	115	182	3.8690119683088112e-06
C115_182	115	182	2.5173368986030007e-10
R115_185	115	185	4.2513316560487916e-06
C115_185	115	185	1.5967257331044185e-10
R115_190	115	190	1.1368909649938580e+03
C115_190	115	190	7.7880712307779101e-10
R115_205	115	205	2.1907275456559601e+03
C115_205	115	205	4.0416654433168364e-10
R115_208	115	208	3.5719030803054716e+03
C115_208	115	208	2.4788432434854265e-10
R115_210	115	210	4.4732327617914375e-06
C115_210	115	210	1.5175178705558770e-10
R115_212	115	212	2.8302917218290459e+03
C115_212	115	212	3.1283657966105612e-10
R116_117	116	117	7.7606184489983866e-06
C116_117	116	117	6.8454759404250798e-11
R116_118	116	118	4.2758815678886601e-06
C116_118	116	118	3.3131648435588382e-10
R116_208	116	208	4.3803414827812030e+03
C116_208	116	208	2.0213464753387731e-10
R116_209	116	209	2.8359938043356051e+03
C116_209	116	209	3.1220758675367744e-10
R116_212	116	212	4.6793978546515536e+03
C116_212	116	212	1.8921639262193744e-10
R117_118	117	118	1.8668348329298919e-05
C117_118	117	118	7.5886201800274502e-11
R117_209	117	209	1.1622968007609399e+04
C117_209	117	209	7.6178372092251169e-11
R117_211	117	211	2.3189457525034156e-05
C117_211	117	211	2.2909171901967208e-11
R117_213	117	213	1.2994149996124199e+04
C117_213	117	213	6.8139799984154125e-11
R117_214	117	214	4.0762718326105452e+04
C117_214	117	214	2.1721288914457797e-11
R118_209	118	209	6.3667383227687606e+03
C118_209	118	209	1.3906944762180050e-10
R118_210	118	210	1.3860419668305293e-05
C118_210	118	210	1.0220975139984421e-10
R118_190	118	190	9.5484899909039359e+03
C118_190	118	190	9.2728670454015858e-11
R118_211	118	211	9.7458130282923384e-06
C118_211	118	211	1.4536191536635951e-10
R118_212	118	212	4.8878550548373796e+03
C118_212	118	212	1.8114669354274834e-10
R118_213	118	213	6.0022568080446517e+03
C118_213	118	213	1.4751431170244144e-10
R118_217	118	217	6.6531758660742244e+03
C118_217	118	217	1.3308212491644995e-10
R119_120	119	120	7.2356675794592346e-07
C119_120	119	120	1.2236863730632757e-10
R119_121	119	121	7.4210554933560700e-06
C119_121	119	121	1.1931170471541395e-11
R119_123	119	123	3.8729761647074414e-06
C119_123	119	123	2.2861457030600733e-11
R119_185	119	185	3.5290797674254987e-06
C119_185	119	185	2.5089225521981403e-11
R119_186	119	186	3.9212553374459833e-06
C119_186	119	186	2.2579982824497643e-11
R119_210	119	210	9.9835319665062876e-07
C119_210	119	210	8.8687929749760714e-11
R119_220	119	220	5.2595915237450310e-06
C119_220	119	220	1.6834363993908558e-11
R120_121	120	121	9.1080776800223028e-07
C120_121	120	121	9.7212475870960278e-11
R120_123	120	123	4.4598825175318125e-06
C120_123	120	123	1.9852962005600286e-11
R120_210	120	210	7.5107667747351121e-07
C120_210	120	210	1.1788660309336080e-10
R120_211	120	211	1.8549137638281171e-06
C120_211	120	211	4.7733689779340379e-11
R120_220	120	220	2.5708984560712754e-06
C120_220	120	220	3.4440052644204969e-11
R120_222	120	222	1.3665861547021424e-06
C120_222	120	222	6.4790557013434959e-11
R121_123	121	123	8.1856766492475265e-06
C121_123	121	123	1.0816684064614168e-11
R121_211	121	211	1.6762865081936535e-05
C121_211	121	211	5.2820253421601360e-12
R121_220	121	220	8.2083633736362226e-06
C121_220	121	220	1.0786788320602435e-11
R121_124	121	124	1.2054195115100431e-05
C121_124	121	124	7.3453164914414369e-12
R121_222	121	222	3.1391133112240701e-06
C121_222	121	222	2.8206015327135120e-11
R122_123	122	123	5.3442695421756091e-06
C122_123	122	123	1.6567629583659679e-11
R122_147	122	147	1.1401139603190459e-05
C122_147	122	147	7.7660550832324449e-12
R122_149	122	149	6.9124936520588888e-06
C122_149	122	149	1.4089859722416451e-10
R122_181	122	181	7.6303386943128198e-06
C122_181	122	181	1.8566280021762240e-10
R122_183	122	183	7.3316479898208001e-06
C122_183	122	183	9.2587787419680019e-11
R122_186	122	186	4.2059903163045559e-06
C122_186	122	186	1.6139387265966763e-10
R122_218	122	218	4.8717081382537726e+03
C122_218	122	218	1.8174709087095923e-10
R122_219	122	219	1.8606854677703243e+03
C122_219	122	219	4.7585623526205385e-10
R122_220	122	220	1.0611323611537331e-05
C122_220	122	220	1.3350549850865896e-10
R122_223	122	223	3.6220989547248751e+03
C122_223	122	223	2.4444908677743575e-10
R122_224	122	224	1.1446875017597140e-05
C122_224	122	224	5.9301867494308209e-11
R123_147	123	147	5.0953686019702977e-06
C123_147	123	147	1.7376932875035236e-11
R123_186	123	186	3.6093556833770554e-06
C123_186	123	186	2.4531214415298836e-11
R123_220	123	220	8.5839569047657191e-07
C123_220	123	220	1.0314809260149304e-10
R123_124	123	124	5.1128417075869457e-06
C123_124	123	124	1.7317547312018812e-11
R123_224	123	224	5.2060209465668660e-06
C123_224	123	224	1.7007591609555345e-11
R124_220	124	220	4.1145162770287083e-06
C124_220	124	220	2.1519389451520266e-11
R124_222	124	222	1.0438286420386482e-05
C124_222	124	222	8.4824150827163948e-12
R124_147	124	147	7.5006607664736619e-06
C124_147	124	147	1.1804543749767105e-11
R124_224	124	224	3.9742328667137053e-06
C124_224	124	224	2.2278985942566410e-11
R124_178	124	178	7.5061834933116289e-06
C124_178	124	178	1.1795858474402483e-11
R124_227	124	227	1.9547352847165697e-06
C124_227	124	227	4.5296096541705535e-11
R125_129	125	129	8.3525084141114110e+02
C125_129	125	129	1.0600633220603541e-09
R125_130	125	130	1.1467945053155879e+03
C125_130	125	130	7.7208146498429597e-10
R125_138	125	138	1.0634310250484486e+03
C125_138	125	138	8.3260574578371119e-10
R125_139	125	139	3.9604459190937941e+03
C125_139	125	139	2.2356542666856978e-10
R125_140	125	140	1.5055505224690621e+03
C125_140	125	140	5.8810300184940813e-10
R125_165	125	165	1.5521894481113388e+03
C125_165	125	165	5.7043216134303264e-10
R125_230	125	230	8.7936835252162871e+02
C125_230	125	230	1.0068804263435472e-09
R126_127	126	127	1.7677668941168183e+03
C126_127	126	127	5.0086851645808093e-10
R126_128	126	128	8.1129903629031776e+02
C126_128	126	128	1.0913593411235844e-09
R126_163	126	163	3.7095207153959332e+03
C126_163	126	163	2.3868818902268759e-10
R126_164	126	164	1.8671166814804640e+03
C126_164	126	164	4.7421716622334422e-10
R126_167	126	167	1.0144896289962843e+03
C126_167	126	167	8.7277263009185769e-10
R126_170	126	170	3.8502965237095050e+03
C126_170	126	170	2.2996119292312526e-10
R126_171	126	171	1.6312143887919219e+03
C126_171	126	171	5.4279730965084338e-10
R126_232	126	232	1.5358498960177301e+03
C126_232	126	232	5.7650085727503848e-10
R127_128	127	128	2.7195677425419699e+03
C127_128	127	128	3.2557335044443585e-10
R127_129	127	129	2.6899218128190982e+03
C127_129	127	129	3.2916153082236298e-10
R127_130	127	130	6.6471313142476911e+03
C127_130	127	130	1.3320314280570370e-10
R127_170	127	170	2.8921624284197719e+03
C127_170	127	170	3.0614420995150600e-10
R127_232	127	232	4.6551795208325484e+03
C127_232	127	232	1.9020078124541345e-10
R127_233	127	233	5.1345037038287128e+03
C127_233	127	233	1.7244486181590605e-10
R128_129	128	129	1.2300084779536485e+03
C128_129	128	129	7.1984770639391148e-10
R128_164	128	164	2.1426786182619953e+03
C128_164	128	164	4.1322985825013522e-10
R128_165	128	165	5.7446457642863506e+03
C128_165	128	165	1.5412939596807223e-10
R128_167	128	167	6.8337798324401929e+03
C128_167	128	167	1.2956501429807353e-10
R128_230	128	230	4.7199467120894960e+03
C128_230	128	230	1.8759084280170392e-10
R128_231	128	231	1.5335008862004915e+03
C128_231	128	231	5.7738393871670662e-10
R128_232	128	232	2.5789648915715693e+03
C128_232	128	232	3.4332331727107906e-10
R128_233	128	233	6.7505121305314642e+03
C128_233	128	233	1.3116320133629498e-10
R129_130	129	130	1.1777413672230373e+03
C129_130	129	130	7.5179390513190829e-10
R129_164	129	164	2.4646586590711890e+03
C129_164	129	164	3.5924600692319458e-10
R129_165	129	165	2.2177855100191487e+03
C129_165	129	165	3.9923553368889818e-10
R129_230	129	230	1.8994884029059367e+03
C129_230	129	230	4.6613539748146922e-10
R129_233	129	233	5.3193744267480897e+03
C129_233	129	233	1.6645167470214839e-10
R130_140	130	140	3.7887009796502753e+03
C130_140	130	140	2.3369983180402136e-10
R130_230	130	230	3.4280721064164941e+03
C130_230	130	230	2.5828476012587876e-10
R130_233	130	233	5.1786847500353279e+03
C130_233	130	233	1.7097367853757847e-10
R131_132	131	132	1.5849547534077779e+04
C131_132	131	132	5.5863978438266445e-11
R131_134	131	134	9.5622206229585809e+03
C131_134	131	134	9.2595519033951008e-11
R131_135	131	135	1.0161931228370915e+04
C131_135	131	135	8.7130955898226822e-11
R131_191	131	191	9.8541484345551689e+03
C131_191	131	191	8.9852389334337183e-11
R131_194	131	194	5.7186518584343767e+03
C131_194	131	194	1.5482998504168528e-10
R131_195	131	195	7.1935763282939852e+03
C131_195	131	195	1.2308464403407314e-10
R131_200	131	200	1.6622356845459090e+04
C131_200	131	200	5.3266741288969472e-11
R131_204	131	204	1.3230616263460115e+04
C131_204	131	204	6.6921960706042164e-11
R131_234	131	234	8.3949554683055194e+03
C131_234	131	234	1.0547033692350457e-10
R131_237	131	237	1.3533410928511197e+04
C131_237	131	237	6.5424658009509261e-11
R132_133	132	133	3.1226853161158692e+03
C132_133	132	133	2.8354403087959000e-10
R132_134	132	134	5.6201443557900020e+03
C132_134	132	134	1.5754377924257787e-10
R132_136	132	136	3.5425323450229357e+03
C132_136	132	136	2.4993950526491740e-10
R132_138	132	138	2.5333383007519760e+03
C132_138	132	138	3.4950672850806373e-10
R132_139	132	139	3.7848049820524598e+03
C132_139	132	139	2.3394039743095222e-10
R132_192	132	192	2.8532730484660365e+03
C132_192	132	192	3.1031687702514665e-10
R132_195	132	195	3.6566605386653569e+03
C132_195	132	195	2.4213863232247666e-10
R132_234	132	234	3.8915581014145805e+03
C132_234	132	234	2.2752295060894782e-10
R132_235	132	235	2.4265552261259213e+03
C132_235	132	235	3.6488713389540356e-10
R132_237	132	237	1.7845092961786595e+03
C132_237	132	237	4.9616932990824547e-10
R132_238	132	238	2.3824133700649927e+03
C132_238	132	238	3.7164783946618214e-10
R133_136	133	136	2.6607240766422115e+03
C133_136	133	136	3.3277361958455441e-10
R133_137	133	137	1.6428330248084249e+03
C133_137	133	137	5.3895847498150403e-10
R133_139	133	139	1.5636694972552893e+03
C133_139	133	139	5.6624419882473671e-10
R133_141	133	141	2.4380588957619952e+03
C133_141	133	141	3.6316546053874944e-10
R133_238	133	238	2.8009268909709576e+03
C133_238	133	238	3.1611634868236939e-10
R133_239	133	239	4.4451213380082127e+03
C133_239	133	239	1.9918888920515771e-10
R134_135	134	135	3.0192000834704991e+03
C134_135	134	135	2.9326270443204025e-10
R134_136	134	136	2.9617537051207455e+03
C134_136	134	136	2.9895084799561445e-10
R134_237	134	237	3.5392150149699924e+03
C134_237	134	237	2.5017377524532997e-10
R134_240	134	240	5.6845946423099631e+03
C134_240	134	240	1.5575759353356560e-10
R135_191	135	191	2.0797743014399234e+03
C135_191	135	191	4.2572830190611738e-10
R135_204	135	204	1.6530100858425467e+03
C135_204	135	204	5.3564027786841846e-10
R135_207	135	207	4.1840701590327544e+03
C135_207	135	207	2.1161661923582209e-10
R135_237	135	237	6.1799198364814583e+03
C135_237	135	237	1.4327350598840676e-10
R135_240	135	240	4.8273792021171867e+03
C135_240	135	240	1.8341604100868520e-10
R135_241	135	241	6.9831204441344207e+03
C135_241	135	241	1.2679414436331553e-10
R136_137	136	137	4.8915185482237221e+03
C136_137	136	137	1.8101102407585184e-10
R136_237	136	237	4.9209571099831674e+03
C136_237	136	237	1.7992816476773331e-10
R136_238	136	238	4.0343833571832342e+03
C136_238	136	238	2.1946818220026336e-10
R136_240	136	240	9.8113721359267747e+03
C136_240	136	240	9.0244133994043458e-11
R136_242	136	242	6.7695847372886374e+03
C136_242	136	242	1.3079366254519019e-10
R137_141	137	141	7.9885990213659315e+03
C137_141	137	141	1.1083530157564557e-10
R137_142	137	142	6.6419112469827496e+03
C137_142	137	142	1.3330783095034931e-10
R137_238	137	238	6.6824948925284434e+03
C137_238	137	238	1.3249823545543870e-10
R137_239	137	239	3.9092497197090020e+03
C137_239	137	239	2.2649327752996780e-10
R137_242	137	242	7.8040549627952760e+03
C137_242	137	242	1.1345624626186109e-10
R137_243	137	243	1.1865498311847361e+04
C137_243	137	243	7.4621289256426324e-11
R138_139	138	139	2.3941471092626134e+03
C138_139	138	139	3.6982638964600010e-10
R138_165	138	165	9.7868226428253649e+02
C138_165	138	165	9.0470504474615463e-10
R138_192	138	192	2.3703684312384680e+03
C138_192	138	192	3.7353635410904762e-10
R138_230	138	230	4.0841867868124154e+03
C138_230	138	230	2.1679194119107431e-10
R138_235	138	235	3.7657585092081067e+03
C138_235	138	235	2.3512362238177425e-10
R138_244	138	244	6.2750131762959581e+03
C138_244	138	244	1.4110229840547502e-10
R139_140	139	140	2.8115372507373008e+03
C139_140	139	140	3.1492336851229933e-10
R139_141	139	141	2.3849509601441709e+03
C139_141	139	141	3.7125240581318957e-10
R139_230	139	230	3.0603230383117575e+03
C139_230	139	230	2.8932199987242058e-10
R139_235	139	235	5.3968476419628432e+03
C139_235	139	235	1.6406221565631815e-10
R139_238	139	238	2.8115372507372958e+03
C139_238	139	238	3.1492336851229996e-10
R139_239	139	239	2.4191900190317051e+03
C139_239	139	239	3.6599803022269159e-10
R139_244	139	244	1.5749857803595341e+03
C139_244	139	244	5.6217573056302671e-10
R139_245	139	245	4.1509801487832183e+03
C139_245	139	245	2.1330354517824998e-10
R140_141	140	141	1.4110193167568104e+04
C140_141	140	141	6.2750294853164105e-11
R140_230	140	230	5.3058661742620034e+03
C140_230	140	230	1.6687544552009997e-10
R140_233	140	233	2.2136032775193100e+04
C140_233	140	233	3.9998982233720352e-11
R140_245	140	245	1.3957391299868004e+04
C140_245	140	245	6.3437268661255745e-11
R141_142	141	142	9.7182210304252985e+03
C141_142	141	142	9.1109142190528199e-11
R141_239	141	239	4.1631451027491748e+03
C141_239	141	239	2.1268025971886132e-10
R141_245	141	245	1.0310927151538241e+04
C141_245	141	245	8.5871888016191480e-11
R141_246	141	246	1.4365712205961618e+04
C141_246	141	246	6.1634172326838113e-11
R142_239	142	239	7.3810267439642412e+03
C142_239	142	239	1.1995875538915260e-10
R142_243	142	243	7.8539249807014894e+03
C142_243	142	243	1.1273583385067131e-10
R142_236	142	236	2.3486625285603677e+04
C142_236	142	236	3.7698850768599984e-11
R142_246	142	246	8.1331322214195816e+03
C142_246	142	246	1.0886565687056498e-10
R143_144	143	144	1.1717047588826586e-05
C143_144	143	144	1.3350119415360207e-10
R143_145	143	145	7.6640709821502714e+03
C143_145	143	145	1.1552852051633559e-10
R143_146	143	146	5.3856594802608615e+03
C143_146	143	146	1.6440303828067373e-10
R143_150	143	150	1.2127503607216289e-05
C143_150	143	150	8.0310069610410049e-11
R143_151	143	151	1.2613710919211765e-05
C143_151	143	151	7.0194947971372260e-12
R143_158	143	158	1.3841143568191505e+04
C143_158	143	158	6.3970059795838792e-11
R143_159	143	159	1.2363064166783278e-05
C143_159	143	159	5.4907186144134824e-11
R143_160	143	160	3.8192318954681687e+03
C143_160	143	160	2.3183163681436094e-10
R143_188	143	188	5.2258065520211794e+03
C143_188	143	188	1.6943198583528650e-10
R143_189	143	189	9.4028785535117768e+03
C143_189	143	189	9.4164651458708321e-11
R143_247	143	247	7.3304694238799420e+03
C143_247	143	247	1.2078609574656088e-10
R144_153	144	153	4.7406681307198285e-06
C144_153	144	153	1.8677088488064171e-11
R144_158	144	158	2.5398116607853131e+03
C144_158	144	158	3.4861592116095234e-10
R144_159	144	159	4.5557685490967632e-06
C144_159	144	159	2.1378624668918684e-10
R144_160	144	160	5.8753892118566728e+03
C144_160	144	160	1.5069959619240276e-10
R144_161	144	161	2.4729794026795539e+03
C144_161	144	161	3.5803726498515103e-10
R144_162	144	162	5.2396816314015020e-06
C144_162	144	162	1.8588164843052228e-10
R144_168	144	168	3.8960745677165846e+03
C144_168	144	168	2.2725919802375018e-10
R144_169	144	169	5.0469421379326532e+03
C144_169	144	169	1.7543668175730043e-10
R144_247	144	247	5.9371793793246843e+03
C144_247	144	247	1.4913121621073720e-10
R145_146	145	146	1.2824481809291167e+03
C145_146	145	146	6.9041291092052240e-10
R145_158	145	158	2.0509824151692219e+03
C145_158	145	158	4.3170471631125434e-10
R145_163	145	163	1.5034423240820067e+03
C145_163	145	163	5.8892766787088551e-10
R145_201	145	201	3.2604312172632713e+03
C145_201	145	201	2.7156493196725054e-10
R145_202	145	202	1.5759844618686791e+03
C145_202	145	202	5.6181948688132357e-10
R145_247	145	247	3.9577938354784433e+03
C145_247	145	247	2.2371523593849984e-10
R146_163	146	163	2.5666835165424977e+03
C146_163	146	163	3.4496609184318961e-10
R146_188	146	188	1.8808090103188733e+03
C146_188	146	188	4.7076485535864468e-10
R146_196	146	196	1.5195913989535929e+03
C146_196	146	196	5.8266898740655475e-10
R146_202	146	202	2.5450731904270501e+03
C146_202	146	202	3.4789521379203692e-10
R146_203	146	203	2.4648775624871382e+03
C146_203	146	203	3.5921410262933508e-10
R146_247	146	247	3.7770050770802704e+03
C146_247	146	247	2.3442350847578244e-10
R146_248	146	248	2.2852242703725692e+03
C146_248	146	248	3.8745377999842730e-10
R147_149	147	149	3.6978464827936057e-06
C147_149	147	149	2.3944173610773978e-11
R147_152	147	152	8.8210873419397422e-06
C147_152	147	152	1.0037524257245344e-11
R147_156	147	156	5.3386792759312218e-06
C147_156	147	156	1.6584977968086629e-11
R147_224	147	224	9.0513639215768747e-07
C147_224	147	224	9.7821586820668648e-11
R147_178	147	178	5.3056343925389687e-06
C147_178	147	178	1.6688273563386076e-11
R147_179	147	179	4.2887414171128484e-06
C147_179	147	179	2.0645189242863190e-11
R147_228	147	228	4.7713124346074907e-06
C147_228	147	228	1.8557132735174541e-11
R147_253	147	253	4.0759127065382500e-06
C147_253	147	253	2.1723202763388011e-11
R148_156	148	156	6.5420579978078318e-06
C148_156	148	156	1.3534254541868840e-11
R148_254	148	254	2.3195886143155458e-06
C148_254	148	254	3.8171371261074479e-11
R148_157	148	157	1.4201562944789012e-05
C148_157	148	157	6.2346573059755181e-12
R148_179	148	179	3.9009137852207280e-06
C148_179	148	179	2.2697727518474235e-11
R148_180	148	180	1.4201562944789068e-05
C148_180	148	180	6.2346573059754930e-12
R149_152	149	152	1.1322664772034224e-06
C149_152	149	152	7.8198798562586631e-11
R149_156	149	156	4.8324608757071806e-06
C149_156	149	156	1.8322316609970031e-11
R149_181	149	181	3.0856476858419061e-06
C149_181	149	181	2.1999305644391458e-10
R149_150	149	150	5.8463691044018733e-06
C149_150	149	150	2.4231621768942881e-10
R149_218	149	218	1.4192504616727440e+03
C149_218	149	218	6.2386365593035340e-10
R149_223	149	223	2.6875818348171474e+03
C149_223	149	223	3.2944811958079054e-10
R149_224	149	224	9.0045616164543314e-06
C149_224	149	224	1.5732804204551919e-10
R149_225	149	225	4.7441864859957841e+03
C149_225	149	225	1.8663237297134925e-10
R149_251	149	251	1.5195881679798915e+03
C149_251	149	251	5.8267022628707161e-10
R149_252	149	252	2.9809883259551730e+03
C149_252	149	252	2.9702188834177772e-10
R149_253	149	253	4.2459407472608827e-06
C149_253	149	253	2.2938630491354725e-10
R149_255	149	255	3.6801483943052467e-06
C149_255	149	255	2.6465255053387803e-10
R150_151	150	151	9.4586678982956706e-07
C150_151	150	151	9.3609247223865536e-11
R150_152	150	152	2.8031063016633426e-06
C150_152	150	152	3.1587056872391853e-11
R150_159	150	159	4.1147684158248215e-06
C150_159	150	159	3.4428913256616847e-10
R150_160	150	160	1.5460881602581358e+03
C150_160	150	160	5.7268324307727058e-10
R150_181	150	181	2.0798209964961202e-06
C150_181	150	181	4.6829061757568243e-10
R150_189	150	189	1.2985209457048563e+03
C150_189	150	189	6.8186715403299214e-10
R150_218	150	218	2.8141497393367213e+03
C150_218	150	218	3.1463101245944648e-10
R150_252	150	252	1.5155337048091023e+03
C150_252	150	252	5.8422902696943169e-10
R150_255	150	255	3.3101108995864862e-06
C150_255	150	255	2.0507502198861496e-10
R151_152	151	152	3.4194284505055515e-06
C151_152	151	152	2.5893765420624427e-11
R151_159	151	159	2.2140341194219229e-06
C151_159	151	159	3.9991198596848186e-11
R151_153	151	153	5.4537396281025623e-06
C151_153	151	153	1.6235076151005224e-11
R151_154	151	154	3.0830886523142756e-06
C151_154	151	154	2.8718563802418505e-11
R151_255	151	255	4.0055707980731840e-06
C151_255	151	255	2.2104684359240801e-11
R152_156	152	156	5.4165249702302976e-06
C152_156	152	156	1.6346620509761156e-11
R152_181	152	181	4.4752131213129249e-06
C152_181	152	181	1.9784952307259916e-11
R152_154	152	154	6.8868241241158823e-06
C152_154	152	154	1.2856706745268719e-11
R152_255	152	255	4.1105858223977155e-06
C152_255	152	255	2.1539965833471709e-11
R153_154	153	154	6.9605961866821320e-06
C153_154	153	154	1.2720444599186665e-11
R153_159	153	159	1.8468968873784387e-06
C153_159	153	159	4.7940888728054532e-11
R153_162	153	162	4.5068226336253441e-06
C153_162	153	162	1.9646186541575927e-11
R153_155	153	155	6.7697383087432361e-06
C153_155	153	155	1.3079069549209402e-11
R153_256	153	256	7.6798720543206151e-06
C153_256	153	256	1.1529082456547866e-11
R154_159	154	159	5.0429244511267800e-06
C154_159	154	159	1.7557645177535105e-11
R154_255	154	255	1.2555757108761343e-06
C154_255	154	255	7.0518947924068962e-11
R154_156	154	156	7.6222988024450806e-06
C154_156	154	156	1.1616164685330563e-11
R154_157	154	157	5.0521142709475840e-06
C154_157	154	157	1.7525707737682052e-11
R154_155	154	155	6.1275613648683778e-06
C154_155	154	155	1.4449774208324379e-11
R154_256	154	256	3.9419746851633521e-06
C154_256	154	256	2.2461300551535857e-11
R155_162	155	162	8.3767680934890812e-06
C155_162	155	162	1.0569933079419970e-11
R155_256	155	256	1.8365173896240030e-06
C155_256	155	256	4.8211837617354387e-11
R155_157	155	157	1.1243984018106162e-05
C155_157	155	157	7.8746001441678683e-12
R156_179	156	179	2.8336037749400569e-06
C156_179	156	179	3.1247092113954091e-11
R156_253	156	253	9.7209088844422363e-07
C156_253	156	253	9.1083950299859579e-11
R156_254	156	254	3.3166972083088540e-06
C156_254	156	254	2.6695797840149085e-11
R156_157	156	157	2.1453507424874154e-06
C156_157	156	157	4.1271516315015502e-11
R156_255	156	255	2.6547215737373540e-06
C156_255	156	255	3.3352604297914950e-11
R156_257	156	257	3.5847719438943304e-06
C156_257	156	257	2.4699445196452913e-11
R157_254	157	254	8.7234375533864007e-06
C157_254	157	254	1.0149883876411590e-11
R157_255	157	255	4.1619947659991631e-06
C157_255	157	255	2.1273904256999684e-11
R157_256	157	256	5.8156250355909471e-06
C157_256	157	256	1.5224825814617348e-11
R157_257	157	257	1.9125209848587646e-06
C157_257	157	257	4.6295898905673249e-11
R158_168	158	168	1.0943064713660385e+03
C158_168	158	168	8.0911408720330331e-10
R158_169	158	169	6.2297063172295193e+03
C158_169	158	169	1.4212849476566725e-10
R158_161	158	161	3.8203245030874200e+03
C158_161	158	161	2.3176533328109774e-10
R158_201	158	201	2.2447993635300768e+03
C158_201	158	201	3.9443114430842834e-10
R158_202	158	202	4.7788606088380066e+03
C158_202	158	202	1.8527821884206242e-10
R158_216	158	216	1.2035383184086691e+03
C158_216	158	216	7.3567976038412288e-10
R158_247	158	247	9.8500668407887167e+02
C158_247	158	247	8.9889621665663996e-10
R158_258	158	258	3.1341935762585567e+03
C158_258	158	258	2.8250290231178654e-10
R159_160	159	160	1.7450672089959799e+03
C159_160	159	160	5.0738377131584728e-10
R159_161	159	161	2.2552760895319275e+03
C159_161	159	161	3.9259884224807473e-10
R159_162	159	162	9.8666996986909988e-06
C159_162	159	162	9.8711898470493984e-11
R159_252	159	252	6.5807300680220615e+03
C159_252	159	252	1.3454719651890025e-10
R159_255	159	255	5.6373121940691054e-06
C159_255	159	255	1.7277039577845669e-10
R159_256	159	256	6.5712932003713147e-06
C159_256	159	256	1.4821445782407106e-10
R159_260	159	260	3.3942865918331013e+03
C159_260	159	260	2.6085563423854123e-10
R160_161	160	161	2.4621119083111912e+03
C160_161	160	161	3.5961760255947322e-10
R160_189	160	189	2.0980973741235975e+03
C160_189	160	189	4.2201033785186022e-10
R160_188	160	188	3.8550054943830114e+03
C160_188	160	188	2.2968029046654065e-10
R160_247	160	247	1.4571806243802919e+03
C160_247	160	247	6.0762459154749620e-10
R160_249	160	249	2.4723564590509300e+03
C160_249	160	249	3.5812747731364279e-10
R160_252	160	252	2.4167783314410381e+03
C160_252	160	252	3.6636325730877306e-10
R160_259	160	259	3.9841037155477848e+03
C160_259	160	259	2.2223788458234489e-10
R160_260	160	260	4.0373506487124037e+03
C160_260	160	260	2.1930688184896174e-10
R161_162	161	162	6.0806714020679356e+03
C161_162	161	162	1.4561200945653529e-10
R161_169	161	169	5.4558475567015876e+03
C161_169	161	169	1.6228803545150607e-10
R161_247	161	247	3.6746652642379863e+03
C161_247	161	247	2.4095222776260376e-10
R161_256	161	256	1.1905963679986546e+04
C161_256	161	256	7.4367670312009603e-11
R161_258	161	258	2.8755554684728991e+03
C161_258	161	258	3.0791225952953468e-10
R161_259	161	259	8.4592960709569725e+03
C161_259	161	259	1.0466813955594719e-10
R161_260	161	260	2.8287438526025617e+03
C161_260	161	260	3.1300776169089256e-10
R161_261	161	261	3.6257885706596917e+03
C161_261	161	261	2.4420033447755695e-10
R162_169	162	169	1.1987898461957995e+04
C162_169	162	169	7.3859382819245504e-11
R162_256	162	256	1.7848055450815210e-05
C162_256	162	256	5.4569567064604448e-11
R162_261	162	261	1.9564575447681054e+04
C162_261	162	261	4.5256222608446475e-11
R163_164	163	164	1.1664987860612305e+03
C163_164	163	164	7.5903960833914108e-10
R163_167	163	167	4.7280697014474254e+03
C163_167	163	167	1.8726855516299660e-10
R163_202	163	202	2.1093394785338323e+03
C163_202	163	202	4.1976115779876279e-10
R163_203	163	203	2.7718100141361570e+03
C163_203	163	203	3.1943703831950528e-10
R163_262	163	262	5.3147090921024956e+03
C163_262	163	262	1.6659778858182601e-10
R164_165	164	165	2.1894121774013570e+03
C164_165	164	165	4.0440936194614386e-10
R164_166	164	166	2.9986600269076457e+03
C164_166	164	166	2.9527147917901324e-10
R164_167	164	167	5.9062769233767385e+03
C164_167	164	167	1.4991149131452989e-10
R164_203	164	203	7.3894754169627304e+03
C164_203	164	203	1.1982160190525818e-10
R164_231	164	231	4.1364763807937388e+03
C164_231	164	231	2.1405145350548312e-10
R164_262	164	262	4.2638977607574507e+03
C164_262	164	262	2.0765478709384246e-10
R165_166	165	166	8.5026864270708074e+02
C165_166	165	166	1.0413400391681014e-09
R165_192	165	192	2.5870093299251148e+03
C165_192	165	192	3.4225573578647660e-10
R165_230	165	230	1.3837067206509957e+03
C165_230	165	230	6.3988905198309279e-10
R165_231	165	231	2.5524676019081530e+03
C165_231	165	231	3.4688737323760177e-10
R165_235	165	235	3.8091139302049996e+03
C165_235	165	235	2.3244743998831988e-10
R165_244	165	244	6.2270163867932606e+03
C165_244	165	244	1.4218989106530454e-10
R165_263	165	263	2.8853121175074116e+03
C165_263	165	263	3.0687105784066901e-10
R166_192	166	192	1.1077286036851369e+03
C166_192	166	192	7.9931020897576564e-10
R166_203	166	203	9.4587182203057716e+02
C166_203	166	203	9.3608749206547062e-10
R166_193	166	193	2.8751618974187903e+02
C166_193	166	193	3.0795440858300706e-09
R166_231	166	231	2.1056343713277374e+03
C166_231	166	231	4.2049977610390476e-10
R166_235	166	235	2.0494623464206124e+03
C166_235	166	235	4.3202490801862479e-10
R166_262	166	262	9.9500481207644543e+02
C166_262	166	262	8.8986381870078228e-10
R166_263	166	263	1.0493126686495034e+03
C166_263	166	263	8.4380834059647855e-10
R167_171	167	171	2.1138133120350076e+03
C167_171	167	171	4.1887274370866306e-10
R167_201	167	201	4.6156382128135383e+03
C167_201	167	201	1.9183019571204184e-10
R167_202	167	202	4.6099658674740713e+03
C167_202	167	202	1.9206623371056446e-10
R167_231	167	231	3.0464582927192391e+03
C167_231	167	231	2.9063873410513155e-10
R167_232	167	232	2.9436596789366927e+03
C167_232	167	232	3.0078843285981705e-10
R167_262	167	262	1.7803326809349585e+03
C167_262	167	262	4.9733333055202573e-10
R167_265	167	265	2.1323791488619036e+03
C167_265	167	265	4.1522577360248861e-10
R167_266	167	266	2.1137111123763625e+03
C167_266	167	266	4.1889299654793337e-10
R168_169	168	169	1.9767994882130342e+03
C168_169	168	169	4.4790520585392874e-10
R168_175	168	175	9.9138419023086271e+02
C168_175	168	175	8.9311367926274207e-10
R168_176	168	176	2.0159576582695026e+03
C168_176	168	176	4.3920504881042153e-10
R168_201	168	201	1.5598175720803938e+03
C168_201	168	201	5.6764252278494339e-10
R168_216	168	216	1.8958186129101498e+03
C168_216	168	216	4.6703770902473111e-10
R168_258	168	258	3.6763660505424446e+03
C168_258	168	258	2.4084075674927888e-10
R168_268	168	268	3.4593292167977525e+03
C168_268	168	268	2.5595100269745897e-10
R168_269	168	269	2.4468133258603857e+03
C168_269	168	269	3.6186609429579415e-10
R169_176	169	176	9.1677002477641163e+03
C169_176	169	176	9.6580249983188788e-11
R169_258	169	258	1.5980946006097427e+03
C169_258	169	258	5.5404653852292235e-10
R169_261	169	261	4.3790623880053945e+03
C169_261	169	261	2.0219368970975013e-10
R169_269	169	269	3.3984451261406643e+03
C169_269	169	269	2.6053643617470959e-10
R169_270	169	270	6.7089400708089925e+03
C169_270	169	270	1.3197595631424867e-10
R170_171	170	171	2.0169473814788505e+03
C170_171	170	171	4.3898952934052258e-10
R170_172	170	172	2.2765868493143694e+03
C170_172	170	172	3.8892378824320193e-10
R170_232	170	232	1.2595137851164970e+03
C170_232	170	232	7.0298458989720736e-10
R170_233	170	233	5.8746775203000034e+03
C170_233	170	233	1.5071785279114079e-10
R170_250	170	250	1.8222295546987896e+03
C170_250	170	250	4.8589859571581687e-10
R170_266	170	266	4.3803957013130139e+03
C170_266	170	266	2.0213214560378588e-10
R170_271	170	271	3.5341230155727767e+03
C170_271	170	271	2.5053422809519825e-10
R171_172	171	172	3.8929131050272172e+03
C171_172	171	172	2.2744375685051661e-10
R171_174	171	174	6.5247235918316676e+02
C171_174	171	174	1.3570211354370013e-09
R171_175	171	175	1.4666343525258180e+03
C171_175	171	175	6.0370792500199096e-10
R171_201	171	201	2.1066684588848207e+03
C171_201	171	201	4.2029336793161205e-10
R171_232	171	232	3.0165820535303560e+03
C171_232	171	232	2.9351722114231229e-10
R171_265	171	265	2.2672371919351367e+03
C171_265	171	265	3.9052763638914883e-10
R171_266	171	266	1.7382931958545487e+03
C171_266	171	266	5.0936101217650238e-10
R171_268	171	268	2.8671967413382185e+03
C171_268	171	268	3.0880991490201852e-10
R171_271	171	271	3.2277151539970932e+03
C171_271	171	271	2.7431750927696558e-10
R171_274	171	274	2.4963515751826085e+03
C171_274	171	274	3.5468512949151865e-10
R172_174	172	174	3.7051063164707152e+03
C172_174	172	174	2.3897257084471532e-10
R172_173	172	173	6.7909463739894391e+03
C172_173	172	173	1.3038223731103448e-10
R172_271	172	271	1.3485422081707100e+03
C172_271	172	271	6.5657476372286919e-10
R172_250	172	250	8.4065312820399522e+03
C172_250	172	250	1.0532510401664050e-10
R172_272	172	272	8.5576700241484195e+03
C172_272	172	272	1.0346493604000685e-10
R172_273	172	273	6.0301167886362191e+03
C172_273	172	273	1.4683277500836725e-10
R172_275	172	275	6.4801967644757287e+03
C172_275	172	275	1.3663455198673025e-10
R173_174	173	174	3.3751324445712739e+03
C173_174	173	174	2.6233601087985460e-10
R173_177	173	177	2.9141454310268105e+03
C173_177	173	177	3.0383479570819475e-10
R173_273	173	273	1.2106071348699492e+04
C173_273	173	273	7.3138407679640604e-11
R173_275	173	275	3.2891802182449246e+03
C173_275	173	275	2.6919132517842129e-10
R174_175	174	175	2.2915987819068705e+03
C174_175	174	175	3.8637600468753568e-10
R174_177	174	177	1.4579786181252910e+03
C174_177	174	177	6.0729202108498405e-10
R174_268	174	268	4.0714551001047107e+03
C174_268	174	268	2.1746986272235414e-10
R174_271	174	271	2.8993984370236217e+03
C174_271	174	271	3.0538016796647202e-10
R174_274	174	274	1.7452256009741259e+03
C174_274	174	274	5.0733772253042201e-10
R174_275	174	275	8.2706321442801743e+02
C174_275	174	275	1.0705575659199645e-09
R174_276	174	276	1.7075835572779636e+03
C174_276	174	276	5.1852149660625356e-10
R175_176	175	176	2.2389682411175349e+03
C175_176	175	176	3.9545839259339450e-10
R175_177	175	177	4.3406327931699152e+03
C175_177	175	177	2.0398380233712161e-10
R175_201	175	201	1.5249660438334342e+03
C175_201	175	201	5.8061540798262563e-10
R175_268	175	268	1.1890362683919968e+03
C175_268	175	268	7.4465245950605334e-10
R175_269	175	269	3.4798692693249818e+03
C175_269	175	269	2.5444024277146248e-10
R175_276	175	276	2.3994693821363380e+03
C175_276	175	276	3.6900607621493315e-10
R176_177	176	177	4.3899219958852427e+03
C176_177	176	177	2.0169351130382723e-10
R176_269	176	269	4.9221935620093527e+03
C176_269	176	269	1.7988296692228247e-10
R176_276	176	276	8.0880070237101945e+03
C176_276	176	276	1.0947304807035563e-10
R177_275	177	275	5.7076735983565823e+03
C177_275	177	275	1.5512778830852203e-10
R177_276	177	276	3.4903323480826057e+03
C177_276	177	276	2.5367749927493300e-10
R178_224	178	224	3.0478085159985256e-06
C178_224	178	224	2.9050997693991234e-11
R178_227	178	227	7.9048395687642072e-06
C178_227	178	227	1.1200970924175512e-11
R178_179	178	179	2.2264399989591988e-06
C178_179	178	179	3.9768364838662158e-11
R178_228	178	228	2.1515884134076529e-06
C178_228	178	228	4.1151866043826070e-11
R178_229	178	229	1.4803070353491030e-06
C178_229	178	229	5.9813184735097239e-11
R178_180	178	180	1.1368758031481110e-05
C178_180	178	180	7.7881750957157857e-12
R178_277	178	277	5.2698930458428056e-06
C178_277	178	277	1.6801456386263270e-11
R179_228	179	228	1.7080812119304214e-06
C179_228	179	228	5.1837042379227786e-11
R179_253	179	253	4.8072638420763020e-06
C179_253	179	253	1.8418352118521949e-11
R179_180	179	180	6.0524488763987438e-06
C179_180	179	180	1.4629099721150084e-11
R179_254	179	254	3.0157650915679357e-06
C179_254	179	254	2.9359673410095062e-11
R179_277	179	277	6.6719748096228507e-06
C179_277	179	277	1.3270715297410583e-11
R180_254	180	254	8.2679373406915816e-06
C180_254	180	254	1.0709064972496977e-11
R180_277	180	277	2.7189861053281054e-06
C180_277	180	277	3.2564299610245888e-11
R181_183	181	183	3.1977732905495427e-06
C181_183	181	183	3.9686998944811663e-10
R181_187	181	187	4.6448137462247660e+03
C181_187	181	187	1.9062525002636649e-10
R181_189	181	189	1.8208252802114637e+03
C181_189	181	189	4.8627333513140311e-10
R181_218	181	218	1.1592716715225195e+03
C181_218	181	218	7.6377160198967247e-10
R181_219	181	219	4.8866283499768861e+03
C181_219	181	219	1.8119216733643926e-10
R181_279	181	279	3.4994678350947984e+03
C181_279	181	279	2.5301526501272004e-10
R182_184	182	184	3.5137077023280615e-06
C182_184	182	184	3.6118549395472046e-10
R182_185	182	185	3.0980321864385050e-06
C182_185	182	185	3.1438041966107010e-10
R182_190	182	190	3.4385552404490936e+03
C182_190	182	190	2.5749732657613482e-10
R182_199	182	199	2.7276602227913804e+03
C182_199	182	199	3.2460743251734532e-10
R182_205	182	205	1.5982685385407970e+03
C182_205	182	205	5.5398624220456617e-10
R182_280	182	280	2.4167992957359211e+03
C182_280	182	280	3.6636007932565539e-10
R183_184	183	184	2.5191909766272025e-05
C183_184	183	184	3.8661644469686785e-11
R183_185	183	185	2.3113511860892871e-05
C183_185	183	185	2.9369014522885665e-11
R183_186	183	186	2.4835370567620208e-05
C183_186	183	186	5.7042436501511975e-11
R183_187	183	187	7.0157467574710645e+03
C183_187	183	187	1.2620449573056752e-10
R183_219	183	219	1.2269230229974224e+04
C183_219	183	219	7.2165797291576311e-11
R183_279	183	279	1.9072042103646512e+04
C183_279	183	279	4.6424959471472172e-11
R183_281	183	281	4.8133069819132879e+03
C183_281	183	281	1.8395227751462598e-10
R184_185	184	185	1.8956299829543981e-05
C184_185	184	185	7.4733469154516708e-11
R184_187	184	187	8.9478352040601949e+03
C184_187	184	187	9.8953407333455337e-11
R184_198	184	198	3.6142639456945712e+03
C184_198	184	198	2.4497900402507669e-10
R184_199	184	199	9.2519020957766570e+03
C184_199	184	199	9.5701270131703968e-11
R184_280	184	280	4.6618171861908486e+03
C184_280	184	280	1.8992996643514284e-10
R184_281	184	281	1.3495744171268785e+04
C184_281	184	281	6.5607258885729064e-11
R185_186	185	186	5.0192813172732489e-06
C185_186	185	186	1.9404384758118102e-10
R185_190	185	190	2.6822104585101474e+03
C185_190	185	190	3.3010787013030001e-10
R185_210	185	210	1.2981452069539622e-05
C185_210	185	210	7.5027096635929749e-11
R185_280	185	280	4.0138784118223243e+03
C185_280	185	280	2.2058933800588516e-10
R185_281	185	281	2.9205383519166007e+03
C185_281	185	281	3.0316971565154920e-10
R186_210	186	210	1.1315727927558285e-05
C186_210	186	210	1.2519477824708403e-10
R186_190	186	190	9.0481627694017352e+03
C186_190	186	190	9.7856195148724534e-11
R186_219	186	219	1.6669867543763930e+03
C186_219	186	219	5.3114926040982765e-10
R186_220	186	220	4.7482486579329334e-06
C186_220	186	220	2.0511997771406443e-10
R186_221	186	221	4.0481542242172090e+03
C186_221	186	221	2.1872160314524911e-10
R186_281	186	281	1.9307994892178765e+03
C186_281	186	281	4.5857624608066552e-10
R187_188	187	188	1.4717622377160587e+03
C187_188	187	188	6.0160449766263156e-10
R187_189	187	189	1.8349953432170887e+03
C187_189	187	189	4.8251827176176696e-10
R187_196	187	196	1.7249280739733779e+03
C187_196	187	196	5.1330765326372986e-10
R187_198	187	198	2.5833315798432200e+03
C187_198	187	198	3.4274298685023445e-10
R187_279	187	279	2.5213139764190828e+03
C187_279	187	279	3.5117355076797044e-10
R187_280	187	280	5.0954962566962558e+03
C187_280	187	280	1.7376497540086019e-10
R187_281	187	281	3.1237528557469486e+03
C187_281	187	281	2.8344712997093993e-10
R187_282	187	282	1.4830598403397587e+03
C187_282	187	282	5.9702161545764525e-10
R187_284	187	284	9.7702231583214336e+02
C187_284	187	284	9.0624212707554859e-10
R188_189	188	189	6.2431002416875447e+02
C188_189	188	189	1.4182357281206600e-09
R188_196	188	196	1.5961953819809978e+03
C188_196	188	196	5.5470576578233749e-10
R188_247	188	247	4.6866460635366402e+03
C188_247	188	247	1.8892375692476440e-10
R188_248	188	248	2.4746454059727644e+03
C188_248	188	248	3.5779622388038610e-10
R188_249	188	249	1.9211165422275469e+03
C188_249	188	249	4.6088759439515911e-10
R188_284	188	284	1.4408535475237788e+03
C188_284	188	284	6.1450990853418973e-10
R189_218	189	218	2.4168200219435575e+03
C189_218	189	218	3.6635693748844586e-10
R189_249	189	249	8.9816163600600169e+02
C189_249	189	249	9.8581229280436933e-10
R189_252	189	252	4.9947306591291444e+03
C189_252	189	252	1.7727057615843039e-10
R189_279	189	279	3.4244658280716035e+03
C189_279	189	279	2.5855675779909886e-10
R189_284	189	284	2.4980372735357769e+03
C189_284	189	284	3.5444578472872776e-10
R190_205	190	205	8.4738473726820814e+02
C190_205	190	205	1.0448840329062401e-09
R190_210	190	210	2.1127976335737899e+03
C190_210	190	210	4.1907410706548226e-10
R190_212	190	212	2.3879426975398342e+03
C190_212	190	212	3.7078728170998349e-10
R190_217	190	217	1.5662154565150411e+03
C190_217	190	217	5.6532374139004484e-10
R190_221	190	221	4.4552304409840835e+03
C190_221	190	221	1.9873692133967971e-10
R190_280	190	280	2.9007615761595334e+03
C190_280	190	280	3.0523666232239992e-10
R190_281	190	281	4.0419175808661289e+03
C190_281	190	281	2.1905908865916726e-10
R190_285	190	285	1.2571201128599273e+03
C190_285	190	285	7.0432313717874360e-10
R190_286	190	286	1.5959747809636210e+03
C190_286	190	286	5.5478243908428183e-10
R191_194	191	194	2.1259528629397714e+03
C191_194	191	194	4.1648090940061652e-10
R191_199	191	199	1.3452795500945590e+03
C191_199	191	199	6.5816713086716016e-10
R191_200	191	200	1.1225983044393272e+03
C191_200	191	200	7.8872271425905580e-10
R191_204	191	204	2.0576211963985356e+03
C191_204	191	204	4.3031184906617058e-10
R191_206	191	206	3.0412722659929336e+03
C191_206	191	206	2.9113433598189315e-10
R191_207	191	207	1.3644840934930353e+03
C191_207	191	207	6.4890370354802481e-10
R191_215	191	215	3.4570838386278560e+03
C191_215	191	215	2.5611724303782861e-10
R191_288	191	288	3.1620865497508053e+03
C191_288	191	288	2.8001092562434045e-10
R192_195	192	195	1.6623656171919195e+03
C192_195	192	195	5.3262577891598608e-10
R192_197	192	197	3.3407867691851770e+03
C192_197	192	197	2.6503301254271756e-10
R192_203	192	203	3.2441538972726485e+03
C192_203	192	203	2.7292749041417832e-10
R192_193	192	193	2.6653041960903870e+03
C192_193	192	193	3.3220177381582948e-10
R192_234	192	234	6.3817357321367499e+03
C192_234	192	234	1.3874262721993686e-10
R192_235	192	235	1.9932409448082842e+03
C192_235	192	235	4.4421061287458269e-10
R192_290	192	290	2.7597231545701884e+03
C192_290	192	290	3.2083608829882765e-10
R193_203	193	203	1.0575112555650910e+03
C193_203	193	203	8.3726653219106247e-10
R193_235	193	235	1.3899436071883511e+03
C193_235	193	235	6.3701777332612099e-10
R193_262	193	262	1.8073922111588990e+03
C193_262	193	262	4.8988746119043523e-10
R193_263	193	263	1.5988764764959778e+03
C193_263	193	263	5.5377560100230009e-10
R193_264	193	264	7.5735421834312126e+02
C193_264	193	264	1.1690946722882831e-09
R193_290	193	290	1.8280951732350468e+03
C193_290	193	290	4.8433954351136932e-10
R194_195	194	195	1.7163482026421707e+03
C194_195	194	195	5.1587363236490941e-10
R194_197	194	197	3.1377519332289853e+03
C194_197	194	197	2.8218253085062617e-10
R194_198	194	198	2.0801432006511554e+03
C194_198	194	198	4.2565280189500123e-10
R194_199	194	199	2.0052094769696168e+03
C194_199	194	199	4.4155924449254736e-10
R194_200	194	200	2.0190940819635771e+03
C194_200	194	200	4.3852279574754969e-10
R194_234	194	234	4.1667547028152176e+03
C194_234	194	234	2.1249601784856154e-10
R194_291	194	291	1.5944448120188943e+03
C194_291	194	291	5.5531478733270054e-10
R195_197	195	197	1.1276228145576481e+03
C195_197	195	197	7.8520828974832167e-10
R195_234	195	234	1.6807582277630543e+03
C195_234	195	234	5.2679723179366304e-10
R195_290	195	290	3.8347230225384992e+03
C195_290	195	290	2.3089510676415762e-10
R195_291	195	291	3.2918856769799027e+03
C195_291	195	291	2.6897008844861102e-10
R196_197	196	197	9.3455007312892212e+02
C196_197	196	197	9.4742786626250199e-10
R196_198	196	198	1.2294723304206368e+03
C196_198	196	198	7.2016161713625037e-10
R196_203	196	203	2.7415391113598835e+03
C196_203	196	203	3.2296412552757875e-10
R196_248	196	248	1.6627800292372174e+03
C196_248	196	248	5.3249303343279659e-10
R196_282	196	282	3.2553117171835147e+03
C196_282	196	282	2.7199201140284700e-10
R196_284	196	284	1.7340255079835624e+03
C196_284	196	284	5.1061462338557101e-10
R196_290	196	290	3.6068458951792691e+03
C196_290	196	290	2.4548284219278865e-10
R196_292	196	292	1.5287332216758684e+03
C196_292	196	292	5.7918462760256031e-10
R197_198	197	198	1.3096987141411564e+03
C197_198	197	198	6.7604768344040047e-10
R197_203	197	203	2.9131015317152846e+03
C197_203	197	203	3.0394367379933035e-10
R197_290	197	290	1.6823606209647842e+03
C197_290	197	290	5.2629547474324400e-10
R197_291	197	291	2.1352755287864857e+03
C197_291	197	291	4.1466254343447596e-10
R197_292	197	292	3.5069478206973376e+03
C197_292	197	292	2.5247560755664147e-10
R198_199	198	199	2.5905196288717511e+03
C198_199	198	199	3.4179196012717588e-10
R198_280	198	280	3.2689513913507112e+03
C198_280	198	280	2.7085712685808712e-10
R198_282	198	282	1.3664070814302725e+03
C198_282	198	282	6.4799048082596075e-10
R198_291	198	291	2.5804365283664079e+03
C198_291	198	291	3.4312751814148688e-10
R198_292	198	292	3.3824654231880245e+03
C198_292	198	292	2.6176728241776952e-10
R199_200	199	200	2.9287275549009919e+03
C199_200	199	200	3.0232200336228691e-10
R199_205	199	205	2.1847592442879713e+03
C199_205	199	205	4.0527064206956324e-10
R199_206	199	206	3.7175449754561373e+03
C199_206	199	206	2.3817298446842879e-10
R199_280	199	280	1.5725702343727289e+03
C199_280	199	280	5.6303926040745528e-10
R199_282	199	282	3.8707570681256930e+03
C199_282	199	282	2.2874563454036123e-10
R199_288	199	288	2.4177540195021179e+03
C199_288	199	288	3.6621541089706551e-10
R199_289	199	289	3.5386938302419326e+03
C199_289	199	289	2.5021062125611075e-10
R199_291	199	291	4.5000915500359215e+03
C199_291	199	291	1.9675572637915160e-10
R199_294	199	294	4.0835644401841982e+03
C199_294	199	294	2.1682498088852524e-10
R200_204	200	204	9.7828852739884348e+02
C200_204	200	204	9.0506916610197462e-10
R200_215	200	215	2.5735467813164682e+03
C200_215	200	215	3.4404611881470219e-10
R200_234	200	234	2.0827397931195042e+03
C200_234	200	234	4.2512213221500403e-10
R200_288	200	288	2.5669066201582991e+03
C200_288	200	288	3.4493610899074974e-10
R200_291	200	291	1.3531343645803483e+03
C200_291	200	291	6.5434653414821644e-10
R200_294	200	294	1.7176879659591216e+03
C200_294	200	294	5.1547126093160948e-10
R200_295	200	295	2.1319975737541104e+03
C200_295	200	295	4.1530008879931218e-10
R200_296	200	296	1.4324361615154492e+03
C200_296	200	296	6.1812093654719611e-10
R201_202	201	202	9.8882325872995705e+02
C201_202	201	202	8.9542673463934358e-10
R201_216	201	216	1.1525034099133759e+03
C201_216	201	216	7.6825697354470285e-10
R201_265	201	265	1.5778283190943137e+03
C201_265	201	265	5.6116294211795989e-10
R201_268	201	268	1.8744102400066643e+03
C201_268	201	268	4.7237192947518907e-10
R201_297	201	297	5.8637130679133070e+03
C201_297	201	297	1.5099967741346014e-10
R202_203	202	203	1.6943752006249749e+03
C202_203	202	203	5.2256358649100324e-10
R202_216	202	216	2.2442323462012505e+03
C202_216	202	216	3.9453079945074481e-10
R202_247	202	247	1.8017452358633993e+03
C202_247	202	247	4.9142285161958854e-10
R202_248	202	248	1.9374978228408463e+03
C202_248	202	248	4.5699085246029297e-10
R202_262	202	262	1.7744932205177581e+03
C202_262	202	262	4.9896994334058620e-10
R202_265	202	265	1.8527126033011061e+03
C202_265	202	265	4.7790400957082504e-10
R202_297	202	297	1.2474370359652203e+03
C202_297	202	297	7.0979035909006497e-10
R202_298	202	298	1.8458881210834745e+03
C202_298	202	298	4.7967088123428019e-10
R203_248	203	248	2.2775637471430791e+03
C203_248	203	248	3.8875697016632271e-10
R203_262	203	262	1.3319795154985088e+03
C203_262	203	262	6.6473903794880951e-10
R203_264	203	264	2.5205640154279845e+03
C203_264	203	264	3.5127803788377835e-10
R203_290	203	290	1.0146284851107936e+03
C203_290	203	290	8.7265318753919633e-10
R203_298	203	298	2.4644331390058101e+03
C203_298	203	298	3.5927888149450531e-10
R204_207	204	207	1.7621861509414236e+03
C204_207	204	207	5.0245473852292920e-10
R204_215	204	215	7.3082212545776554e+02
C204_215	204	215	1.2115380074808216e-09
R204_234	204	234	1.3712329258980187e+03
C204_234	204	234	6.4570997747894680e-10
R204_237	204	237	1.8188254894663387e+03
C204_237	204	237	4.8680799055647194e-10
R204_240	204	240	2.4739716068183275e+03
C204_240	204	240	3.5789367156024100e-10
R204_241	204	241	7.8358235289126560e+02
C204_241	204	241	1.1299626368983145e-09
R204_287	204	287	6.9311243247560878e+02
C204_287	204	287	1.2774533253393328e-09
R204_295	204	295	2.1190417866145003e+03
C204_295	204	295	4.1783922681137627e-10
R204_296	204	296	1.0540610535284488e+03
C204_296	204	296	8.4000711224086870e-10
R204_300	204	300	1.2253145217865890e+03
C204_300	204	300	7.2260531149912542e-10
R205_206	205	206	3.0470793349644623e+03
C205_206	205	206	2.9057949740265835e-10
R205_208	205	208	3.4749197118557531e+03
C205_208	205	208	2.5480265880075515e-10
R205_212	205	212	3.6116258559027733e+03
C205_212	205	212	2.4515794742494940e-10
R205_280	205	280	3.8010284581073356e+03
C205_280	205	280	2.3294189755708404e-10
R205_285	205	285	4.7235134722988014e+03
C205_285	205	285	1.8744919155890365e-10
R205_286	205	286	1.6831934908285032e+03
C205_286	205	286	5.2603505569890131e-10
R205_288	205	288	4.8837691076783613e+03
C205_288	205	288	1.8129824776276311e-10
R205_289	205	289	5.6432994477181828e+03
C205_289	205	289	1.5689735940877834e-10
R205_303	205	303	7.0163798433739385e+03
C205_303	205	303	1.2619310833579846e-10
R206_207	206	207	6.4983211675298880e+03
C206_207	206	207	1.3625346591426802e-10
R206_208	206	208	1.0196998507540047e+04
C206_208	206	208	8.6831314238723092e-11
R206_288	206	288	5.4400248575231626e+03
C206_288	206	288	1.6276006174411681e-10
R206_303	206	303	8.0490678236738868e+03
C206_303	206	303	1.1000264889007517e-10
R207_215	207	215	8.0274960671990402e+02
C207_215	207	215	1.1029825169493243e-09
R207_241	207	241	3.8246667163861644e+03
C207_241	207	241	2.3150220590635170e-10
R207_288	207	288	2.7801630083080986e+03
C207_288	207	288	3.1847729037975799e-10
R207_301	207	301	5.6433541052486335e+03
C207_301	207	301	1.5689583981209176e-10
R207_303	207	303	4.6728957432163961e+03
C207_303	207	303	1.8947967820282640e-10
R208_209	208	209	2.6487810064051068e+03
C208_209	208	209	3.3427406024089538e-10
R208_212	208	212	6.6717772791781476e+02
C208_212	208	212	1.3271108201757433e-09
R208_303	208	303	4.3298978600135861e+03
C208_303	208	303	2.0448953077549551e-10
R208_304	208	304	4.0696448409789241e+03
C208_304	208	304	2.1756659765106654e-10
R209_212	209	212	1.8021729033217250e+03
C209_212	209	212	4.9130623375149837e-10
R209_213	209	213	3.6002209801836766e+03
C209_213	209	213	2.4593456528738619e-10
R209_214	209	214	5.7726010672017883e+03
C209_214	209	214	1.5338298479184499e-10
R209_304	209	304	4.5859750493726578e+03
C209_304	209	304	1.9307099846108444e-10
R210_211	210	211	2.4159562033068261e-06
C210_211	210	211	4.0313671976459524e-10
R210_217	210	217	1.4350963628988936e+03
C210_217	210	217	6.1697514159359647e-10
R210_220	210	220	2.4864973212253253e-06
C210_220	210	220	2.7300293457904689e-10
R210_221	210	221	9.7502563872775693e+02
C210_221	210	221	9.0809794792198650e-10
R210_222	210	222	3.6592903810514865e-06
C210_222	210	222	3.8714338056656726e-10
R210_305	210	305	2.7461127393522643e+03
C210_305	210	305	3.2242623145503014e-10
R211_213	211	213	6.9367193821699211e+03
C211_213	211	213	1.2764229499839250e-10
R211_217	211	217	1.1545461962920810e+04
C211_217	211	217	7.6689766467863697e-11
R211_222	211	222	1.7398293183318262e-05
C211_222	211	222	3.0534677347761097e-11
R211_305	211	305	1.1708476705774729e+04
C211_305	211	305	7.5622030427177900e-11
R212_213	212	213	5.1110734366934912e+03
C212_213	212	213	1.7323538639523137e-10
R212_217	212	217	2.1336679623113846e+03
C212_217	212	217	4.1497496205587370e-10
R212_286	212	286	1.7149016317478170e+03
C212_286	212	286	5.1630878722623111e-10
R212_303	212	303	8.1209500120919283e+03
C212_303	212	303	1.0902896586995728e-10
R212_304	212	304	2.2249423787644178e+03
C212_304	212	304	3.9795133130220737e-10
R212_306	212	306	3.4176836022201219e+03
C212_306	212	306	2.5906985103150960e-10
R212_307	212	307	5.4792824232925623e+03
C212_307	212	307	1.6159393024459983e-10
R213_214	213	214	6.0094751360891105e+03
C213_214	213	214	1.4733712373360767e-10
R213_217	213	217	6.2868819924462259e+03
C213_217	213	217	1.4083591560392620e-10
R213_304	213	304	1.1297715875833617e+04
C213_304	213	304	7.8371486009305228e-11
R213_305	213	305	1.0970161057772815e+04
C213_305	213	305	8.0711557199303300e-11
R213_306	213	306	8.9968335307383550e+03
C213_306	213	306	9.8414489795204097e-11
R213_308	213	308	8.1442312568179887e+03
C213_308	213	308	1.0871729372355024e-10
R214_304	214	304	1.9797810080675226e+04
C214_304	214	304	4.4723066747885581e-11
R214_308	214	308	2.9906309007918957e+04
C214_308	214	308	2.9606421222543648e-11
R214_309	214	309	6.9919144173394350e+04
C214_309	214	309	1.2663467097140467e-11
R215_241	215	241	6.2784942915861311e+03
C215_241	215	241	1.4102406414330233e-10
R215_288	215	288	1.7655943157930312e+03
C215_288	215	288	5.0148483928614537e-10
R215_296	215	296	2.1567100105987633e+03
C215_296	215	296	4.1054141602198196e-10
R215_300	215	300	2.7166626138260749e+03
C215_300	215	300	3.2592151016242679e-10
R215_301	215	301	2.6750179292679877e+03
C215_301	215	301	3.3099545689486002e-10
R215_303	215	303	9.2040363643932014e+03
C215_303	215	303	9.6198966045520769e-11
R215_310	215	310	2.7919391601362954e+03
C215_310	215	310	3.1713398140695018e-10
R215_311	215	311	6.8294479108819869e+03
C215_311	215	311	1.2964719743878283e-10
R216_247	216	247	1.4318141812652555e+03
C216_247	216	247	6.1838944835535825e-10
R216_258	216	258	1.1311918511933313e+03
C216_258	216	258	7.8273086989262068e-10
R216_268	216	268	1.1931784843877119e+03
C216_268	216	268	7.4206733802643044e-10
R216_265	216	265	5.2912678729438330e+03
C216_265	216	265	1.6733584520025279e-10
R216_269	216	269	4.4061120686703116e+03
C216_269	216	269	2.0095239701136429e-10
R216_297	216	297	1.7712236623754468e+03
C216_297	216	297	4.9989100784286937e-10
R216_313	216	313	2.4942678080417422e+03
C216_313	216	313	3.5498144138545624e-10
R216_314	216	314	2.2691346853453438e+03
C216_314	216	314	3.9020106978147332e-10
R217_221	217	221	4.6942288595269283e+03
C217_221	217	221	1.8861858000447598e-10
R217_285	217	285	3.0765069573639935e+03
C217_285	217	285	2.8780002579894794e-10
R217_286	217	286	1.4235318887500432e+03
C217_286	217	286	6.2198731809053978e-10
R217_299	217	299	6.1506417879415867e+03
C217_299	217	299	1.4395551102258548e-10
R217_305	217	305	2.1025792202648040e+03
C217_305	217	305	4.2111078296897090e-10
R217_306	217	306	1.4407218284522587e+03
C217_306	217	306	6.1456609056252679e-10
R217_316	217	316	2.3524391149132671e+03
C217_316	217	316	3.7638329344504411e-10
R218_219	218	219	3.7666875386369229e+03
C218_219	218	219	2.3506563064172095e-10
R218_223	218	223	1.5692927555543017e+03
C218_223	218	223	5.6421517181302132e-10
R218_251	218	251	2.9313298671248854e+03
C218_251	218	251	3.0205361451471126e-10
R218_252	218	252	1.6089184667497609e+03
C218_252	218	252	5.5031923618147605e-10
R218_249	218	249	2.9351079726028879e+03
C218_249	218	249	3.0166480755213930e-10
R218_279	218	279	1.2756086138224107e+03
C218_279	218	279	6.9411477165147731e-10
R218_322	218	322	1.4658181514522532e+03
C218_322	218	322	6.0404408338290462e-10
R219_220	219	220	3.7889719109601815e+03
C219_220	219	220	2.3368312104367695e-10
R219_221	219	221	1.9989694305366620e+03
C219_221	219	221	4.4293762984774217e-10
R219_223	219	223	1.5851378227462847e+03
C219_223	219	223	5.5857526644969787e-10
R219_279	219	279	1.1071507250033794e+03
C219_279	219	279	7.9972740992180386e-10
R219_281	219	281	1.0457840978624165e+03
C219_281	219	281	8.4665542678435890e-10
R219_283	219	283	1.3792856823923867e+03
C219_283	219	283	6.4194009479184255e-10
R219_319	219	319	3.7368945044516054e+03
C219_319	219	319	2.3693973181347184e-10
R219_323	219	323	5.3510271684856898e+03
C219_323	219	323	1.6546706899837483e-10
R220_221	220	221	1.3401603535526735e+03
C220_221	220	221	6.6068122322288922e-10
R220_222	220	222	4.3512193394870286e-06
C220_222	220	222	1.7296438197235800e-10
R220_223	220	223	4.0177069531868874e+03
C220_223	220	223	2.2037913466975894e-10
R220_224	220	224	5.9260541007125748e-06
C220_224	220	224	1.6435230633127804e-10
R220_226	220	226	2.8014244119893588e+03
C220_226	220	226	3.1606020776810566e-10
R220_227	220	227	8.7782896243219461e-06
C220_227	220	227	1.6138337981807269e-10
R220_324	220	324	5.6856484616380958e+03
C220_324	220	324	1.5572872429135400e-10
R221_222	221	222	5.1544456536665584e+03
C221_222	221	222	1.7177769273213059e-10
R221_223	221	223	5.8676264377808111e+03
C221_223	221	223	1.5089896930024628e-10
R221_226	221	226	4.3595161619654182e+03
C221_226	221	226	2.0310024067001582e-10
R221_281	221	281	4.1581189183337010e+03
C221_281	221	281	2.1293733995823703e-10
R221_283	221	283	2.1015423104902197e+03
C221_283	221	283	4.2131856079236463e-10
R221_285	221	285	3.3804190918160675e+03
C221_285	221	285	2.6192574282981144e-10
R221_299	221	299	1.1671544004776197e+03
C221_299	221	299	7.5861324031993660e-10
R221_305	221	305	4.2390134175534631e+03
C221_305	221	305	2.0887378606388502e-10
R221_323	221	323	2.2897310530068648e+03
C221_323	221	323	3.8669117079810395e-10
R221_324	221	324	2.6672203163034078e+03
C221_324	221	324	3.3196312141440657e-10
R222_227	222	227	2.1725855380383711e-05
C222_227	222	227	4.4829565595628024e-11
R222_305	222	305	7.1237300240879476e+03
C222_305	222	305	1.2429145668155221e-10
R222_324	222	324	5.6021180437122457e+03
C222_324	222	324	1.5805071845884867e-10
R223_224	223	224	2.8402340452057520e+03
C223_224	223	224	3.1174148595062651e-10
R223_225	223	225	2.8827756923960856e+03
C223_225	223	225	3.0714105992896866e-10
R223_226	223	226	7.8364387777738057e+02
C223_226	223	226	1.1298739220821580e-09
R223_251	223	251	1.5849389708193933e+03
C223_251	223	251	5.5864534723519977e-10
R223_279	223	279	3.5600693968107694e+03
C223_279	223	279	2.4870829273530120e-10
R223_319	223	319	4.5803640805138639e+03
C223_319	223	319	1.9330751139779834e-10
R223_322	223	322	1.3456662867680373e+03
C223_322	223	322	6.5797797745721964e-10
R223_323	223	323	2.3389334622047882e+03
C223_323	223	323	3.7855663532444524e-10
R223_325	223	325	2.8093079992964413e+03
C223_325	223	325	3.1517326755262966e-10
R224_225	224	225	1.1977650140056310e+03
C224_225	224	225	7.3922578414520094e-10
R224_226	224	226	1.9690479857578675e+03
C224_226	224	226	4.4966846318842301e-10
R224_227	224	227	5.8607706677371239e-06
C224_227	224	227	1.6618303532291103e-10
R224_228	224	228	5.0587569588459391e-06
C224_228	224	228	1.9252964054597124e-10
R224_229	224	229	8.9492471801195175e-06
C224_229	224	229	1.0883157424231879e-10
R224_253	224	253	8.7197066078208686e-06
C224_253	224	253	1.1169649424012451e-10
R224_326	224	326	2.1195609664149601e+03
C224_326	224	326	4.1773687840534426e-10
R225_226	225	226	2.7750211750253106e+03
C225_226	225	226	3.1906739655488375e-10
R225_251	225	251	1.5833908009803988e+03
C225_251	225	251	5.5919156606933004e-10
R225_253	225	253	1.5182229401121938e+03
C225_253	225	253	5.8319417939671592e-10
R225_228	225	228	1.8327583790117944e+03
C225_228	225	228	4.8310720705989041e-10
R225_320	225	320	1.2148631257394293e+03
C225_320	225	320	7.2882184251093146e-10
R225_325	225	325	1.1335327313886157e+03
C225_325	225	325	7.8111443735315184e-10
R225_326	225	326	1.0045592817677842e+03
C225_326	225	326	8.8140022970259617e-10
R226_227	226	227	5.0819494695803760e+03
C226_227	226	227	1.7422817503400135e-10
R226_323	226	323	2.7489891927083486e+03
C226_323	226	323	3.2208885507755350e-10
R226_324	226	324	6.2425385158329545e+03
C226_324	226	324	1.4183633460239161e-10
R226_325	226	325	2.1768534303249148e+03
C226_325	226	325	4.0674248866072874e-10
R226_326	226	326	4.2048759241051584e+03
C226_326	226	326	2.1056953824111388e-10
R226_327	226	327	5.7406516670436840e+03
C226_327	226	327	1.5423663253826589e-10
R226_328	226	328	1.8993042090447434e+03
C226_328	226	328	4.6618060313009168e-10
R227_229	227	229	1.9291230943743647e-05
C227_229	227	229	9.6384696408098193e-11
R227_324	227	324	3.9260469864610204e+03
C227_324	227	324	2.2552424480740252e-10
R227_326	227	326	5.5053284919271719e+03
C227_326	227	326	1.6082941880731519e-10
R227_327	227	327	3.2983565244438118e+03
C227_327	227	327	2.6844241219475345e-10
R227_328	227	328	8.1493596150570802e+03
C227_328	227	328	1.0864887838107734e-10
R228_229	228	229	4.8200728336266238e-06
C228_229	228	229	2.9391050664458374e-10
R228_253	228	253	2.9855639730170863e-06
C228_253	228	253	3.2622334262420633e-10
R228_254	228	254	3.9677870117896227e-06
C228_254	228	254	3.5704286656153536e-10
R228_277	228	277	4.7182317890143996e-06
C228_277	228	277	2.0642492833093563e-10
R228_278	228	278	2.7569527211989202e+03
C228_278	228	278	3.2115849317682773e-10
R228_320	228	320	3.0462622418163555e+03
C228_320	228	320	2.9065743899056532e-10
R228_326	228	326	1.5752233662423560e+03
C228_326	228	326	5.6209093940254184e-10
R228_329	228	329	3.5312562654721096e+03
C228_329	228	329	2.5073761719234060e-10
R229_277	229	277	1.7544600121949429e-05
C229_277	229	277	5.5513414505101870e-11
R229_326	229	326	1.4181652886177892e+03
C229_326	229	326	6.2434103330999649e-10
R229_327	229	327	6.7476135938176849e+03
C229_327	229	327	1.3121954441956199e-10
R229_329	229	329	2.6314284765046154e+03
C229_329	229	329	3.3647837651894743e-10
R230_231	230	231	1.5675093162845053e+03
C230_231	230	231	5.6485710962070936e-10
R230_233	230	233	1.5577701794981647e+03
C230_233	230	233	5.6838858090430096e-10
R230_244	230	244	1.8673847596220869e+03
C230_244	230	244	4.7414908852484533e-10
R230_245	230	245	4.1407056020359987e+03
C230_245	230	245	2.1383282628560617e-10
R230_263	230	263	3.5291160575843246e+03
C230_263	230	263	2.5088967527638296e-10
R230_330	230	330	3.5140008204659989e+03
C230_330	230	330	2.5196886026411990e-10
R231_232	231	232	9.3438610138959177e+02
C231_232	231	232	9.4759412664981990e-10
R231_233	231	233	4.8960234419830349e+03
C231_233	231	233	1.8084447351857029e-10
R231_262	231	262	1.4168802842980233e+03
C231_262	231	262	6.2490726387562847e-10
R231_263	231	263	1.1219319444588493e+03
C231_263	231	263	7.8919116803209646e-10
R231_266	231	266	3.7202862638831825e+03
C231_266	231	266	2.3799748699332952e-10
R231_267	231	267	1.9372575558678975e+03
C231_267	231	267	4.5704753042159633e-10
R231_330	231	330	2.2716663889408242e+03
C231_330	231	330	3.8976620247167163e-10
R232_233	232	233	2.1407707232287103e+03
C232_233	232	233	4.1359813645274977e-10
R232_250	232	250	4.6811253321739359e+03
C232_250	232	250	1.8914656602215079e-10
R232_266	232	266	1.2835417079756198e+03
C232_266	232	266	6.8982470627812120e-10
R232_267	232	267	4.6215894329570256e+03
C232_267	232	267	1.9158317599265492e-10
R232_330	232	330	1.7390761677924195e+03
C232_330	232	330	5.0913168617792581e-10
R233_245	233	245	7.6264118346586038e+03
C233_245	233	245	1.1609899922741789e-10
R233_250	233	250	8.0127905435809871e+03
C233_250	233	250	1.1050067724649378e-10
R233_330	233	330	2.7757962602768221e+03
C233_330	233	330	3.1897830340462375e-10
R233_331	233	331	1.1559307533722946e+04
C233_331	233	331	7.6597908578597206e-11
R234_235	234	235	4.5579687002724377e+03
C234_235	234	235	1.9425731941666845e-10
R234_237	234	237	2.4655126314387085e+03
C234_237	234	237	3.5912157593908939e-10
R234_287	234	287	5.6434834241298659e+03
C234_287	234	287	1.5689224458677620e-10
R234_290	234	290	4.6290554292523202e+03
C234_290	234	290	1.9127418006377424e-10
R234_291	234	291	2.5640808706465828e+03
C234_291	234	291	3.4531624639308845e-10
R234_293	234	293	3.2246783108562954e+03
C234_293	234	293	2.7457584799051852e-10
R234_295	234	295	2.4386029376799047e+03
C234_295	234	295	3.6308443987293423e-10
R234_337	234	337	4.3062807142814800e+03
C234_337	234	337	2.0561102270076600e-10
R235_237	235	237	6.6286347365274596e+03
C235_237	235	237	1.3357483356577952e-10
R235_238	235	238	4.2811495841705864e+03
C235_238	235	238	2.0681799696366781e-10
R235_244	235	244	2.3357740278437391e+03
C235_244	235	244	3.7906868179254953e-10
R235_263	235	263	1.8618877209901159e+03
C235_263	235	263	4.7554896663110878e-10
R235_264	235	264	3.5585851154440147e+03
C235_264	235	264	2.4881202865075317e-10
R235_290	235	290	4.9020424726184292e+03
C235_290	235	290	1.8062242149996162e-10
R235_293	235	293	3.9503787838478052e+03
C235_293	235	293	2.2413516023331101e-10
R235_336	235	336	3.4017535998148210e+03
C235_336	235	336	2.6028304394186547e-10
R235_337	235	337	3.1863180452058041e+03
C235_337	235	337	2.7788148236872283e-10
R235_338	235	338	4.4211736713598593e+03
C235_338	235	338	2.0026781291938341e-10
R235_339	235	339	6.2618663513435740e+03
C235_339	235	339	1.4139854350452893e-10
R236_246	236	246	1.1925568359287159e+04
C236_246	236	246	7.4245415817894397e-11
R236_243	236	243	1.1424265583137028e+04
C236_243	236	243	7.7503343672869127e-11
R236_334	236	334	9.5543722090513220e+03
C236_334	236	334	9.2671581379381441e-11
R236_332	236	332	1.1903811255573535e+04
C236_332	236	332	7.4381117332101020e-11
R236_333	236	333	3.4359587968907057e+04
C236_333	236	333	2.5769190902441553e-11
R236_340	236	340	1.1772342604145100e+04
C236_340	236	340	7.5211774875481415e-11
R237_238	237	238	2.0255312213981879e+03
C237_238	237	238	4.3712917004005068e-10
R237_240	237	240	1.6495222656095912e+03
C237_240	237	240	5.3677285851778904e-10
R237_242	237	242	6.4901351832988248e+03
C237_242	237	242	1.3642532192217866e-10
R237_287	237	287	1.9744495523688784e+03
C237_287	237	287	4.4843829037703418e-10
R237_337	237	337	2.9440859906572182e+03
C237_337	237	337	3.0074487787034551e-10
R237_341	237	341	4.1041541963598984e+03
C237_341	237	341	2.1573721145402025e-10
R238_239	238	239	2.7575007470532000e+03
C238_239	238	239	3.2109466611974692e-10
R238_242	238	242	3.2125825155671478e+03
C238_242	238	242	2.7560966213616113e-10
R238_244	238	244	6.3064352163009780e+03
C238_244	238	244	1.4039925113499222e-10
R238_335	238	335	7.9716122628888179e+03
C238_335	238	335	1.1107148121365538e-10
R238_337	238	337	7.5908525976356113e+03
C238_337	238	337	1.1664286327675354e-10
R238_338	238	338	4.1715492056899775e+03
C238_338	238	338	2.1225178897381630e-10
R238_341	238	341	4.1040905255690213e+03
C238_341	238	341	2.1574055839746349e-10
R238_342	238	342	4.6002542212043636e+03
C238_342	238	342	1.9247170680671518e-10
R239_242	239	242	6.0865427957545244e+03
C239_242	239	242	1.4547154458810280e-10
R239_243	239	243	2.4136195118902533e+03
C239_243	239	243	3.6684273446504186e-10
R239_244	239	244	4.6621281312360125e+03
C239_244	239	244	1.8991729887639525e-10
R239_245	239	245	4.6500005092243255e+03
C239_245	239	245	1.9041262037360474e-10
R239_246	239	246	2.0165675288117691e+03
C239_246	239	246	4.3907222002216769e-10
R239_334	239	334	2.3773081688214361e+03
C239_334	239	334	3.7244594256324428e-10
R239_335	239	335	1.2167591009616119e+03
C239_335	239	335	7.2768617962277704e-10
R239_342	239	342	2.2719537963318990e+03
C239_342	239	342	3.8971689614882183e-10
R240_241	240	241	4.0736694681550994e+03
C240_241	240	241	2.1735165030485210e-10
R240_242	240	242	5.0410196572572959e+03
C240_242	240	242	1.7564279489077338e-10
R240_287	240	287	2.7727088129065341e+03
C240_287	240	287	3.1933348989930406e-10
R240_341	240	341	7.1431681479129957e+03
C240_341	240	341	1.2395323242652366e-10
R240_343	240	343	6.5142026922068435e+03
C240_343	240	343	1.3592128208710112e-10
R241_287	241	287	2.6079396864668515e+03
C241_287	241	287	3.3950891820643880e-10
R241_300	241	300	2.1994642741623443e+03
C241_300	241	300	4.0256111094925953e-10
R241_301	241	301	6.4918275770924729e+03
C241_301	241	301	1.3638975637990634e-10
R241_302	241	302	4.7057804208053813e+03
C241_302	241	302	1.8815556666973918e-10
R241_343	241	343	1.0171370220414823e+04
C241_343	241	343	8.7050098709698688e-11
R242_243	242	243	6.5348551685013363e+03
C242_243	242	243	1.3549172229061914e-10
R242_341	242	341	3.1513518857214822e+03
C242_341	242	341	2.8096474586407191e-10
R242_342	242	342	4.0447631366043115e+03
C242_342	242	342	2.1890497707693541e-10
R242_343	242	343	1.1263820847888637e+04
C242_343	242	343	7.8607321055356528e-11
R242_344	242	344	7.2889754820351855e+03
C242_344	242	344	1.2147369460663608e-10
R243_246	243	246	8.8705870122129872e+03
C243_246	243	246	9.9815128410437691e-11
R243_334	243	334	2.2675135820734017e+03
C243_334	243	334	3.9048003447475637e-10
R243_340	243	340	1.2285527838744289e+04
C243_340	243	340	7.2070064332742514e-11
R243_342	243	342	4.9236393160096914e+03
C243_342	243	342	1.7983014694455274e-10
R243_344	243	344	7.2190118758532035e+03
C243_344	243	344	1.2265096621625292e-10
R244_245	244	245	4.7395430455714613e+03
C244_245	244	245	1.8681522104273710e-10
R244_263	244	263	3.1137093704903577e+03
C244_263	244	263	2.8436140832262750e-10
R244_330	244	330	6.3155187315353623e+03
C244_330	244	330	1.4019731701195448e-10
R244_335	244	335	3.6832878687422872e+03
C244_335	244	335	2.4038815679164910e-10
R244_338	244	338	2.3735652593254981e+03
C244_338	244	338	3.7303325797396093e-10
R244_339	244	339	2.2681893192027956e+03
C244_339	244	339	3.9036370297837384e-10
R244_347	244	347	2.7152399854305063e+03
C244_347	244	347	3.2609227414556328e-10
R245_246	245	246	7.4598379716062218e+03
C245_246	245	246	1.1869142266495572e-10
R245_330	245	330	9.9378464459208462e+03
C245_330	245	330	8.9095639233129318e-11
R245_331	245	331	9.6774217916730286e+03
C245_331	245	331	9.1493251070430947e-11
R245_335	245	335	8.2389986875501108e+03
C245_335	245	335	1.0746679484704248e-10
R245_347	245	347	3.9433321183502794e+03
C245_347	245	347	2.2453568584287067e-10
R245_348	245	348	1.3330692391098848e+04
C245_348	245	348	6.6419564394960501e-11
R245_350	245	350	9.4731337116712457e+03
C245_350	245	350	9.3466302561435592e-11
R246_334	246	334	2.5491865906564858e+03
C246_334	246	334	3.4733384560601360e-10
R246_332	246	332	6.9357495482335808e+03
C246_332	246	332	1.2766014336914764e-10
R246_335	246	335	6.2209891443642409e+03
C246_335	246	335	1.4232765258915852e-10
R246_348	246	348	4.6099214157475126e+03
C246_348	246	348	1.9206808573252583e-10
R246_350	246	350	1.0988540925442952e+04
C246_350	246	350	8.0576555860104640e-11
R247_248	247	248	3.4368183866520053e+03
C247_248	247	248	2.5762745716759723e-10
R247_249	247	249	3.9791219468334507e+03
C247_249	247	249	2.2251612127761213e-10
R247_258	247	258	2.7541148097788719e+03
C247_258	247	258	3.2148942322818064e-10
R247_259	247	259	2.7313391537734788e+03
C247_259	247	259	3.2417020803760337e-10
R247_297	247	297	4.4865701875615605e+03
C247_297	247	297	1.9734869726427326e-10
R247_314	247	314	3.0524572485008980e+03
C247_314	247	314	2.9006754546188678e-10
R247_356	247	356	4.7517023878911259e+03
C247_356	247	356	1.8633717127493788e-10
R248_249	248	249	3.2783199723411631e+03
C248_249	248	249	2.7008308803600137e-10
R248_284	248	284	2.4044154239546929e+03
C248_284	248	284	3.6824700626969705e-10
R248_290	248	290	3.5049151029168020e+03
C248_290	248	290	2.5262203382990698e-10
R248_292	248	292	2.8608986953892886e+03
C248_292	248	292	3.0948973590954753e-10
R248_297	248	297	5.2052316617915685e+03
C248_297	248	297	1.7010170521310691e-10
R248_298	248	298	2.4417236267303128e+03
C248_298	248	298	3.6262039323658229e-10
R248_315	248	315	2.9458568878985134e+03
C248_315	248	315	3.0056408555937401e-10
R248_355	248	355	2.3645450625302569e+03
C248_355	248	355	3.7445629424906347e-10
R248_356	248	356	2.3454897130009140e+03
C248_356	248	356	3.7749847155251833e-10
R249_252	249	252	1.9007763540056440e+03
C249_252	249	252	4.6581954780429209e-10
R249_259	249	259	3.1088029073339990e+03
C249_259	249	259	2.8481020125502400e-10
R249_279	249	279	2.3119177962417393e+03
C249_279	249	279	3.8298021804206856e-10
R249_284	249	284	1.4073809697763045e+03
C249_284	249	284	6.2912516277716370e-10
R249_315	249	315	1.1957188793646014e+03
C249_315	249	315	7.4049075997738433e-10
R249_317	249	317	2.1610780473358682e+03
C249_317	249	317	4.0971161721416117e-10
R249_322	249	322	2.7337318090935801e+03
C249_322	249	322	3.2388648321489054e-10
R249_356	249	356	3.6319639825118516e+03
C249_356	249	356	2.4378512175873727e-10
R250_266	250	266	4.1046784603775795e+03
C250_266	250	266	2.1570965673607293e-10
R250_271	250	271	1.8581872756073217e+03
C250_271	250	271	4.7649598795719546e-10
R250_272	250	272	4.2826636228807183e+03
C250_272	250	272	2.0674488114581981e-10
R250_330	250	330	2.5963235694732593e+03
C250_330	250	330	3.4102790272771483e-10
R250_331	250	331	4.6918087643824347e+03
C250_331	250	331	1.8871587188753305e-10
R250_351	250	351	2.3100962760401953e+03
C250_351	250	351	3.8328219948379072e-10
R250_346	250	346	4.0755333584906189e+03
C250_346	250	346	2.1725224745256820e-10
R250_361	250	361	5.7074892961144578e+03
C250_361	250	361	1.5513279758628281e-10
R251_252	251	252	2.4150154447088062e+03
C251_252	251	252	3.6663069117835836e-10
R251_253	251	253	4.2888458084261956e+03
C251_253	251	253	2.0644686735075397e-10
R251_255	251	255	7.9211621149233424e+03
C251_255	251	255	1.1177889921377639e-10
R251_320	251	320	3.7962385566821868e+03
C251_320	251	320	2.3323581183839848e-10
R251_322	251	322	2.4320238611956170e+03
C251_322	251	322	3.6406665075428815e-10
R251_321	251	321	2.2633865288804282e+03
C251_321	251	321	3.9119203476834676e-10
R251_325	251	325	4.4386673897774517e+03
C251_325	251	325	1.9947851549750692e-10
R251_362	251	362	2.5816991650921746e+03
C251_362	251	362	3.4295970408635425e-10
R252_255	252	255	1.8558650355922525e+03
C252_255	252	255	4.7709222638457714e-10
R252_259	252	259	2.5030856829131658e+03
C252_259	252	259	3.5373091210746067e-10
R252_260	252	260	1.5593773065577034e+03
C252_260	252	260	5.6780278767461731e-10
R252_317	252	317	3.0449358991139488e+03
C252_317	252	317	2.9078404637603364e-10
R252_322	252	322	2.2539804739532478e+03
C252_322	252	322	3.9282451287036561e-10
R252_321	252	321	3.2243080363416811e+03
C252_321	252	321	2.7460737985338452e-10
R252_362	252	362	2.0531875937981276e+03
C252_362	252	362	4.3124105384939114e-10
R252_363	252	363	2.2735949649627564e+03
C252_363	252	363	3.8943558344593022e-10
R253_254	253	254	4.1979013500884956e-06
C253_254	253	254	2.3201132605831904e-10
R253_255	253	255	6.9816331467935682e-06
C253_255	253	255	2.0291384820837008e-10
R253_257	253	257	5.9459099479427475e-06
C253_257	253	257	2.3825958700991687e-10
R253_320	253	320	2.3114338425903488e+03
C253_320	253	320	3.8306040405973290e-10
R253_362	253	362	2.4356913889736402e+03
C253_362	253	362	3.6351845956687507e-10
R253_364	253	364	4.4147362920167870e+03
C253_364	253	364	2.0055983486513385e-10
R254_257	254	257	6.9385970259506544e-06
C254_257	254	257	7.6564652301822918e-11
R254_277	254	277	6.9385970259506400e-06
C254_277	254	277	7.6564652301823073e-11
R254_278	254	278	2.7053671486868575e+03
C254_278	254	278	3.2728229960571830e-10
R254_320	254	320	4.9146977965077449e+03
C254_320	254	320	1.8015731960755665e-10
R254_364	254	364	4.1490457947342593e+03
C254_364	254	364	2.1340299083315129e-10
R255_256	255	256	5.4610447555085371e-06
C255_256	255	256	1.7834694687561544e-10
R255_257	255	257	5.7583925530555393e-06
C255_257	255	257	1.6913759350762440e-10
R255_260	255	260	3.6206527596247251e+03
C255_260	255	260	2.4454672692549846e-10
R255_362	255	362	2.5861145919528421e+03
C255_362	255	362	3.4237414863793696e-10
R255_365	255	365	7.0378671393475815e+03
C255_365	255	365	1.2580782844702571e-10
R256_257	256	257	2.1393896194550896e-05
C256_257	256	257	4.5525165217175847e-11
R256_260	256	260	4.7317258501745564e+03
C256_260	256	260	1.8712385496030720e-10
R256_261	256	261	7.9227865358225818e+03
C256_261	256	261	1.1175598101710962e-10
R256_365	256	365	7.5339768569236176e+03
C256_365	256	365	1.1752342733656169e-10
R257_362	257	362	4.2185212836963428e+03
C257_362	257	362	2.0988842349141369e-10
R257_364	257	364	4.9095155802584022e+03
C257_364	257	364	1.8034748382515529e-10
R257_365	257	365	6.5410422083133271e+03
C257_365	257	365	1.3536356340503023e-10
R258_259	258	259	4.3645215039054019e+03
C258_259	258	259	2.0286732025669288e-10
R258_260	258	260	6.1756611482741209e+03
C258_260	258	260	1.4337230629103465e-10
R258_261	258	261	2.7432530455745687e+03
C258_261	258	261	3.2276234346239504e-10
R258_269	258	269	2.7296308031196563e+03
C258_269	258	269	3.2437309129427596e-10
R258_270	258	270	1.0515870512385809e+03
C258_270	258	270	8.4198334380129104e-10
R258_313	258	313	2.8498273182119642e+03
C258_313	258	313	3.1069208160146649e-10
R258_314	258	314	1.6747856691742609e+03
C258_314	258	314	5.2867587655950533e-10
R258_367	258	367	4.6272883264435823e+03
C258_367	258	367	1.9134722525071411e-10
R259_260	259	260	1.7301755452493144e+03
C259_260	259	260	5.1175083599532277e-10
R259_314	259	314	2.6043658049184583e+03
C259_314	259	314	3.3997481460855002e-10
R259_317	259	317	2.6963611859896255e+03
C259_317	259	317	3.2837543660718116e-10
R259_356	259	356	5.1605440116116333e+03
C259_356	259	356	1.7157469826974393e-10
R259_363	259	363	2.1512726366840375e+03
C259_363	259	363	4.1157906561986528e-10
R259_366	259	366	1.7898633324640030e+03
C259_366	259	366	4.9468513357446931e-10
R259_367	259	367	4.6506856624592810e+03
C259_367	259	367	1.9038456820403358e-10
R260_261	260	261	4.2512662949478463e+03
C260_261	260	261	2.0827177604757931e-10
R260_362	260	362	8.2183845016445903e+03
C260_362	260	362	1.0773635396625918e-10
R260_363	260	363	4.8033689837517950e+03
C260_363	260	363	1.8433286817962111e-10
R260_365	260	365	3.6655203602266206e+03
C260_365	260	365	2.4155336614888129e-10
R260_367	260	367	9.6068268555047871e+03
C260_367	260	367	9.2165581311861391e-11
R261_270	261	270	1.6931725962933484e+04
C261_270	261	270	5.2293474607274954e-11
R261_365	261	365	1.7773870133796067e+04
C261_365	261	365	4.9815756221624661e-11
R261_367	261	367	1.2892267215463309e+04
C261_367	261	367	6.8678283416124568e-11
R262_263	262	263	2.5987498291306210e+03
C262_263	262	263	3.4070951030950368e-10
R262_264	262	264	3.8794759017039937e+03
C262_264	262	264	2.2823154573820013e-10
R262_265	262	265	5.7498171457645367e+03
C262_265	262	265	1.5399077209824360e-10
R262_266	262	266	7.0354695447308368e+03
C262_266	262	266	1.2585070208471419e-10
R262_267	262	267	6.6441120474934187e+03
C262_267	262	267	1.3326367396739440e-10
R262_298	262	298	4.0979313252440706e+03
C262_298	262	298	2.1606481695914344e-10
R262_369	262	369	3.5785928130746811e+03
C262_369	262	369	2.4742093553227138e-10
R263_264	263	264	2.0200353643351852e+03
C263_264	263	264	4.3831845587089539e-10
R263_267	263	267	1.5944294756373038e+03
C263_267	263	267	5.5532012875394977e-10
R263_330	263	330	3.8861324720250741e+03
C263_330	263	330	2.2784060710071623e-10
R263_336	263	336	3.2354363167147753e+03
C263_336	263	336	2.7366286801127462e-10
R263_339	263	339	2.4582064693350917e+03
C263_339	263	339	3.6018893967824133e-10
R263_369	263	369	3.6751904062837898e+03
C263_369	263	369	2.4091779848633781e-10
R264_290	264	290	1.6395260695609759e+03
C264_290	264	290	5.4004556447040392e-10
R264_293	264	293	2.2190223681448060e+03
C264_293	264	293	3.9901300428992365e-10
R264_298	264	298	1.2482346082280912e+03
C264_298	264	298	7.0933683128436902e-10
R264_336	264	336	2.9977574122061928e+03
C264_336	264	336	2.9536038443096634e-10
R264_355	264	355	4.4606688959105077e+03
C264_355	264	355	1.9849462095510886e-10
R264_358	264	358	2.9118489636752233e+03
C264_358	264	358	3.0407441895010200e-10
R264_369	264	369	2.9563689566431981e+03
C264_369	264	369	2.9949535889638975e-10
R265_266	265	266	2.3285910502086822e+03
C265_266	265	266	3.8023799053107711e-10
R265_268	265	268	1.7540715792449737e+03
C265_268	265	268	5.0477916190918576e-10
R265_274	265	274	3.1738981669536861e+03
C265_274	265	274	2.7896886891926558e-10
R265_297	265	297	1.3091716763882876e+03
C265_297	265	297	6.7631984228582822e-10
R265_298	265	298	4.7594895771913862e+03
C265_298	265	298	1.8603229765291196e-10
R265_369	265	369	2.7806618023649339e+03
C265_369	265	369	3.1842016204450221e-10
R265_370	265	370	2.4973949233217254e+03
C265_370	265	370	3.5453695105711413e-10
R265_371	265	371	4.7878556612087486e+03
C265_371	265	371	1.8493013247531065e-10
R266_267	266	267	1.0688231207524934e+03
C266_267	266	267	8.2840534089179372e-10
R266_271	266	271	2.7265008652448773e+03
C266_271	266	271	3.2474546147649116e-10
R266_274	266	274	2.5792203991517622e+03
C266_274	266	274	3.4328930633116544e-10
R266_330	266	330	2.8306112597686529e+03
C266_330	266	330	3.1280126461885332e-10
R266_351	266	351	4.9624713125817925e+03
C266_351	266	351	1.7842295218012032e-10
R266_359	266	359	3.2618530046084561e+03
C266_359	266	359	2.7144656134076259e-10
R266_369	266	369	3.9088551093382080e+03
C266_369	266	369	2.2651614268964464e-10
R266_371	266	371	1.5505571957332979e+03
C266_371	266	371	5.7103264822247516e-10
R266_372	266	372	3.3154903664413200e+03
C266_372	266	372	2.6705515137731012e-10
R267_330	267	330	1.2887869233985944e+03
C267_330	267	330	6.8701719859564306e-10
R267_339	267	339	3.3562709141593950e+03
C267_339	267	339	2.6381028359915937e-10
R267_336	267	336	6.7568522818913116e+03
C267_336	267	336	1.3104012708298578e-10
R267_369	267	369	1.1046745057702221e+03
C267_369	267	369	8.0152006502825134e-10
R267_371	267	371	3.9157854873931897e+03
C267_371	267	371	2.2611524164196229e-10
R267_372	267	372	1.0682625643417291e+03
C267_372	267	372	8.2884003545102349e-10
R267_373	267	373	4.4039490279920446e+03
C267_373	267	373	2.0105109665715220e-10
R268_269	268	269	2.0552290028480475e+03
C268_269	268	269	4.3081271258483856e-10
R268_274	268	274	3.4949332576066722e+03
C268_274	268	274	2.5334354519443221e-10
R268_276	268	276	3.2676973391727947e+03
C268_276	268	276	2.7096107435829432e-10
R268_297	268	297	4.6544687981462039e+03
C268_297	268	297	1.9022982430404249e-10
R268_313	268	313	2.2881797896947828e+03
C268_313	268	313	3.8695332669558493e-10
R268_370	268	370	6.9267009915883245e+03
C268_370	268	370	1.2782690963205117e-10
R268_376	268	376	3.8767208706595270e+03
C268_376	268	376	2.2839374080325993e-10
R268_378	268	378	3.1731227970047080e+03
C268_378	268	378	2.7903703649155882e-10
R269_270	269	270	2.8201796054836482e+03
C269_270	269	270	3.1395829541436411e-10
R269_276	269	276	3.2911929634508906e+03
C269_276	269	276	2.6902669990264512e-10
R269_313	269	313	2.4593458494030169e+03
C269_313	269	313	3.6002206924858777e-10
R269_378	269	378	3.2669524408551156e+03
C269_378	269	378	2.7102285623363531e-10
R270_313	270	313	1.1914625304057943e+03
C270_313	270	313	7.4313606941415083e-10
R270_314	270	314	4.8969724065260925e+03
C270_314	270	314	1.8080942839702772e-10
R270_367	270	367	2.8415737180947176e+03
C270_367	270	367	3.1159451400531522e-10
R270_377	270	377	6.6877717446934266e+03
C270_377	270	377	1.3239369038014149e-10
R270_378	270	378	6.7525905597555275e+03
C270_378	270	378	1.3112282965547612e-10
R271_272	271	272	4.6554813610470965e+03
C271_272	271	272	1.9018844949276185e-10
R271_273	271	273	1.2710124164341256e+04
C271_273	271	273	6.9662480889374531e-11
R271_274	271	274	5.1494956555001709e+03
C271_274	271	274	1.7194281555598268e-10
R271_275	271	275	1.0584216002180343e+04
C271_275	271	275	8.3654640222535541e-11
R271_351	271	351	1.4770317664195085e+04
C271_351	271	351	5.9945818487462524e-11
R271_359	271	359	4.0282265354789956e+03
C271_359	271	359	2.1980362174311411e-10
R271_361	271	361	7.2398529941029110e+03
C271_361	271	361	1.2229789505687501e-10
R271_380	271	380	8.0720223560943659e+03
C271_380	271	380	1.0968983268876976e-10
R272_273	272	273	1.6504006671363073e+04
C272_273	272	273	5.3648716904382645e-11
R272_361	272	361	4.0774064409218922e+03
C272_361	272	361	2.1715244593075412e-10
R272_346	272	346	2.3981059026648651e+04
C272_346	272	346	3.6921588021450163e-11
R272_368	272	368	2.1848079382237458e+04
C272_368	272	368	4.0526160959477645e-11
R272_360	272	360	1.5262259119356861e+04
C272_360	272	360	5.8013612190415419e-11
R272_380	272	380	1.6804582606668500e+04
C272_380	272	380	5.2689126675996270e-11
R273_275	273	275	1.0613106631174507e+04
C273_275	273	275	8.3426918476368359e-11
R273_360	273	360	3.4700222752151218e+04
C273_360	273	360	2.5516227605343228e-11
R273_380	273	380	9.9508503765761907e+03
C273_380	273	380	8.8979207624730446e-11
R274_275	274	275	4.3427762871654140e+03
C274_275	274	275	2.0388312064721254e-10
R274_276	274	276	5.0234004838891406e+03
C274_276	274	276	1.7625884787400119e-10
R274_359	274	359	1.5620119876560868e+03
C274_359	274	359	5.6684506181584133e-10
R274_370	274	370	1.8061905586577830e+03
C274_370	274	370	4.9021338166996771e-10
R274_371	274	371	3.8334366702722164e+03
C274_371	274	371	2.3097258618260295e-10
R274_376	274	376	4.4592177776021790e+03
C274_376	274	376	1.9855921505948727e-10
R274_378	274	378	7.7240970378901329e+03
C274_378	274	378	1.1463071700894316e-10
R274_379	274	379	5.1109813957250071e+03
C274_379	274	379	1.7323850609994267e-10
R274_380	274	380	6.7092041695117359e+03
C274_380	274	380	1.3197076126011481e-10
R274_381	274	381	1.9793152984318979e+03
C274_381	274	381	4.4733589560059893e-10
R275_276	275	276	8.2369392997049090e+03
C275_276	275	276	1.0749366354219954e-10
R275_380	275	380	1.1047794781281997e+04
C275_380	275	380	8.0144390733990013e-11
R275_381	275	381	1.5650970211735328e+04
C275_381	275	381	5.6572772787983472e-11
R276_378	276	378	6.8155712795518111e+03
C276_378	276	378	1.2991116157151024e-10
R276_381	276	381	1.1290948522548248e+04
C276_381	276	381	7.8418458815200634e-11
R277_278	277	278	7.4747511703407181e+03
C277_278	277	278	1.1845461628385426e-10
R277_329	277	329	8.7743215612576569e+03
C277_329	277	329	1.0091022713476777e-10
R277_385	277	385	2.4813595400405349e+04
C277_385	277	385	3.5682808855887772e-11
R278_320	278	320	3.5205203094876306e+03
C278_320	278	320	2.5150225076499054e-10
R278_326	278	326	9.4206038130608595e+03
C278_326	278	326	9.3987476733969320e-11
R278_329	278	329	5.2554144705611825e+03
C278_329	278	329	1.6847744105812713e-10
R278_364	278	364	4.8257634208280515e+03
C278_364	278	364	1.8347745309654477e-10
R278_384	278	384	1.7216709226613359e+03
C278_384	278	384	5.1427875678549039e-10
R278_385	278	385	4.5476946501934772e+03
C278_385	278	385	1.9469618120960056e-10
R278_386	278	386	7.5135333375971468e+03
C278_386	278	386	1.1784319599268060e-10
R279_281	279	281	2.3277844227727237e+03
C279_281	279	281	3.8036975118397776e-10
R279_282	279	282	6.2765334934166603e+03
C279_282	279	282	1.4106812026554140e-10
R279_283	279	283	3.6070530981972192e+03
C279_283	279	283	2.4546874071316731e-10
R279_284	279	284	2.4991038661667853e+03
C279_284	279	284	3.5429451079921990e-10
R279_315	279	315	3.4604665694540090e+03
C279_315	279	315	2.5586687919938535e-10
R279_319	279	319	1.6365476636165538e+03
C279_319	279	319	5.4102841083365815e-10
R279_322	279	322	2.9624828415791731e+03
C279_322	279	322	2.9887726918547188e-10
R279_387	279	387	3.0963465586002731e+03
C279_387	279	387	2.8595596937968744e-10
R280_281	280	281	1.3188050888206171e+03
C280_281	280	281	6.7137956109330262e-10
R280_282	280	282	1.4778844144149998e+03
C280_282	280	282	5.9911233453969454e-10
R280_285	280	285	2.7390933969189759e+03
C280_285	280	285	3.2325249759498836e-10
R280_283	280	283	7.0616693416619391e+03
C280_283	280	283	1.2538377809284682e-10
R280_289	280	289	3.0492051178106954e+03
C280_289	280	289	2.9037691709494558e-10
R280_387	280	387	4.7650281770239699e+03
C280_387	280	387	1.8581606420908809e-10
R281_282	281	282	2.7979123022463154e+03
C281_282	281	282	3.1645694576957896e-10
R281_283	281	283	9.8221435818714838e+02
C281_283	281	283	9.0145167836295752e-10
R281_285	281	285	3.0401159811072903e+03
C281_285	281	285	2.9124506670219449e-10
R281_387	281	387	3.8205377358035016e+03
C281_387	281	387	2.3175239794190561e-10
R282_284	282	284	1.9437211913999372e+03
C282_284	282	284	4.5552766807172080e-10
R282_289	282	289	3.7284713115917525e+03
C282_289	282	289	2.3747501528233532e-10
R282_291	282	291	4.0152456581792521e+03
C282_291	282	291	2.2051422430315286e-10
R282_292	282	292	1.2976671038771858e+03
C282_292	282	292	6.8231581046828962e-10
R282_294	282	294	2.4584644776557598e+03
C282_294	282	294	3.6015113895169266e-10
R282_387	282	387	1.8594281163003482e+03
C282_387	282	387	4.7617801082931508e-10
R283_285	283	285	1.6751945342864517e+03
C283_285	283	285	5.2854684251769230e-10
R283_299	283	299	5.3841125816862886e+03
C283_299	283	299	1.6445027258748173e-10
R283_318	283	318	2.4629866637506689e+03
C283_318	283	318	3.5948988061172555e-10
R283_319	283	319	2.0474985555882688e+03
C283_319	283	319	4.3243927048613215e-10
R283_323	283	323	4.9938240908003636e+03
C283_323	283	323	1.7730275748621605e-10
R283_387	283	387	2.5415139556783615e+03
C283_387	283	387	3.4838241974700109e-10
R284_292	284	292	2.1362687583811776e+03
C284_292	284	292	4.1446975162944989e-10
R284_315	284	315	1.6670857389305399e+03
C284_315	284	315	5.3111772299606451e-10
R284_387	284	387	5.5088906575015271e+03
C284_387	284	387	1.6072542309299860e-10
R285_286	285	286	1.9622995163285796e+03
C285_286	285	286	4.5121490085091588e-10
R285_289	285	289	3.8260946693416859e+03
C285_289	285	289	2.3141580599006570e-10
R285_299	285	299	6.3276978286785306e+03
C285_299	285	299	1.3992747531133452e-10
R285_316	285	316	4.5376948904343180e+03
C285_316	285	316	1.9512523496599693e-10
R285_318	285	318	4.3621726705845240e+03
C285_318	285	318	2.0297655516267206e-10
R285_387	285	387	5.4929192183383975e+03
C285_387	285	387	1.6119275498244780e-10
R285_388	285	388	3.4793044985663305e+03
C285_388	285	388	2.5448154424680060e-10
R286_288	286	288	5.3642075119059737e+03
C286_288	286	288	1.6506050143190661e-10
R286_289	286	289	4.0255736896395615e+03
C286_289	286	289	2.1994847193550643e-10
R286_303	286	303	6.1405295462002541e+03
C286_303	286	303	1.4419257737272761e-10
R286_306	286	306	2.1982057686949011e+03
C286_306	286	306	4.0279158316724967e-10
R286_307	286	307	9.7453819208111963e+02
C286_307	286	307	9.0855216234183128e-10
R286_316	286	316	2.7621779157726760e+03
C286_316	286	316	3.2055095967716405e-10
R286_388	286	388	3.8301071076829844e+03
C286_388	286	388	2.3117337369597285e-10
R287_295	287	295	3.9313778356353009e+03
C287_295	287	295	2.2521843962039801e-10
R287_296	287	296	5.6487864621621711e+03
C287_296	287	296	1.5674495533348424e-10
R287_300	287	300	1.7572457820340896e+03
C287_300	287	300	5.0386735353269052e-10
R287_302	287	302	6.3711441325664382e+03
C287_302	287	302	1.3897327752705130e-10
R287_337	287	337	1.9981197905464051e+03
C287_337	287	337	4.4312597567429810e-10
R287_341	287	341	2.7649018748564145e+03
C287_341	287	341	3.2023515545049171e-10
R287_343	287	343	3.6146865475027839e+03
C287_343	287	343	2.4495036293304438e-10
R287_345	287	345	2.4554382616322341e+03
C287_345	287	345	3.6059500885655523e-10
R287_353	287	353	5.3122715444921323e+03
C287_353	287	353	1.6667423234755753e-10
R287_390	287	390	2.5498453775067114e+03
C287_390	287	390	3.4724410723515308e-10
R288_289	288	289	2.2758687532184940e+03
C288_289	288	289	3.8904650386708646e-10
R288_294	288	294	5.2112726128215663e+03
C288_294	288	294	1.6990452188618151e-10
R288_296	288	296	4.6597479217647451e+03
C288_296	288	296	1.9001430904972071e-10
R288_303	288	303	4.3644537079090442e+03
C288_303	288	303	2.0287047153129119e-10
R288_307	288	307	8.4158824574096288e+03
C288_307	288	307	1.0520807368458994e-10
R288_310	288	310	5.3374878233394766e+03
C288_310	288	310	1.6588680124538906e-10
R288_311	288	311	5.5688955971626165e+03
C288_311	288	311	1.5899360407315334e-10
R288_312	288	312	4.0030340231684331e+03
C288_312	288	312	2.2118692386211199e-10
R288_391	288	391	5.7061491776057082e+03
C288_391	288	391	1.5516923132239604e-10
R289_294	289	294	1.0373921369576126e+03
C289_294	289	294	8.5350442726189474e-10
R289_307	289	307	6.0961674387462954e+03
C289_307	289	307	1.4524187378325856e-10
R289_312	289	312	2.7278105591829708e+03
C289_312	289	312	3.2458954259829505e-10
R289_387	289	387	1.1950719040980523e+03
C289_387	289	387	7.4089163895811399e-10
R289_388	289	388	1.6626781187513282e+03
C289_388	289	388	5.3252567151418933e-10
R289_391	289	391	1.4705323298994970e+03
C289_391	289	391	6.0210766108115000e-10
R290_291	290	291	2.0302333171818789e+03
C290_291	290	291	4.3611676264333504e-10
R290_292	290	292	2.0748495484085661e+03
C290_292	290	292	4.2673878806254971e-10
R290_293	290	293	1.7591251552746444e+03
C290_293	290	293	5.0332904344248523e-10
R290_298	290	298	5.2586217944188165e+03
C290_298	290	298	1.6837468376975316e-10
R290_355	290	355	3.1792016270375475e+03
C290_355	290	355	2.7850350042914818e-10
R290_393	290	393	7.4076814269794622e+03
C290_393	290	393	1.1952711390573882e-10
R291_292	291	292	1.1192111848431493e+03
C291_292	291	292	7.9110966159982242e-10
R291_293	291	293	4.3219868750713813e+03
C291_293	291	293	2.0486382936676011e-10
R291_294	291	294	1.3360668082778270e+03
C291_294	291	294	6.6270546967729375e-10
R291_295	291	295	2.3986172175139950e+03
C291_295	291	295	3.6913717421643337e-10
R291_393	291	393	4.1569519006912769e+03
C291_393	291	393	2.1299711972918430e-10
R292_294	292	294	3.6191732022350720e+03
C292_294	292	294	2.4464670028867286e-10
R292_315	292	315	5.6660660978728411e+03
C292_315	292	315	1.5626693483727707e-10
R292_355	292	355	5.4688813385050607e+03
C292_355	292	355	1.6190126040328980e-10
R292_387	292	387	6.8125811322252994e+03
C292_387	292	387	1.2996818159151698e-10
R292_389	292	389	5.1173317783382472e+03
C292_389	292	389	1.7302352476890262e-10
R292_393	292	393	6.9797254441389459e+03
C292_393	292	393	1.2685581815306343e-10
R293_295	293	295	1.2698676552281079e+03
C293_295	293	295	6.9725280272687245e-10
R293_336	293	336	2.6862844213352273e+03
C293_336	293	336	3.2960723543186815e-10
R293_337	293	337	1.7992439987631933e+03
C293_337	293	337	4.9210600802817190e-10
R293_355	293	355	5.0946239207878943e+03
C293_355	293	355	1.7379472861326891e-10
R293_357	293	357	1.2967985109147687e+03
C293_357	293	357	6.8277282418794633e-10
R293_358	293	358	3.1407451445190586e+03
C293_358	293	358	2.8191360360618618e-10
R293_390	293	390	5.6690093497763219e+03
C293_390	293	390	1.5618580373922566e-10
R293_393	293	393	2.1253540936973009e+03
C293_393	293	393	4.1659824324129969e-10
R294_295	294	295	5.6669165474267065e+03
C294_295	294	295	1.5624348343404852e-10
R294_296	294	296	3.9230237962804458e+03
C294_296	294	296	2.2569804000156623e-10
R294_387	294	387	5.1538234346161380e+03
C294_387	294	387	1.7179843138455270e-10
R294_389	294	389	8.8699960272617045e+03
C294_389	294	389	9.9821778834927149e-11
R294_391	294	391	3.2384428603293550e+03
C294_391	294	391	2.7340880166400452e-10
R294_393	294	393	3.8682617590802693e+03
C294_393	294	393	2.2889319204461497e-10
R295_296	295	296	1.2307417045323239e+03
C295_296	295	296	7.1941884998238108e-10
R295_337	295	337	4.8716248394381628e+03
C295_337	295	337	1.8175019852352058e-10
R295_357	295	357	4.9749297693359649e+03
C295_357	295	357	1.7797613690096025e-10
R295_390	295	390	1.8537482426778597e+03
C295_390	295	390	4.7763701743067070e-10
R295_393	295	393	1.2527477060157705e+03
C295_393	295	393	7.0678140334894674e-10
R296_300	296	300	8.5301066564928158e+02
C296_300	296	300	1.0379926270043187e-09
R296_310	296	310	4.5785078147235913e+02
C296_310	296	310	1.9338588411985793e-09
R296_390	296	390	1.6234024328789735e+03
C296_390	296	390	5.4540929825378002e-10
R296_391	296	391	1.7334828605642494e+03
C296_391	296	391	5.1077446558184952e-10
R296_393	296	393	1.4887459291159300e+03
C296_393	296	393	5.9474136209782497e-10
R297_298	297	298	1.6018279486016672e+03
C297_298	297	298	5.5275523346495217e-10
R297_313	297	313	5.3623753004018627e+03
C297_313	297	313	1.6511689915356088e-10
R297_314	297	314	3.2820476941259781e+03
C297_314	297	314	2.6977632996762122e-10
R297_356	297	356	2.1506354102163091e+03
C297_356	297	356	4.1170101519482808e-10
R297_369	297	369	5.9588406193996298e+03
C297_369	297	369	1.4858910285625471e-10
R297_370	297	370	4.7928613454711367e+03
C297_370	297	370	1.8473699067815690e-10
R297_376	297	376	6.3068921380887477e+03
C297_376	297	376	1.4038907948857341e-10
R297_396	297	396	1.1278009724814347e+03
C297_396	297	396	7.8508425094887506e-10
R298_355	298	355	1.3513536632558939e+03
C298_355	298	355	6.5520877752068979e-10
R298_356	298	356	3.5377407028825241e+03
C298_356	298	356	2.5027803224203728e-10
R298_358	298	358	3.1589715303745656e+03
C298_358	298	358	2.8028704063534690e-10
R298_369	298	369	1.6145873921670675e+03
C298_369	298	369	5.4838702816303329e-10
R298_396	298	396	2.8031727204414528e+03
C298_396	298	396	3.1586308444117619e-10
R299_305	299	305	3.5995121990958037e+03
C299_305	299	305	2.4598299234057795e-10
R299_316	299	316	1.3203768167005201e+03
C299_316	299	316	6.7058037561774726e-10
R299_318	299	318	1.1033498342906519e+03
C299_318	299	318	8.0248236251310030e-10
R299_323	299	323	1.2708308440015142e+03
C299_323	299	323	6.9672434052044875e-10
R299_324	299	324	3.8163808166498798e+03
C299_324	299	324	2.3200482976886044e-10
R299_397	299	397	1.9778927800052409e+03
C299_397	299	397	4.4765762363400402e-10
R299_398	299	398	1.7689634421421479e+03
C299_398	299	398	5.0052972300421950e-10
R300_301	300	301	1.8318979257090402e+03
C300_301	300	301	4.8333412537562468e-10
R300_302	300	302	1.6132495701931339e+03
C300_302	300	302	5.4884178992466747e-10
R300_310	300	310	1.4714510871383436e+03
C300_310	300	310	6.0173171194018378e-10
R300_345	300	345	3.2235130067837558e+03
C300_345	300	345	2.7467510751055493e-10
R300_390	300	390	2.1893774826893391e+03
C300_390	300	390	4.0441577055610759e-10
R300_399	300	399	1.2359661578778209e+03
C300_399	300	399	7.1637785230323964e-10
R301_302	301	302	2.2895518659671216e+03
C301_302	301	302	3.8672143438252856e-10
R301_303	301	303	5.0098763501747599e+03
C301_303	301	303	1.7673465766657374e-10
R301_310	301	310	1.9503593248656807e+03
C301_310	301	310	4.5397725968314988e-10
R301_311	301	311	1.9311130506824500e+03
C301_311	301	311	4.5850178547915441e-10
R301_399	301	399	1.8007122994061981e+03
C301_399	301	399	4.9170474483457206e-10
R301_400	301	400	1.8755818793635028e+03
C301_400	301	400	4.7207684795956527e-10
R301_401	301	401	3.4108314606359113e+03
C301_401	301	401	2.5959030574173362e-10
R301_403	301	403	3.0975046335551865e+03
C301_403	301	403	2.8584905801537203e-10
R302_343	302	343	2.9726298654799430e+03
C302_343	302	343	2.9785705646775699e-10
R302_345	302	345	1.8164061312724798e+03
C302_345	302	345	4.8745639340014869e-10
R302_399	302	399	1.3607135676139533e+03
C302_399	302	399	6.5070181026606868e-10
R302_402	302	402	2.5376174895009931e+03
C302_402	302	402	3.4891735470900786e-10
R302_403	302	403	3.4694516983137596e+03
C302_403	302	403	2.5520423937025435e-10
R303_304	303	304	4.6411884492839554e+03
C303_304	303	304	1.9077415006421531e-10
R303_307	303	307	1.9700052775458073e+03
C303_307	303	307	4.4944995416613131e-10
R303_311	303	311	1.6408826755875223e+03
C303_311	303	311	5.3959907973491985e-10
R303_401	303	401	8.1629539863883647e+03
C303_401	303	401	1.0846793736390356e-10
R303_404	303	404	5.3774382095510682e+03
C303_404	303	404	1.6465438508012510e-10
R304_306	304	306	3.1403117726063415e+03
C304_306	304	306	2.8195250848139055e-10
R304_307	304	307	3.0678401043696326e+03
C304_307	304	307	2.8861308007508832e-10
R304_308	304	308	3.8814701578247209e+03
C304_308	304	308	2.2811428291289822e-10
R304_309	304	309	5.0590120634047798e+03
C304_309	304	309	1.7501812025806911e-10
R304_404	304	404	5.7920829951430633e+03
C304_404	304	404	1.5286707432239242e-10
R304_405	304	405	3.9743546965668006e+03
C304_405	304	405	2.2278303002619736e-10
R305_306	305	306	5.6578577640580215e+03
C305_306	305	306	1.5649364452473361e-10
R305_308	305	308	1.2592157434031282e+04
C305_308	305	308	7.0315097816922710e-11
R305_316	305	316	4.7773447958854931e+03
C305_316	305	316	1.8533700612578152e-10
R305_324	305	324	7.8255902221911501e+03
C305_324	305	324	1.1314402576168684e-10
R305_397	305	397	7.2683238855109121e+03
C305_397	305	397	1.2181883961789925e-10
R305_407	305	407	9.4032352186274529e+03
C305_407	305	407	9.4161079789434471e-11
R306_307	306	307	7.5608537603959178e+02
C306_307	306	307	1.1710566157724967e-09
R306_308	306	308	1.3726638486416853e+03
C306_308	306	308	6.4503686213938183e-10
R306_316	306	316	9.0309183897018465e+02
C306_316	306	316	9.8043049830863531e-10
R306_405	306	405	1.0593765362662109e+03
C306_405	306	405	8.3579232821284889e-10
R306_406	306	406	2.6324150432735810e+03
C306_406	306	406	3.3635227239809561e-10
R306_407	306	407	2.9881517054472201e+03
C306_407	306	407	2.9630984935802796e-10
R307_311	307	311	2.3302498458927698e+03
C307_311	307	311	3.7996731692123628e-10
R307_312	307	312	1.9293656650287730e+03
C307_312	307	312	4.5891704084347106e-10
R307_316	307	316	2.5211050794616062e+03
C307_316	307	316	3.5120264875634833e-10
R307_388	307	388	1.4801368809432415e+03
C307_388	307	388	5.9820060772740987e-10
R307_404	307	404	2.7886485738301321e+03
C307_404	307	404	3.1750819734302403e-10
R307_405	307	405	1.1241575121193289e+03
C307_405	307	405	7.8762875500494203e-10
R307_406	307	406	2.1404982722983809e+03
C307_406	307	406	4.1365078082930344e-10
R307_408	307	408	1.6574633474637719e+03
C307_408	307	408	5.3420112309261997e-10
R308_309	308	309	2.9228120217426895e+03
C308_309	308	309	3.0293387844083121e-10
R308_405	308	405	1.7986656003914429e+03
C308_405	308	405	4.9226425496062573e-10
R308_407	308	407	4.1813927432313258e+03
C308_407	308	407	2.1175212090117133e-10
R308_410	308	410	5.7570595573849523e+03
C308_410	308	410	1.5379705088584958e-10
R309_405	309	405	3.8765153583606111e+03
C309_405	309	405	2.2840584902891913e-10
R309_404	309	404	4.5651171053724966e+03
C309_404	309	404	1.9395313663651420e-10
R309_410	309	410	4.7451239615396680e+03
C309_410	309	410	1.8659550074487515e-10
R309_411	309	411	1.4511652272336572e+04
C309_411	309	411	6.1014332832923906e-11
R310_311	310	311	1.3912283817854920e+03
C310_311	310	311	6.3642949877406941e-10
R310_312	310	312	2.1422283108827037e+03
C310_312	310	312	4.1331672128596036e-10
R310_390	310	390	3.2757013096093374e+03
C310_390	310	390	2.7029899798940944e-10
R310_391	310	391	1.4560176585639047e+03
C310_391	310	391	6.0810991988469716e-10
R310_393	310	393	4.5535655968205419e+03
C310_393	310	393	1.9444515794792339e-10
R310_399	310	399	1.5114856973218332e+03
C310_399	310	399	5.8579368846748165e-10
R310_400	310	400	1.9168298249657421e+03
C310_400	310	400	4.6191830394533044e-10
R310_413	310	413	9.8706705653060988e+02
C310_413	310	413	8.9701988921817763e-10
R310_414	310	414	1.6759834572376903e+03
C310_414	310	414	5.2829804368076707e-10
R311_312	311	312	1.4680392405596615e+03
C311_312	311	312	6.0313018701220231e-10
R311_400	311	400	2.2447209167774149e+03
C311_400	311	400	3.9444492857986673e-10
R311_401	311	401	2.2223376192191658e+03
C311_401	311	401	3.9841776246900706e-10
R311_404	311	404	5.3057868884110276e+03
C311_404	311	404	1.6687793918635219e-10
R311_408	311	408	2.2277680052140995e+03
C311_408	311	408	3.9744658313957024e-10
R311_409	311	409	2.7659949777827060e+03
C311_409	311	409	3.2010860063447231e-10
R311_414	311	414	1.9607599674655667e+03
C311_414	311	414	4.5156918561759105e-10
R312_388	312	388	1.7591433241566385e+03
C312_388	312	388	5.0332384493144362e-10
R312_391	312	391	1.0703249051488058e+03
C312_391	312	391	8.2724299644032073e-10
R312_408	312	408	2.0747145378868672e+03
C312_408	312	408	4.2676655777513111e-10
R312_412	312	412	2.7644029661374511e+03
C312_412	312	412	3.2029295024854756e-10
R312_414	312	414	1.9555025376940205e+03
C312_414	312	414	4.5278324350532883e-10
R313_314	313	314	1.3912610231762862e+03
C313_314	313	314	6.3641456703686375e-10
R313_367	313	367	7.5064080071845929e+03
C313_367	313	367	1.1795505664660661e-10
R313_376	313	376	2.0490657159218686e+03
C313_376	313	376	4.3210853357216654e-10
R313_377	313	377	2.4432511722246204e+03
C313_377	313	377	3.6239367927686773e-10
R313_378	313	378	1.9477654324468128e+03
C313_378	313	378	4.5458183359775681e-10
R313_396	313	396	9.4003179802941831e+03
C313_396	313	396	9.4190301174502487e-11
R313_416	313	416	5.5668021640895940e+03
C313_416	313	416	1.5905339467812814e-10
R314_356	314	356	2.6564366391669396e+03
C314_356	314	356	3.3331070978514590e-10
R314_366	314	366	4.1371300639800720e+03
C314_366	314	366	2.1401763251508571e-10
R314_367	314	367	3.4767262137420189e+03
C314_367	314	367	2.5467026370966933e-10
R314_396	314	396	4.6947668398952301e+03
C314_396	314	396	1.8859696591870778e-10
R314_416	314	416	2.1287650913198581e+03
C314_416	314	416	4.1593071274530842e-10
R315_322	315	322	4.2836428580445290e+03
C315_322	315	322	2.0669761953595523e-10
R315_317	315	317	2.6519919776189745e+03
C315_317	315	317	3.3386932885632304e-10
R315_319	315	319	4.5130896989107059e+03
C315_319	315	319	1.9618905024504779e-10
R315_355	315	355	3.1297294143100899e+03
C315_355	315	355	2.8290585686148834e-10
R315_356	315	356	3.0344093642132343e+03
C315_356	315	356	2.9179279241038477e-10
R315_387	315	387	2.5942998513066291e+03
C315_387	315	387	3.4129392608724674e-10
R315_389	315	389	1.7461403877232590e+03
C315_389	315	389	5.0707193300446557e-10
R315_392	315	392	2.4368128310024581e+03
C315_392	315	392	3.6335116527425521e-10
R315_417	315	417	3.2399908059198642e+03
C315_417	315	417	2.7327817723501875e-10
R316_318	316	318	2.9204709829431627e+03
C316_318	316	318	3.0317670912371190e-10
R316_388	316	388	2.5327267883633481e+03
C316_388	316	388	3.4959111490748640e-10
R316_397	316	397	7.1283555133542222e+03
C316_397	316	397	1.2421080570985290e-10
R316_398	316	398	2.3154972090770393e+03
C316_398	316	398	3.8238818782810341e-10
R316_406	316	406	2.7120913641926777e+03
C316_406	316	406	3.2647085322789902e-10
R316_407	316	407	3.8461885355669897e+03
C316_407	316	407	2.3020680694985104e-10
R316_418	316	418	5.7550894733742471e+03
C316_418	316	418	1.5384969873993514e-10
R317_322	317	322	1.9227629627216220e+03
C317_322	317	322	4.6049294627909421e-10
R317_321	317	321	2.8242371853391073e+03
C317_321	317	321	3.1350723172129306e-10
R317_356	317	356	3.9167509259025933e+03
C317_356	317	356	2.2605950657839193e-10
R317_363	317	363	3.0360774873579662e+03
C317_363	317	363	2.9163247163052575e-10
R317_366	317	366	2.1566749164537523e+03
C317_366	317	366	4.1054809649101186e-10
R317_383	317	383	3.5789911281601367e+03
C317_383	317	383	2.4739339942291782e-10
R317_392	317	392	2.3623234605505427e+03
C317_392	317	392	3.7480844451913114e-10
R317_417	317	417	2.7493383800000483e+03
C317_417	317	417	3.2204794729559059e-10
R317_420	317	420	2.6948891165180657e+03
C317_420	317	420	3.2855481001905053e-10
R318_323	318	323	3.2373899328912262e+03
C318_323	318	323	2.7349772503593855e-10
R318_319	318	319	2.8884457405701178e+03
C318_319	318	319	3.0653813892492829e-10
R318_387	318	387	5.1433932350240430e+03
C318_387	318	387	1.7214681849925895e-10
R318_388	318	388	3.2373899328912285e+03
C318_388	318	388	2.7349772503593840e-10
R318_398	318	398	3.0221543582169179e+03
C318_398	318	398	2.9297602860444250e-10
R318_418	318	418	3.1135170392701311e+03
C318_418	318	418	2.8437897417370787e-10
R318_419	318	419	2.9475130479866561e+03
C318_419	318	419	3.0039520344271215e-10
R318_422	318	422	4.4453259262387937e+03
C318_422	318	422	1.9917972189030379e-10
R319_322	319	322	3.7250807357807284e+03
C319_322	319	322	2.3769116550823637e-10
R319_323	319	323	2.3705621800457675e+03
C319_323	319	323	3.7350582454787409e-10
R319_387	319	387	1.7398249940170660e+03
C319_387	319	387	5.0891255427689025e-10
R319_392	319	392	1.5768496451465071e+03
C319_392	319	392	5.6151122868644521e-10
R319_419	319	419	3.5190413995644703e+03
C319_419	319	419	2.5160794692826939e-10
R319_422	319	422	5.9753289511240046e+03
C319_422	319	422	1.4817908586161535e-10
R320_325	320	325	1.6790061692684164e+03
C320_325	320	325	5.2734694958613425e-10
R320_321	320	321	2.2253559137836319e+03
C320_321	320	321	3.9787738051958553e-10
R320_326	320	326	3.4093590455559338e+03
C320_326	320	326	2.5970241616357025e-10
R320_362	320	362	2.4545600870303679e+03
C320_362	320	362	3.6072401990827512e-10
R320_364	320	364	1.6790061692684278e+03
C320_364	320	364	5.2734694958613063e-10
R320_384	320	384	1.2459361162229764e+03
C320_384	320	384	7.1064540964116558e-10
R320_423	320	423	3.6648540123050952e+03
C320_423	320	423	2.4159728565643335e-10
R320_424	320	424	4.3026144612766875e+03
C320_424	320	424	2.0578622362489700e-10
R321_322	321	322	1.5900884893430293e+03
C321_322	321	322	5.5683616832282411e-10
R321_325	321	325	2.9073229745761505e+03
C321_325	321	325	3.0454778827215875e-10
R321_362	321	362	1.9531559335397758e+03
C321_362	321	362	4.5332723644615693e-10
R321_363	321	363	1.5872404739017418e+03
C321_363	321	363	5.5783530993477692e-10
R321_383	321	383	1.5725546514056177e+03
C321_383	321	383	5.6304483975076749e-10
R321_392	321	392	4.8160800703755795e+03
C321_392	321	392	1.8384635819207867e-10
R321_420	321	420	3.2681362444521669e+03
C321_420	321	420	2.7092468473523558e-10
R321_421	321	421	8.6540494663244699e+03
C321_421	321	421	1.0231265549676287e-10
R321_423	321	423	2.0345379821012868e+03
C321_423	321	423	4.3519402905692263e-10
R321_424	321	424	5.5092209083105663e+03
C321_424	321	424	1.6071578839112459e-10
R321_425	321	425	1.9626516133232228e+03
C321_425	321	425	4.5113395351953547e-10
R322_323	322	323	4.3093625304851021e+03
C322_323	322	323	2.0546398114254940e-10
R322_325	322	325	4.2400538742315102e+03
C322_325	322	325	2.0882253102514604e-10
R322_392	322	392	1.6247962356379003e+03
C322_392	322	392	5.4494142851850085e-10
R322_425	322	425	5.9206367534572391e+03
C322_425	322	425	1.4954789806737885e-10
R323_324	323	324	5.0183814448251396e+03
C323_324	323	324	1.7643512981920244e-10
R323_325	323	325	4.5656127920371373e+03
C323_325	323	325	1.9393207922587189e-10
R323_328	323	328	1.3685946475792132e+03
C323_328	323	328	6.4695473072771370e-10
R323_392	323	392	6.2729768060314091e+03
C323_392	323	392	1.4114810385536229e-10
R323_397	323	397	4.8304348739952193e+03
C323_397	323	397	1.8330001434584633e-10
R323_398	323	398	3.8001935308659617e+03
C323_398	323	398	2.3299307640741052e-10
R323_422	323	422	2.1330640191179477e+03
C323_422	323	422	4.1509245562453081e-10
R323_425	323	425	3.9196896687076983e+03
C323_425	323	425	2.2589002103115936e-10
R323_426	323	426	4.1482887949192018e+03
C323_426	323	426	2.1344193364368836e-10
R324_327	324	327	9.9483032156333957e+03
C324_327	324	327	8.9001989837683733e-11
R324_328	324	328	2.2531496067379549e+03
C324_328	324	328	3.9296937009961077e-10
R324_397	324	397	2.8144854662444855e+03
C324_397	324	397	3.1459348158633776e-10
R324_426	324	426	8.6957293802640088e+03
C324_426	324	426	1.0182225584314562e-10
R325_326	325	326	1.2894801381914262e+03
C325_326	325	326	6.8664786333340012e-10
R325_327	325	327	3.7239106664890655e+03
C325_327	325	327	2.3776584912945307e-10
R325_328	325	328	2.1080351006624774e+03
C325_328	325	328	4.2002089121843652e-10
R325_384	325	384	4.2343462969395887e+03
C325_384	325	384	2.0910400794095282e-10
R325_424	325	424	3.0050079251931716e+03
C325_424	325	424	2.9464773595999175e-10
R325_425	325	425	2.1605800732259418e+03
C325_425	325	425	4.0980604823314411e-10
R325_428	325	428	3.2685175803228067e+03
C325_428	325	428	2.7089307612430040e-10
R326_327	326	327	9.8609891072652715e+02
C326_327	326	327	8.9790057779056964e-10
R326_329	326	329	8.7557601684919234e+02
C326_329	326	329	1.0112414737971323e-09
R326_384	326	384	3.4430514107347644e+03
C326_384	326	384	2.5716106908524126e-10
R326_428	326	428	4.8914485605240598e+03
C326_428	326	428	1.8101361401317449e-10
R327_328	327	328	1.3144311904062583e+03
C327_328	327	328	6.7361364228304620e-10
R327_329	327	329	5.7615800611138902e+03
C327_329	327	329	1.5367638257357156e-10
R327_426	327	426	6.5434124974444194e+03
C327_426	327	426	1.3531452923773449e-10
R327_428	327	428	4.5774044142608946e+03
C327_428	327	428	1.9343250051087460e-10
R328_397	328	397	4.8592357840401537e+03
C328_397	328	397	1.8221358687884644e-10
R328_425	328	425	3.8388471018710952e+03
C328_425	328	425	2.3064705579663163e-10
R328_426	328	426	8.3601317393856823e+02
C328_426	328	426	1.0590966856762264e-09
R328_428	328	428	4.7716737304370981e+03
C328_428	328	428	1.8555727648606294e-10
R329_384	329	384	3.3170470029072044e+03
C329_384	329	384	2.6692982671755345e-10
R329_385	329	385	3.6286541440393516e+03
C329_385	329	385	2.4400748777737413e-10
R329_428	329	428	4.4159029474214431e+03
C329_428	329	428	2.0050684814461752e-10
R330_331	330	331	2.5335611292684357e+03
C330_331	330	331	3.4947598914089124e-10
R330_339	330	339	3.7803904017972877e+03
C330_339	330	339	2.3421358314714025e-10
R330_347	330	347	2.3382931570537180e+03
C330_347	330	347	3.7866029716121654e-10
R330_351	330	351	2.3860700819219351e+03
C330_351	330	351	3.7107827989143204e-10
R330_352	330	352	3.5290650033538354e+03
C330_352	330	352	2.5089330484378869e-10
R330_372	330	372	2.8988600891966576e+03
C330_372	330	372	3.0543688017222328e-10
R330_430	330	430	4.0516189579891329e+03
C330_430	330	430	2.1853456380790653e-10
R331_347	331	347	4.2084882691275043e+03
C331_347	331	347	2.1038879642251288e-10
R331_350	331	350	6.1370994688868122e+03
C331_350	331	350	1.4427316783584787e-10
R331_351	331	351	4.7185261499131138e+03
C331_351	331	351	1.8764731900792876e-10
R331_346	331	346	6.5922059663321570e+03
C331_346	331	346	1.3431297295958711e-10
R331_430	331	430	1.7803011811175613e+03
C331_430	331	430	4.9734213013563791e-10
R331_431	331	431	9.0368057906237027e+03
C331_431	331	431	9.7979175630694847e-11
R332_334	332	334	2.1621192595530783e+03
C332_334	332	334	4.0951431230626054e-10
R332_333	332	333	3.1142713607587807e+03
C332_333	332	333	2.8431009348018765e-10
R332_340	332	340	4.5572206896318430e+03
C332_340	332	340	1.9428920432017286e-10
R332_348	332	348	1.9954784108770245e+03
C332_348	332	348	4.4371253373312784e-10
R332_350	332	350	6.2092695196827326e+03
C332_350	332	350	1.4259628751712508e-10
R332_432	332	432	1.2347839972918298e+03
C332_432	332	432	7.1706369991992969e-10
R332_433	332	433	4.1334605089923089e+03
C332_433	332	433	2.1420763057340906e-10
R332_434	332	434	4.1028498375579575e+03
C332_434	332	434	2.1580579761773758e-10
R332_435	332	435	5.9238401996273124e+03
C332_435	332	435	1.4946702677018614e-10
R333_340	333	340	9.4193379838793971e+03
C333_340	333	340	9.4000107355244995e-11
R333_434	333	434	9.1805422226829778e+03
C333_434	333	434	9.6445151084032593e-11
R333_432	333	432	1.7490747464111806e+04
C333_432	333	432	5.0622123698071619e-11
R333_435	333	435	7.6636271087095229e+03
C333_435	333	435	1.1553521187033533e-10
R333_437	333	437	9.6576063214364312e+03
C333_437	333	437	9.1680976862215558e-11
R333_438	333	438	2.9541893133991227e+04
C333_438	333	438	2.9971633086751220e-11
R334_335	334	335	1.5957298537935997e+03
C334_335	334	335	5.5486759215230222e-10
R334_340	334	340	2.4575556144719380e+03
C334_340	334	340	3.6028433150647232e-10
R334_342	334	342	1.4350054959922784e+03
C334_342	334	342	6.1701420947363691e-10
R334_344	334	344	5.0880652802239892e+03
C334_344	334	344	1.7401875426822782e-10
R334_348	334	348	1.7160271075449066e+03
C334_348	334	348	5.1597016026556532e-10
R334_432	334	432	6.1770439201031286e+03
C334_432	334	432	1.4334021145914365e-10
R334_434	334	434	5.1232838506369562e+03
C334_434	334	434	1.7282251140348579e-10
R334_439	334	439	1.2860704397924217e+03
C334_439	334	439	6.8846834069439553e-10
R335_338	335	338	9.9992862503093011e+02
C335_338	335	338	8.8548198294914493e-10
R335_342	335	342	1.4761772221704630e+03
C335_342	335	342	5.9980520523013153e-10
R335_347	335	347	2.0606457726543154e+03
C335_347	335	347	4.2968024560547983e-10
R335_348	335	348	1.3415612997689864e+03
C335_348	335	348	6.5999129659782745e-10
R335_349	335	349	1.6770661303452282e+03
C335_349	335	349	5.2795698731196393e-10
R335_439	335	439	2.4308137598584044e+03
C335_439	335	439	3.6424788946051381e-10
R336_337	336	337	1.6987484166046545e+03
C336_337	336	337	5.2121831169662912e-10
R336_338	336	338	2.7811181675344524e+03
C336_338	336	338	3.1836791116464901e-10
R336_339	336	339	1.2950127514465987e+03
C336_339	336	339	6.8371433463565495e-10
R336_354	336	354	1.2094304337350770e+03
C336_354	336	354	7.3209566834329313e-10
R336_353	336	353	2.7054917674982557e+03
C336_353	336	353	3.2726722451598477e-10
R336_357	336	357	1.9786821024173489e+03
C336_357	336	357	4.4747904709821096e-10
R336_358	336	358	1.8540787783563007e+03
C336_358	336	358	4.7755186674697382e-10
R336_369	336	369	3.5149107727102528e+03
C336_369	336	369	2.5190362969506547e-10
R336_373	336	373	1.0963759200479044e+03
C336_373	336	373	8.0758685548412364e-10
R336_440	336	440	1.8817547861473558e+03
C336_440	336	440	4.7052824747308223e-10
R337_338	337	338	4.2151166081912461e+03
C337_338	337	338	2.1005795663620873e-10
R337_341	337	341	2.3026631362659537e+03
C337_341	337	341	3.8451945825467704e-10
R337_353	337	353	1.2344481515466512e+03
C337_353	337	353	7.1725878530471382e-10
R337_357	337	357	4.8227845223481063e+03
C337_357	337	357	1.8359078196363402e-10
R337_390	337	390	2.9461848051164811e+03
C337_390	337	390	3.0053063207791338e-10
R337_440	337	440	4.8443327505268580e+03
C337_440	337	440	1.8277414605834088e-10
R338_339	338	339	7.4521591106989126e+02
C338_339	338	339	1.1881372479404294e-09
R338_341	338	341	3.2303750226040925e+03
C338_341	338	341	2.7409163812387336e-10
R338_342	338	342	2.3055404790527768e+03
C338_342	338	342	3.8403957325605979e-10
R338_347	338	347	3.3216508455669550e+03
C338_347	338	347	2.6655985919822733e-10
R338_349	338	349	1.6164788884162206e+03
C338_349	338	349	5.4774534207960363e-10
R338_439	338	439	5.1106777970947414e+03
C338_439	338	439	1.7324879729325390e-10
R338_440	338	440	9.0953346252400740e+02
C338_440	338	440	9.7348675797250231e-10
R339_347	339	347	1.6571774277645800e+03
C339_347	339	347	5.3429329102941614e-10
R339_349	339	349	1.8441414227393241e+03
C339_349	339	349	4.8012520665838165e-10
R339_352	339	352	1.8609453472117600e+03
C339_352	339	352	4.7578978234187055e-10
R339_372	339	372	4.2256595688905745e+03
C339_372	339	372	2.0953386501328176e-10
R339_373	339	373	1.3533018603300904e+03
C339_373	339	373	6.5426554684853025e-10
R339_440	339	440	3.3977375097503377e+03
C339_440	339	440	2.6059069576715467e-10
R340_344	340	344	4.0109745012172057e+03
C340_344	340	344	2.2074904276536860e-10
R340_434	340	434	1.4645528320186068e+03
C340_434	340	434	6.0456595511110296e-10
R340_437	340	437	7.8666558130209078e+03
C340_437	340	437	1.1255339025185933e-10
R340_436	340	436	4.5423241487599053e+03
C340_436	340	436	1.9492637528779780e-10
R340_439	340	439	5.0794555606420081e+03
C340_439	340	439	1.7431371750953740e-10
R340_441	340	441	5.4036749066199091e+03
C340_441	340	441	1.6385493150509390e-10
R341_342	341	342	1.0951785083194115e+03
C341_342	341	342	8.0846982932371943e-10
R341_343	341	343	2.3103771928814558e+03
C341_343	341	343	3.8323559651994472e-10
R341_344	341	344	4.6500983376842860e+03
C341_344	341	344	1.9040861448554484e-10
R341_345	341	345	2.4759742998242323e+03
C341_345	341	345	3.5760418909148431e-10
R341_353	341	353	2.1250482686968494e+03
C341_353	341	353	4.1665819771847739e-10
R341_440	341	440	2.0925181664227052e+03
C341_440	341	440	4.2313552919527609e-10
R341_441	341	441	3.7558120125213613e+03
C341_441	341	441	2.3574629900222253e-10
R341_442	341	442	1.8170276174551836e+03
C341_442	341	442	4.8728966648292498e-10
R342_344	342	344	2.0385342055470749e+03
C342_344	342	344	4.3434090008922999e-10
R342_439	342	439	1.2248138818222726e+03
C342_439	342	439	7.2290067482144951e-10
R342_440	342	440	3.6136857981381895e+03
C342_440	342	440	2.4501819780684242e-10
R342_441	342	441	3.5345275136619275e+03
C342_441	342	441	2.5050555647893850e-10
R342_442	342	442	3.8781839731438126e+03
C342_442	342	442	2.2830757587351996e-10
R343_344	343	344	5.5891811673031889e+03
C343_344	343	344	1.5841654711064222e-10
R343_345	343	345	1.2503041549423594e+03
C343_345	343	345	7.0816271240882091e-10
R343_402	343	402	7.2409187339396512e+03
C343_402	343	402	1.2227989489094292e-10
R343_441	343	441	6.0644018788334870e+03
C343_441	343	441	1.4600265605588693e-10
R343_445	343	445	5.6017913758772565e+03
C343_445	343	445	1.5805993516874602e-10
R344_439	344	439	4.7385254131581005e+03
C344_439	344	439	1.8685534095508671e-10
R344_441	344	441	9.6136293459626495e+02
C344_441	344	441	9.2100366036250548e-10
R344_436	344	436	8.1291341297879944e+03
C344_436	344	436	1.0891919945760467e-10
R344_445	344	445	6.3841259930657179e+03
C344_445	344	445	1.3869068102066286e-10
R345_353	345	353	2.0284282909421902e+03
C345_353	345	353	4.3650484744951440e-10
R345_390	345	390	2.0406214681156328e+03
C345_390	345	390	4.3389663175386495e-10
R345_399	345	399	2.5020968170628330e+03
C345_399	345	399	3.5387071182136640e-10
R345_402	345	402	2.1979489339777983e+03
C345_402	345	402	4.0283865016717616e-10
R345_441	345	441	4.3922947551093966e+03
C345_441	345	441	2.0158455455887256e-10
R345_442	345	442	2.0412127622943001e+03
C345_442	345	442	4.3377094149891521e-10
R345_445	345	445	3.6423705670648355e+03
C345_445	345	445	2.4308860545551386e-10
R345_446	345	446	7.6930383237020908e+02
C345_446	345	446	1.1509350979989831e-09
R345_447	345	447	3.9326647552434147e+03
C345_447	345	447	2.2514473945928719e-10
R346_351	346	351	2.6786780305802649e+03
C346_351	346	351	3.3054319018258329e-10
R346_361	346	361	3.9258170517747326e+03
C346_361	346	361	2.2553745373838327e-10
R346_368	346	368	7.4210592989127517e+03
C346_368	346	368	1.1931164353176931e-10
R346_430	346	430	5.8087240097700769e+03
C346_430	346	430	1.5242913593600861e-10
R346_431	346	431	7.4349928371609012e+03
C346_431	346	431	1.1908804770793872e-10
R346_449	346	449	2.3499417955332669e+03
C346_449	346	449	3.7678328177446371e-10
R346_450	346	450	1.0072713285827416e+04
C346_450	346	450	8.7902708691788983e-11
R347_348	347	348	4.3169777079444939e+03
C347_348	347	348	2.0510154130992433e-10
R347_349	347	349	2.0029480989111755e+03
C347_349	347	349	4.4205777582620509e-10
R347_350	347	350	4.3081940600508142e+03
C347_350	347	350	2.0551970718086844e-10
R347_352	347	352	2.5618190285997548e+03
C347_352	347	352	3.4562112772811837e-10
R347_430	347	430	2.8003161566731537e+03
C347_430	347	430	3.1618529200356434e-10
R347_452	347	452	5.5876277255284258e+03
C347_452	347	452	1.5846058921476650e-10
R348_349	348	349	4.3632018807298109e+03
C348_349	348	349	2.0292867621149367e-10
R348_350	348	350	4.0744776520231335e+03
C348_350	348	350	2.1730853800617999e-10
R348_432	348	432	5.1281268374604215e+03
C348_432	348	432	1.7265929836838473e-10
R348_433	348	433	1.3389803048972817e+04
C348_433	348	433	6.6126348420630732e-11
R348_439	348	439	4.8893731824276947e+03
C348_439	348	439	1.8109044833848574e-10
R348_443	348	443	9.1245524904130325e+03
C348_443	348	443	9.7036954155317785e-11
R348_452	348	452	4.1363452387771149e+03
C348_452	348	452	2.1405823996494274e-10
R349_352	349	352	3.5740576942638004e+03
C349_352	349	352	2.4773488774986949e-10
R349_373	349	373	7.3542640071689248e+03
C349_373	349	373	1.2039529459873828e-10
R349_439	349	439	3.7155807048956372e+03
C349_439	349	439	2.3829889646411804e-10
R349_440	349	440	2.8154308521608691e+03
C349_440	349	440	3.1448784509142996e-10
R349_443	349	443	2.3333669850008419e+03
C349_443	349	443	3.7945971953472233e-10
R349_444	349	444	3.9764025100573103e+03
C349_444	349	444	2.2266829865954363e-10
R349_452	349	452	2.7488412005538357e+03
C349_452	349	452	3.2210619570224940e-10
R350_430	350	430	1.2345877851645369e+04
C350_430	350	430	7.1717766232556532e-11
R350_431	350	431	1.2327512762147409e+04
C350_431	350	431	7.1824608806631909e-11
R350_433	350	433	1.2275647036212105e+04
C350_433	350	433	7.2128074315601483e-11
R350_452	350	452	9.5205461834080506e+03
C350_452	350	452	9.3000838884964911e-11
R351_359	351	359	6.1856884433290688e+03
C351_359	351	359	1.4313989296613806e-10
R351_361	351	361	5.4286121090916558e+03
C351_361	351	361	1.6310223753454971e-10
R351_372	351	372	3.1472471854031010e+03
C351_372	351	372	2.8133118549015249e-10
R351_352	351	352	6.0470561566451242e+03
C351_352	351	352	1.4642145843593850e-10
R351_374	351	374	3.9316989479757081e+03
C351_374	351	374	2.2520004542969164e-10
R351_430	351	430	1.8898377730541467e+03
C351_430	351	430	4.6851576062483092e-10
R351_449	351	449	3.7994910595541642e+03
C351_449	351	449	2.3303615347996007e-10
R351_453	351	453	5.4450363575354540e+03
C351_453	351	453	1.6261026071472560e-10
R352_372	352	372	1.4333195206132439e+03
C352_372	352	372	6.1773998676943633e-10
R352_373	352	373	2.3053821830451116e+03
C352_373	352	373	3.8406594282362177e-10
R352_430	352	430	1.7339017466414434e+03
C352_430	352	430	5.1065106971317750e-10
R352_444	352	444	4.8174024439334753e+03
C352_444	352	444	1.8379589249700372e-10
R352_452	352	452	4.4912066931173786e+03
C352_452	352	452	1.9714496397079075e-10
R352_453	352	453	1.3897911345442219e+03
C352_453	352	453	6.3708765993126784e-10
R353_354	353	354	1.7934978470264396e+03
C353_354	353	354	4.9368265658528403e-10
R353_357	353	357	2.7602356117909967e+03
C353_357	353	357	3.2077652281483696e-10
R353_390	353	390	1.4752787476524427e+03
C353_390	353	390	6.0017049869994718e-10
R353_440	353	440	1.4752787476524420e+03
C353_440	353	440	6.0017049869994738e-10
R353_442	353	442	2.3864502056440347e+03
C353_442	353	442	3.7101917299843713e-10
R353_446	353	446	5.3515373967740643e+03
C353_446	353	446	1.6545129297493749e-10
R353_454	353	454	2.6965192642038842e+03
C353_454	353	454	3.2835618623381490e-10
R354_357	354	357	1.4748592314135005e+03
C354_357	354	357	6.0034121415873535e-10
R354_358	354	358	3.6620784114713279e+03
C354_358	354	358	2.4178039960216520e-10
R354_373	354	373	2.1905389352244256e+03
C354_373	354	373	4.0420134399906793e-10
R354_440	354	440	1.7077786248075315e+03
C354_440	354	440	5.1846226954608223e-10
R354_444	354	444	2.8188866227775193e+03
C354_444	354	444	3.1410230356394214e-10
R354_454	354	454	1.2621311829982758e+03
C354_454	354	454	7.0152674589390103e-10
R354_455	354	455	1.5478216763507000e+03
C354_455	354	455	5.7204185419314736e-10
R355_356	355	356	1.3989973608664229e+03
C355_356	355	356	6.3289524803080783e-10
R355_358	355	358	1.3320889190324954e+03
C355_358	355	358	6.6468444339517932e-10
R355_389	355	389	1.2505556373247739e+03
C355_389	355	389	7.0802030335420714e-10
R355_393	355	393	2.1195642405941339e+03
C355_393	355	393	4.1773623310978717e-10
R355_394	355	394	1.1006975073826356e+03
C355_394	355	394	8.0441608685518892e-10
R355_396	355	396	3.8026852035668653e+03
C355_396	355	396	2.3284040994755226e-10
R355_417	355	417	3.5628578620685821e+03
C355_417	355	417	2.4851364157028962e-10
R355_456	355	456	2.7094788500763548e+03
C355_456	355	456	3.2678564059470267e-10
R356_366	356	366	7.5648917159107232e+03
C356_366	356	366	1.1704315341854250e-10
R356_396	356	396	1.8984427147893527e+03
C356_396	356	396	4.6639215121023259e-10
R356_416	356	416	5.0818764062052596e+03
C356_416	356	416	1.7423067995491851e-10
R356_417	356	417	3.6329522105447631e+03
C356_417	356	417	2.4371880784174453e-10
R356_456	356	456	6.1234316897954004e+03
C356_456	356	456	1.4459519213311974e-10
R357_358	357	358	1.2522833687120417e+03
C357_358	357	358	7.0704347260527970e-10
R357_390	357	390	1.0733857446103214e+03
C357_390	357	390	8.2488405137282617e-10
R357_393	357	393	1.7582378459119839e+03
C357_393	357	393	5.0358305263343947e-10
R357_454	357	454	3.5084716946287222e+03
C357_454	357	454	2.5236594698926247e-10
R357_455	357	455	3.4863024873880499e+03
C357_455	357	455	2.5397072827245087e-10
R357_457	357	457	1.5884208818099851e+03
C357_457	357	457	5.5742076413090007e-10
R358_369	358	369	2.1049614901909204e+03
C358_369	358	369	4.2063419488956663e-10
R358_373	358	373	3.0804167609887013e+03
C358_373	358	373	2.8743473705025970e-10
R358_393	358	393	3.1137693439906975e+03
C358_393	358	393	2.8435593131160498e-10
R358_394	358	394	1.8952917989724401e+03
C358_394	358	394	4.6716752648855596e-10
R358_395	358	395	1.4312365965525335e+03
C358_395	358	395	6.1863900338542033e-10
R358_396	358	396	3.7691959046832853e+03
C358_396	358	396	2.3490919657422247e-10
R358_455	358	455	1.3620285913573482e+03
C358_455	358	455	6.5007356476828734e-10
R358_456	358	456	2.5470023843725899e+03
C358_456	358	456	3.4763170507125682e-10
R358_457	358	457	1.9961017902008771e+03
C358_457	358	457	4.4357396303466884e-10
R358_458	358	458	1.3396909821845370e+03
C358_458	358	458	6.6091269813297682e-10
R359_361	359	361	1.3396227350174740e+03
C359_361	359	361	6.6094636837322022e-10
R359_371	359	371	1.4993692933108020e+03
C359_371	359	371	5.9052748755770541e-10
R359_370	359	370	4.1063613901918825e+03
C359_370	359	370	2.1562125141124665e-10
R359_372	359	372	4.4322325440771829e+03
C359_372	359	372	1.9976812427930707e-10
R359_374	359	374	1.7488179145844481e+03
C359_374	359	374	5.0629558075541107e-10
R359_375	359	375	1.1175177846754052e+03
C359_375	359	375	7.9230844809971348e-10
R359_379	359	379	3.5219216714756876e+03
C359_379	359	379	2.5140217877957775e-10
R359_380	359	380	3.5457860352617263e+03
C359_380	359	380	2.4971015534913528e-10
R359_381	359	381	6.0479011367219609e+03
C359_381	359	381	1.4640100122071578e-10
R359_382	359	382	1.3514094702755135e+03
C359_382	359	382	6.5518172040002715e-10
R359_460	359	460	4.1522172202338779e+03
C359_460	359	460	2.1323999558243918e-10
R360_361	360	361	4.4556028708912154e+03
C360_361	360	361	1.9872030954206144e-10
R360_368	360	368	5.8471742903207487e+03
C360_368	360	368	1.5142678116602369e-10
R360_380	360	380	4.1665610094524372e+03
C360_380	360	380	2.1250589627544182e-10
R360_382	360	382	8.3337489728630553e+03
C360_382	360	382	1.0624495465164158e-10
R360_459	360	459	1.7169919477994365e+04
C360_459	360	459	5.1568021785704184e-11
R360_461	360	461	3.6098082139187795e+03
C360_461	360	461	2.4528139148389718e-10
R361_368	361	368	2.1370353161855674e+03
C361_368	361	368	4.1432108070183868e-10
R361_374	361	374	6.0576511403226077e+03
C361_374	361	374	1.4616536363512775e-10
R361_380	361	380	5.7173409577694301e+03
C361_380	361	380	1.5486548523869008e-10
R361_382	361	382	2.2943175018099973e+03
C361_382	361	382	3.8591815692531178e-10
R361_449	361	449	3.9631702202267938e+03
C361_449	361	449	2.2341174678319303e-10
R361_460	361	460	2.9059149325145299e+03
C361_460	361	460	3.0469535490973038e-10
R361_461	361	461	5.3645405416829235e+03
C361_461	361	461	1.6505025450366585e-10
R361_462	361	462	5.9752539912781331e+03
C361_462	361	462	1.4818094477530406e-10
R362_363	362	363	1.3261228014310439e+03
C362_363	362	363	6.6767480413165974e-10
R362_364	362	364	1.7787272160154910e+03
C362_364	362	364	4.9778221962748053e-10
R362_365	362	365	1.7836480642321576e+03
C362_365	362	365	4.9640890456782111e-10
R362_423	362	423	5.7970789509071001e+03
C362_423	362	423	1.5273533260426852e-10
R362_463	362	463	6.5741624932250679e+03
C362_463	362	463	1.3468160889124037e-10
R363_365	363	365	2.9785161549513264e+03
C363_365	363	365	2.9726841676790212e-10
R363_366	363	366	1.6222931700767579e+03
C363_366	363	366	5.4578222853401226e-10
R363_367	363	367	3.9060122018773804e+03
C363_367	363	367	2.2668100762061974e-10
R363_383	363	383	1.3816734928344079e+03
C363_383	363	383	6.4083069284598099e-10
R363_423	363	423	5.5717538635443198e+03
C363_423	363	423	1.5891204159129259e-10
R363_463	363	463	2.5689228841760523e+03
C363_463	363	463	3.4466537985782570e-10
R364_365	364	365	1.0395407952005880e+04
C364_365	364	365	8.5174029320239531e-11
R364_384	364	384	4.8347915571275189e+03
C364_384	364	384	1.8313484071401237e-10
R364_386	364	386	5.9594154028531884e+03
C364_386	364	386	1.4857477149119161e-10
R364_423	364	423	6.3310425949046230e+03
C364_423	364	423	1.3985354993703670e-10
R364_463	364	463	9.0413483910802079e+03
C364_463	364	463	9.7929948432638066e-11
R365_367	365	367	4.7237779345265926e+03
C365_367	365	367	1.8743869715559241e-10
R365_463	365	463	5.3246487020271898e+03
C365_463	365	463	1.6628679773050663e-10
R366_367	366	367	2.9258857786889785e+03
C366_367	366	367	3.0261563460509925e-10
R366_383	366	383	1.8206889036625450e+03
C366_383	366	383	4.8630975886043392e-10
R366_416	366	416	1.2539222295357492e+03
C366_416	366	416	7.0611937554358251e-10
R366_417	366	417	8.4226803913528929e+03
C366_417	366	417	1.0512316039072447e-10
R366_420	366	420	3.2176567974513132e+03
C366_420	366	420	2.7517502251990794e-10
R366_463	366	463	6.9000033352363253e+03
C366_463	366	463	1.2832150053876379e-10
R366_464	366	464	1.9126900867988386e+03
C366_464	366	464	4.6291805860816453e-10
R367_377	367	377	4.5330358161286158e+03
C367_377	367	377	1.9532578554743943e-10
R367_416	367	416	2.7884204751391467e+03
C367_416	367	416	3.1753417018493820e-10
R367_463	367	463	4.6044454421170385e+03
C367_463	367	463	1.9229650841359540e-10
R367_464	367	464	4.7817592153839933e+03
C367_464	367	464	1.8516590690125277e-10
R367_465	367	465	4.5586384668672754e+03
C367_465	367	465	1.9422877864417824e-10
R368_449	368	449	3.6818914103517764e+03
C368_449	368	449	2.4047933059910783e-10
R368_450	368	450	4.5504256056352597e+03
C368_450	368	450	1.9457933354706315e-10
R368_459	368	459	4.3359856866938799e+03
C368_459	368	459	2.0420242262725684e-10
R368_461	368	461	4.5423794575211941e+03
C368_461	368	461	1.9492400183211000e-10
R368_462	368	462	1.3828133081275073e+03
C368_462	368	462	6.4030247358478332e-10
R368_467	368	467	3.0312834184657918e+03
C368_467	368	467	2.9209369744388092e-10
R368_468	368	468	4.2311026137911058e+03
C368_468	368	468	2.0926431299822741e-10
R369_370	369	370	3.7264731677104896e+03
C369_370	369	370	2.3760234995707564e-10
R369_371	369	371	1.3736497353325105e+03
C369_371	369	371	6.4457391060150591e-10
R369_372	369	372	3.4359565956847946e+03
C369_372	369	372	2.5769207411176090e-10
R369_373	369	373	3.0795926066016277e+03
C369_373	369	373	2.8751165975718829e-10
R369_395	369	395	1.5973987646526273e+03
C369_395	369	395	5.5428788433584691e-10
R369_396	369	396	4.0490267373478805e+03
C369_396	369	396	2.1867447145581233e-10
R369_471	369	471	5.5314490405143160e+03
C369_471	369	471	1.6006995187244342e-10
R370_371	370	371	1.3392479363848838e+03
C370_371	370	371	6.6113133919777899e-10
R370_375	370	375	4.0108469793969361e+03
C370_375	370	375	2.2075606131279785e-10
R370_376	370	376	1.5624559257823648e+03
C370_376	370	376	5.6668400502666748e-10
R370_379	370	379	1.8501795525953485e+03
C370_379	370	379	4.7855830017036708e-10
R370_396	370	396	5.8793333593356401e+03
C370_396	370	396	1.5059849945301479e-10
R370_471	370	471	1.4931781441985493e+03
C370_471	370	471	5.9297598557822526e-10
R370_472	370	472	3.8825224768072326e+03
C370_472	370	472	2.2805245481234625e-10
R371_372	371	372	1.1456995483611427e+03
C371_372	371	372	7.7281935125709060e-10
R371_374	371	374	3.6002804203305332e+03
C371_374	371	374	2.4593050494069903e-10
R371_375	371	375	2.1138419892451088e+03
C371_375	371	375	4.1886706111661592e-10
R371_395	371	395	3.4788411913625282e+03
C371_395	371	395	2.5451543574290481e-10
R371_471	371	471	4.4005718475014100e+03
C371_471	371	471	2.0120539156808221e-10
R371_472	371	472	1.3666090855423136e+03
C371_472	371	472	6.4789469868674115e-10
R372_373	372	373	1.5742853253444671e+03
C372_373	372	373	5.6242586235520102e-10
R372_374	372	374	2.0251060693852196e+03
C372_374	372	374	4.3722094120669688e-10
R372_395	372	395	4.4112753937506759e+03
C372_395	372	395	2.0071718554555599e-10
R372_453	372	453	2.4367779505786739e+03
C372_453	372	453	3.6335636634012354e-10
R372_472	372	472	4.9971774703057790e+03
C372_472	372	472	1.7718377763474167e-10
R372_474	372	474	4.2580549340612615e+03
C372_474	372	474	2.0793972727249492e-10
R373_395	373	395	2.6032739875911161e+03
C373_395	373	395	3.4011740059650942e-10
R373_440	373	440	3.3425369176243935e+03
C373_440	373	440	2.6489424156585969e-10
R373_444	373	444	1.1288395685643225e+03
C373_444	373	444	7.8436192915003044e-10
R373_453	373	453	3.9117496440905270e+03
C373_453	373	453	2.2634853000820249e-10
R373_455	373	455	2.4956041940124037e+03
C373_455	373	455	3.5479135025672237e-10
R373_474	373	474	2.5453499712076209e+03
C373_474	373	474	3.4785738374512018e-10
R374_375	374	375	1.4489716825521309e+03
C374_375	374	375	6.1106700176533269e-10
R374_449	374	449	1.8792753217332513e+03
C374_449	374	449	4.7114904956203018e-10
R374_453	374	453	1.3232070320796149e+03
C374_453	374	453	6.6914606726993731e-10
R374_460	374	460	1.1372268007873267e+03
C374_460	374	460	7.7857713262385780e-10
R374_469	374	469	2.0054328256609640e+03
C374_469	374	469	4.4151006723856621e-10
R374_470	374	470	4.6035799036119688e+03
C374_470	374	470	1.9233266289248080e-10
R374_472	374	472	2.1091613268798105e+03
C374_472	374	472	4.1979661319214730e-10
R374_473	374	473	8.3939817463075167e+02
C374_473	374	473	1.0548257173533795e-09
R374_474	374	474	3.7477570150033939e+03
C374_474	374	474	2.3625298496017844e-10
R375_379	375	379	1.1954576755459486e+03
C375_379	375	379	7.4065255492683332e-10
R375_382	375	382	3.3154771968767686e+03
C375_382	375	382	2.6705621215976949e-10
R375_460	375	460	2.6556964964215272e+03
C375_460	375	460	3.3340360349651247e-10
R375_472	375	472	6.3982526168426580e+02
C375_472	375	472	1.3838446756060207e-09
R375_473	375	473	1.7682180604580535e+03
C375_473	375	473	5.0074071829728621e-10
R375_477	375	477	3.6697552956189666e+03
C375_477	375	477	2.4127461107748308e-10
R375_478	375	478	2.5937419079542688e+03
C375_478	375	478	3.4136734228824872e-10
R376_378	376	378	1.7208695889497069e+03
C376_378	376	378	5.1451823391242272e-10
R376_377	376	377	2.6378741360581748e+03
C376_377	376	377	3.3565618980710654e-10
R376_379	376	379	1.9428417105135222e+03
C376_379	376	379	4.5573387523473047e-10
R376_381	376	381	5.0129570830952471e+03
C376_381	376	381	1.7662604467247879e-10
R376_396	376	396	2.7828711204756323e+03
C376_396	376	396	3.1816736865222465e-10
R376_416	376	416	5.9846060590786919e+03
C376_416	376	416	1.4794938429686835e-10
R376_471	376	471	2.5813043834245855e+03
C376_471	376	471	3.4301215594161182e-10
R376_475	376	475	1.3261811719787199e+03
C376_475	376	475	6.6764541708801119e-10
R376_479	376	479	2.5739521972120970e+03
C376_479	376	479	3.4399192908827758e-10
R377_378	377	378	4.2525690915099613e+03
C377_378	377	378	2.0820797091050060e-10
R377_416	377	416	3.8756959305521327e+03
C377_416	377	416	2.2845414025394477e-10
R377_465	377	465	8.8592354952279329e+03
C377_465	377	465	9.9943023546098850e-11
R377_475	377	475	4.6357313789066902e+03
C377_475	377	475	1.9099872475976397e-10
R377_476	377	476	4.2340552397517258e+03
C377_476	377	476	2.0911838215694104e-10
R377_479	377	479	6.5636761463756311e+03
C377_479	377	479	1.3489678069947367e-10
R378_381	378	381	5.1029867834140923e+03
C378_381	378	381	1.7350991081885994e-10
R378_479	378	479	1.0224601386466349e+04
C378_479	378	479	8.6596899794252352e-11
R379_381	379	381	3.4640926973326968e+03
C379_381	379	381	2.5559904398105748e-10
R379_382	379	382	5.1467678662908611e+03
C379_382	379	382	1.7203394532306696e-10
R379_471	379	471	3.3015384874544848e+03
C379_471	379	471	2.6818369225877651e-10
R379_472	379	472	3.4946922837211823e+03
C379_472	379	472	2.5336101430858957e-10
R379_475	379	475	4.3471512401035197e+03
C379_475	379	475	2.0367793361588118e-10
R379_477	379	477	1.4526075749847339e+03
C379_477	379	477	6.0953749446701429e-10
R379_478	379	478	4.9148920017003129e+03
C379_478	379	478	1.8015020093904165e-10
R379_479	379	479	2.4104259388676069e+03
C379_479	379	479	3.6732876435770541e-10
R379_480	379	480	3.3015384874544766e+03
C379_480	379	480	2.6818369225877713e-10
R380_381	380	381	3.6512499466244267e+03
C380_381	380	381	2.4249744461306133e-10
R380_382	380	382	1.4396041531824151e+03
C380_382	380	382	6.1504322541906890e-10
R380_461	380	461	7.6362069378403658e+03
C380_461	380	461	1.1595007690433409e-10
R380_480	380	480	6.6432447459749301e+03
C380_480	380	480	1.3328107205992461e-10
R381_382	381	382	6.7987475387555651e+03
C381_382	381	382	1.3023263132698496e-10
R381_479	381	479	6.0580618411202149e+03
C381_479	381	479	1.4615545448711936e-10
R381_480	381	480	5.5341058682103167e+03
C381_480	381	480	1.5999310508064733e-10
R382_460	382	460	2.6343330800030794e+03
C382_460	382	460	3.3610737701360264e-10
R382_461	382	461	1.6627476812408959e+03
C382_461	382	461	5.3250339284143145e-10
R382_478	382	478	2.8775337557417693e+03
C382_478	382	478	3.0770057169034228e-10
R382_480	382	480	1.7991051201861549e+03
C382_480	382	480	4.9214399523713493e-10
R383_420	383	420	8.5242991510458694e+02
C383_420	383	420	1.0386997992572395e-09
R383_423	383	423	2.1952366089772490e+03
C383_423	383	423	4.0333637753632069e-10
R383_425	383	425	6.4945329108396254e+03
C383_425	383	425	1.3633294246953495e-10
R383_463	383	463	2.5937258471093742e+03
C383_463	383	463	3.4136945609990794e-10
R383_464	383	464	2.2230714180327182e+03
C383_464	383	464	3.9828625140776687e-10
R383_481	383	481	1.9453737636555379e+03
C383_481	383	481	4.5514070264637263e-10
R384_385	384	385	1.7949757856172344e+03
C384_385	384	385	4.9327617051699292e-10
R384_386	384	386	5.3502306781130562e+02
C384_386	384	386	1.6549170212830412e-09
R384_423	384	423	3.1982941139231493e+03
C384_423	384	423	2.7684095025704559e-10
R384_424	384	424	1.0215808650136169e+03
C384_424	384	424	8.6671433659654376e-10
R384_428	384	428	2.3020616472472784e+03
C384_428	384	428	3.8461992655963492e-10
R384_482	384	482	4.3957519909551547e+03
C384_482	384	482	2.0142600936583031e-10
R385_386	385	386	6.7976274811920666e+03
C385_386	385	386	1.3025408999681291e-10
R385_428	385	428	1.0542920274393200e+04
C385_428	385	428	8.3982308379066313e-11
R385_482	385	482	8.0256962226897267e+03
C385_482	385	482	1.1032298720661788e-10
R386_423	386	423	2.0990184706029609e+03
C386_423	386	423	4.2182515023112500e-10
R386_424	386	424	2.5103528779200974e+03
C386_424	386	424	3.5270690008872221e-10
R386_463	386	463	9.5927981938305729e+03
C386_463	386	463	9.2300365733685556e-11
R386_482	386	482	4.7430713409900418e+03
C386_482	386	482	1.8667625216768988e-10
R386_483	386	483	4.9645635707367464e+03
C386_483	386	483	1.7834775788128404e-10
R387_388	387	388	5.1661374266623543e+03
C387_388	387	388	1.7138893307993846e-10
R387_389	387	389	4.0569208739160676e+03
C387_389	387	389	2.1824896497064836e-10
R387_391	387	391	5.6376790222926693e+03
C387_391	387	391	1.5705377659828663e-10
R387_392	387	392	7.4277207541015368e+03
C387_392	387	392	1.1920464042904114e-10
R387_419	387	419	5.9389828874050763e+03
C387_419	387	419	1.4908592910374028e-10
R387_485	387	485	6.0714211097308116e+03
C387_485	387	485	1.4583386091946712e-10
R388_391	388	391	3.8660444012967178e+03
C388_391	388	391	2.2902447302545725e-10
R388_406	388	406	7.1710784664265984e+03
C388_406	388	406	1.2347079812964463e-10
R388_408	388	408	5.2235530176615021e+03
C388_408	388	408	1.6950508182960636e-10
R388_412	388	412	4.9406644800244703e+03
C388_412	388	412	1.7921046557195375e-10
R388_418	388	418	2.4595756432352514e+03
C388_418	388	418	3.5998843301901754e-10
R388_419	388	419	7.1584993805984932e+03
C388_419	388	419	1.2368776396066042e-10
R388_485	388	485	7.1379279182178980e+03
C388_485	388	485	1.2404423130138019e-10
R389_391	389	391	7.5779730160790677e+03
C389_391	389	391	1.1684111038945428e-10
R389_392	389	392	6.0203626485197556e+03
C389_392	389	392	1.4707067221568462e-10
R389_393	389	393	2.4660070102166301e+03
C389_393	389	393	3.5904958016409661e-10
R389_394	389	394	1.4801936580763349e+03
C389_394	389	394	5.9817766200315539e-10
R389_417	389	417	4.1021035988970252e+03
C389_417	389	417	2.1584505616534692e-10
R389_415	389	415	2.9784251910664811e+03
C389_415	389	415	2.9727749562276540e-10
R389_485	389	485	2.7012138685854161e+03
C389_485	389	485	3.2778551598495982e-10
R390_393	390	393	1.9039013455185961e+03
C390_393	390	393	4.6505496925252938e-10
R390_399	390	399	2.3937994500733598e+03
C390_399	390	399	3.6988010072141415e-10
R390_413	390	413	3.3886542990361609e+03
C390_413	390	413	2.6128920319545163e-10
R390_446	390	446	3.2551834359195091e+03
C390_446	390	446	2.7200273014718480e-10
R390_454	390	454	3.5638472284984528e+03
C390_454	390	454	2.4844465122402331e-10
R390_457	390	457	3.5936786062723040e+03
C390_457	390	457	2.4638229477578082e-10
R390_484	390	484	2.4299717132239671e+03
C390_484	390	484	3.6437411056331595e-10
R390_486	390	486	5.5757293984219032e+03
C390_486	390	486	1.5879873617084067e-10
R391_393	391	393	3.2202337015825929e+03
C391_393	391	393	2.7495482121836635e-10
R391_412	391	412	2.6876549537068131e+03
C391_412	391	412	3.2943915679311091e-10
R391_413	391	413	5.2828237918332752e+03
C391_413	391	413	1.6760331530814450e-10
R391_414	391	414	6.0679403236874305e+03
C391_414	391	414	1.4591751640067868e-10
R391_485	391	485	3.0535022691265385e+03
C391_485	391	485	2.8996827369421806e-10
R391_486	391	486	6.5192948380337830e+03
C391_486	391	486	1.3581511554507972e-10
R392_417	392	417	3.4137162368381109e+03
C392_417	392	417	2.5937093779068827e-10
R392_415	392	415	8.9530208903049770e+03
C392_415	392	415	9.8896092452861360e-11
R392_419	392	419	3.8565215285360450e+03
C392_419	392	419	2.2959000102771619e-10
R392_420	392	420	8.7429342793340020e+03
C392_420	392	420	1.0127249655677927e-10
R392_421	392	421	2.2590345485467728e+03
C392_421	392	421	3.9194565761271175e-10
R392_422	392	422	6.3747239180951301e+03
C392_422	392	422	1.3889523579000384e-10
R392_425	392	425	9.6885509381318807e+03
C392_425	392	425	9.1388153641758534e-11
R392_485	392	485	9.3733950931460804e+03
C392_485	392	485	9.4460840805422476e-11
R392_487	392	487	6.6714356752210942e+03
C392_487	392	487	1.3271787735113808e-10
R393_394	393	394	1.9751089262865564e+03
C393_394	393	394	4.4828858293131943e-10
R393_413	393	413	6.7307406743642614e+03
C393_413	393	413	1.3154849139743905e-10
R393_457	393	457	3.3185339508952820e+03
C393_457	393	457	2.6681022246619772e-10
R393_485	393	485	4.2277744041225133e+03
C393_485	393	485	2.0942905109521125e-10
R393_486	393	486	2.5053938760618753e+03
C393_486	393	486	3.5340502352139272e-10
R393_488	393	488	5.5001941657557372e+03
C393_488	393	488	1.6097954999709392e-10
R394_417	394	417	7.5831456024011677e+03
C394_417	394	417	1.1676141117739272e-10
R394_415	394	415	2.6611054966678789e+03
C394_415	394	415	3.3272592266961352e-10
R394_456	394	456	3.2614810989523016e+03
C394_456	394	456	2.7147751430613120e-10
R394_457	394	457	7.9107855775029702e+03
C394_457	394	457	1.1192551903037189e-10
R394_458	394	458	6.6405397105368056e+03
C394_458	394	458	1.3333536433718954e-10
R394_485	394	485	8.4605215127124902e+03
C394_485	394	485	1.0465297917741833e-10
R394_488	394	488	2.6003903413229959e+03
C394_488	394	488	3.4049456638480178e-10
R395_396	395	396	8.1800283739449324e+03
C395_396	395	396	1.0824152939618652e-10
R395_455	395	455	4.0027035185616078e+03
C395_455	395	455	2.2120518734252391e-10
R395_456	395	456	6.7992671132971254e+03
C395_456	395	456	1.3022267943679000e-10
R395_458	395	458	4.9498993001184199e+03
C395_458	395	458	1.7887612010184081e-10
R395_471	395	471	3.0364470154127662e+03
C395_471	395	471	2.9159698068357001e-10
R395_472	395	472	3.6714673698552056e+03
C395_472	395	472	2.4116210019181488e-10
R395_474	395	474	5.0410932948563132e+03
C395_474	395	474	1.7564022919461504e-10
R395_490	395	490	3.1016738059720042e+03
C395_490	395	490	2.8546482869836376e-10
R396_416	396	416	2.2295277087879426e+03
C396_416	396	416	3.9713288971920775e-10
R396_456	396	456	1.3571046655371929e+03
C396_456	396	456	6.5243219936136473e-10
R396_471	396	471	1.0812048587700754e+03
C396_471	396	471	8.1891861150828352e-10
R396_475	396	475	4.7877071323887385e+03
C396_475	396	475	1.8493586955437613e-10
R396_492	396	492	4.1848492761235930e+03
C396_492	396	492	2.1157722137131773e-10
R397_398	397	398	2.3232995384076999e+03
C397_398	397	398	3.8110401481284336e-10
R397_407	397	407	7.6806900712320448e+03
C397_407	397	407	1.1527854574113441e-10
R397_426	397	426	4.8800106841253883e+03
C397_426	397	426	1.8143787770388617e-10
R397_495	397	495	1.2995226543026125e+04
C397_495	397	495	6.8134155166010499e-11
R398_407	398	407	2.4844283179844529e+03
C398_407	398	407	3.5638733276809348e-10
R398_406	398	406	4.4054149131320410e+03
C398_406	398	406	2.0098419766561996e-10
R398_418	398	418	1.4541136320747671e+03
C398_418	398	418	6.0890618323731780e-10
R398_422	398	422	2.3346073576263284e+03
C398_422	398	422	3.7925811327872883e-10
R398_426	398	426	6.1010858779189775e+03
C398_426	398	426	1.4512478588516574e-10
R398_495	398	495	2.1243007180914788e+03
C398_495	398	495	4.1680482153933495e-10
R398_496	398	496	2.3138773714574804e+03
C398_496	398	496	3.8265587996233635e-10
R398_497	398	497	2.5998244802892582e+03
C398_497	398	497	3.4056867623674646e-10
R399_400	399	400	3.6616030086579271e+03
C399_400	399	400	2.4181179106703019e-10
R399_402	399	402	1.0275285181648216e+04
C399_402	399	402	8.6169752571088594e-11
R399_403	399	403	5.1018105792212800e+03
C399_403	399	403	1.7354991290859466e-10
R399_413	399	413	4.1926126682731729e+03
C399_413	399	413	2.1118544729882733e-10
R399_446	399	446	8.9413546545401205e+03
C399_446	399	446	9.9025127165760485e-11
R399_484	399	484	7.4373027184795110e+03
C399_484	399	484	1.1905106128058962e-10
R399_499	399	499	5.7455578108411391e+03
C399_499	399	499	1.5410492955606972e-10
R400_401	400	401	5.2128369859720324e+03
C400_401	400	401	1.6985353351403462e-10
R400_403	400	403	5.0378192230159812e+03
C400_403	400	403	1.7575437753995634e-10
R400_409	400	409	4.6079683035467315e+03
C400_409	400	409	1.9214949482584273e-10
R400_413	400	413	5.0548814993725182e+03
C400_413	400	413	1.7516113519375487e-10
R400_414	400	414	3.8127491473771565e+03
C400_414	400	414	2.3222581593365303e-10
R400_494	400	494	4.8026062535146930e+03
C400_494	400	494	1.8436214317008056e-10
R400_499	400	499	6.6123578503819690e+03
C400_499	400	499	1.3390363947844309e-10
R400_500	400	500	9.4550003911443364e+03
C400_500	400	500	9.3645557384565904e-11
R401_403	401	403	6.1449424566909438e+03
C401_403	401	403	1.4408902734897192e-10
R401_404	401	404	3.7805116115158926e+03
C401_404	401	404	2.3420607385595860e-10
R401_409	401	409	1.1581191158824108e+03
C401_409	401	409	7.6453170451760408e-10
R401_429	401	429	5.4068490607305812e+03
C401_429	401	429	1.6375873854713471e-10
R401_500	401	500	4.1004168464295899e+03
C401_500	401	500	2.1593384645050723e-10
R402_403	402	403	6.4184598808724986e+03
C402_403	402	403	1.3794879116384536e-10
R402_445	402	445	4.5804933670966484e+03
C402_445	402	445	1.9330205520223772e-10
R402_446	402	446	3.8335781562239895e+03
C402_446	402	446	2.3096406167237837e-10
R402_448	402	448	2.0267065599170992e+03
C402_448	402	448	4.3687566775143678e-10
R402_498	402	498	1.0738871872053611e+04
C402_498	402	498	8.2449887869895977e-11
R402_499	402	499	6.1361607484735205e+03
C402_499	402	499	1.4429523899292627e-10
R402_501	402	501	7.0002333969112105e+03
C402_501	402	501	1.2648418009757833e-10
R403_499	403	499	5.4337376871884808e+03
C403_499	403	499	1.6294838519489382e-10
R403_500	403	500	1.0672840588290221e+04
C403_500	403	500	8.2959993112934070e-11
R403_501	403	501	1.6944676748099067e+04
C403_501	403	501	5.2253506801145111e-11
R404_405	404	405	2.8311691001180266e+03
C404_405	404	405	3.1273963171719004e-10
R404_408	404	408	5.7914832242763687e+03
C404_408	404	408	1.5288290536499501e-10
R404_409	404	409	5.4470188432427940e+03
C404_409	404	409	1.6255107742070529e-10
R404_410	404	410	7.2443410506392966e+03
C404_410	404	410	1.2222212834966735e-10
R404_411	404	411	6.6624227901040649e+03
C404_411	404	411	1.3289741729017021e-10
R404_429	404	429	7.1810241915716397e+03
C404_429	404	429	1.2329979096007154e-10
R404_502	404	502	4.7169024824286535e+03
C404_502	404	502	1.8771191157721644e-10
R405_406	405	406	1.3872615160121268e+03
C405_406	405	406	6.3824936501176614e-10
R405_407	405	407	6.6449575276681026e+03
C405_407	405	407	1.3324671798327018e-10
R405_408	405	408	5.1312233033891343e+03
C405_408	405	408	1.7255510613135615e-10
R405_410	405	410	2.0759255821394786e+03
C405_410	405	410	4.2651759259475713e-10
R405_502	405	502	5.7378910198345502e+03
C405_502	405	502	1.5431083975616021e-10
R406_407	406	407	1.8956073949038682e+03
C406_407	406	407	4.6708974868970808e-10
R406_408	406	408	2.2115419607211529e+03
C406_408	406	408	4.0036264173404030e-10
R406_410	406	410	3.8864949451652296e+03
C406_410	406	410	2.2781935759403325e-10
R406_418	406	418	3.2034771895410154e+03
C406_418	406	418	2.7639303460339610e-10
R406_496	406	496	2.0354652204270121e+03
C406_496	406	496	4.3499578023458032e-10
R406_502	406	502	3.0436042253043120e+03
C406_502	406	502	2.9091127365992282e-10
R406_503	406	503	2.7727844923361099e+03
C406_503	406	503	3.1932477412048074e-10
R406_504	406	504	4.3946040819463187e+03
C406_504	406	504	2.0147862360057210e-10
R407_410	407	410	7.4947645177861077e+03
C407_410	407	410	1.1813830569309811e-10
R407_495	407	495	1.0730135841885689e+04
C407_495	407	495	8.2517015138216444e-11
R407_496	407	496	5.3752595432902681e+03
C407_496	407	496	1.6472112175592241e-10
R407_504	407	504	8.4097900204991711e+03
C407_504	407	504	1.0528429122983565e-10
R408_409	408	409	1.7416293822699718e+03
C408_409	408	409	5.0838530327616523e-10
R408_412	408	412	1.7143200385225543e+03
C408_412	408	412	5.1648394803987526e-10
R408_414	408	414	1.5381017961129053e+03
C408_414	408	414	5.7565681539260436e-10
R408_418	408	418	5.4500152891722546e+03
C408_418	408	418	1.6246170601742972e-10
R408_502	408	502	1.6342515095677109e+03
C408_502	408	502	5.4178856590697559e-10
R408_503	408	503	1.6228747919655152e+03
C408_503	408	503	5.4558662571105762e-10
R408_505	408	505	2.8908158351619550e+03
C408_505	408	505	3.0628681735112861e-10
R409_414	409	414	1.5466049052268563e+03
C409_414	409	414	5.7249190061900566e-10
R409_429	409	429	1.9862010169447005e+03
C409_429	409	429	4.4578508124117621e-10
R409_494	409	494	1.8604450022003264e+03
C409_494	409	494	4.7591774046146257e-10
R409_500	409	500	2.8589011338031555e+03
C409_500	409	500	3.0970598151540139e-10
R409_502	409	502	1.9256295789334174e+03
C409_502	409	502	4.5980742682111411e-10
R409_505	409	505	1.9818566113732234e+03
C409_505	409	505	4.4676228170033741e-10
R409_507	409	507	2.4022646348422481e+03
C409_507	409	507	3.6857670418902188e-10
R410_411	410	411	1.4438575471011885e+04
C410_411	410	411	6.1323139770792651e-11
R410_502	410	502	6.2678461063129325e+03
C410_502	410	502	1.4126364411024901e-10
R410_504	410	504	1.7554781635653882e+04
C410_504	410	504	5.0437470546583632e-11
R410_508	410	508	2.3931513037073950e+04
C410_508	410	508	3.6998027677077375e-11
R411_502	411	502	9.2858087820089768e+03
C411_502	411	502	9.5351821525280262e-11
R411_429	411	429	8.8186536468919112e+03
C411_429	411	429	1.0040294325563644e-10
R411_508	411	508	9.2931485460275399e+03
C411_508	411	508	9.5276512294477638e-11
R411_509	411	509	2.7437134144482185e+04
C411_509	411	509	3.2270818702763985e-11
R412_414	412	414	1.2079317538569442e+03
C412_414	412	414	7.3300397880330953e-10
R412_413	412	413	4.0444237942993768e+03
C412_413	412	413	2.1892334402443176e-10
R412_418	412	418	3.7339910137642510e+03
C412_418	412	418	2.3712397229563921e-10
R412_485	412	485	3.0617906898934348e+03
C412_485	412	485	2.8918331505241359e-10
R412_486	412	486	3.2864530016028984e+03
C412_486	412	486	2.6941470980055258e-10
R412_493	412	493	1.8794876992050122e+03
C412_493	412	493	4.7109581088214377e-10
R412_503	412	503	3.5758898502903198e+03
C412_503	412	503	2.4760795739502839e-10
R412_505	412	505	3.5218453110779251e+03
C412_505	412	505	2.5140762966360989e-10
R412_510	412	510	3.1997240921922898e+03
C412_510	412	510	2.7671722816993126e-10
R413_414	413	414	1.1451562699350327e+03
C413_414	413	414	7.7318598775190034e-10
R413_484	413	484	1.8793820761669565e+03
C413_484	413	484	4.7112228690923363e-10
R413_486	413	486	1.8490511083685435e+03
C413_486	413	486	4.7885035610574525e-10
R413_494	413	494	2.9223917945732810e+03
C413_494	413	494	3.0297743900875079e-10
R413_499	413	499	5.8015382085139163e+03
C413_499	413	499	1.5261793508497863e-10
R413_510	413	510	2.6933196040087673e+03
C413_510	413	510	3.2874627295703514e-10
R414_494	414	494	4.5735158034429869e+03
C414_494	414	494	1.9359696560651398e-10
R414_505	414	505	5.0781419571596707e+03
C414_505	414	505	1.7435880862913816e-10
R414_510	414	510	7.2110041633763285e+03
C414_510	414	510	1.2278716828329082e-10
R415_417	415	417	9.7460422069665537e+02
C415_417	415	417	9.0849060869764668e-10
R415_456	415	456	3.4925952750416727e+03
C415_456	415	456	2.5351313621342386e-10
R415_485	415	485	1.6428594556631513e+03
C415_485	415	485	5.3894980404309446e-10
R415_487	415	487	1.1869645517012571e+03
C415_487	415	487	7.4595216885874454e-10
R415_488	415	488	1.2785414020480025e+03
C415_488	415	488	6.9252257320858921e-10
R415_511	415	511	3.2646547308331460e+03
C415_511	415	511	2.7121360594050929e-10
R416_417	416	417	7.8416314844648559e+03
C416_417	416	417	1.1291257226944586e-10
R416_420	416	420	8.8993592264908257e+03
C416_420	416	420	9.9492419528853702e-11
R416_456	416	456	9.5900802867834846e+03
C416_456	416	456	9.2326524410878488e-11
R416_464	416	464	2.8640582841587620e+03
C416_464	416	464	3.0914831119090421e-10
R416_465	416	465	6.1080958005852781e+03
C416_465	416	465	1.4495823422009183e-10
R416_475	416	475	5.5075774254533198e+03
C416_475	416	475	1.6076374661716584e-10
R416_476	416	476	1.2069333275643987e+04
C416_476	416	476	7.3361035069499859e-11
R416_491	416	491	4.3134655402814660e+03
C416_491	416	491	2.0526854183289101e-10
R416_492	416	492	9.3693728130130748e+03
C416_492	416	492	9.4501392928910502e-11
R416_512	416	512	7.5339974828325985e+03
C416_512	416	512	1.1752310559136318e-10
R417_420	417	420	1.1929176370036355e+03
C417_420	417	420	7.4222960096724732e-10
R417_421	417	421	2.5787751003808235e+03
C417_421	417	421	3.4334858498100314e-10
R417_427	417	427	1.5457383431870433e+03
C417_427	417	427	5.7281284740237514e-10
R417_456	417	456	1.1043713418129837e+03
C417_456	417	456	8.0174009246424151e-10
R417_487	417	487	1.5860695216789047e+03
C417_487	417	487	5.5824714465401001e-10
R417_511	417	511	2.2714709171954464e+03
C417_511	417	511	3.8979974385637937e-10
R417_512	417	512	2.1049315582271620e+03
C417_512	417	512	4.2064017627524523e-10
R418_419	418	419	1.3689967002926921e+03
C418_419	418	419	6.4676473033915793e-10
R418_422	418	422	3.1064395070717378e+03
C418_422	418	422	2.8502688678931768e-10
R418_485	418	485	5.0605633425657570e+03
C418_485	418	485	1.7496446971674179e-10
R418_493	418	493	1.2883830019863963e+03
C418_493	418	493	6.8723258560139624e-10
R418_496	418	496	1.7950850459048781e+03
C418_496	418	496	4.9324614659339018e-10
R418_497	418	497	2.3833421919686812e+03
C418_497	418	497	3.7150300308686644e-10
R418_503	418	503	3.0760473032961604e+03
C418_503	418	503	2.8784303178667736e-10
R418_513	418	513	5.3393914162148085e+03
C418_513	418	513	1.6582765949900886e-10
R419_422	419	422	1.3722389793285963e+03
C419_422	419	422	6.4523657689217811e-10
R419_421	419	421	3.8494704828485978e+03
C419_421	419	421	2.3001053927936407e-10
R419_485	419	485	1.4788944598508733e+03
C419_485	419	485	5.9870315680896015e-10
R419_487	419	487	2.0293643921887135e+03
C419_487	419	487	4.3630349734532229e-10
R419_493	419	493	3.7590137753600316e+03
C419_493	419	493	2.3554550065866582e-10
R419_513	419	513	2.4980575619551942e+03
C419_513	419	513	3.5444290603415690e-10
R420_421	420	421	1.0680131342701241e+03
C420_421	420	421	8.2903360762982721e-10
R420_425	420	425	2.6275854754511884e+03
C420_425	420	425	3.3697049628726649e-10
R420_427	420	427	2.6083379571273017e+03
C420_427	420	427	3.3945707812923055e-10
R420_464	420	464	9.5319799319312881e+02
C420_464	420	464	9.2889283026491222e-10
R420_481	420	481	1.1453531990104170e+03
C420_481	420	481	7.7305304814706960e-10
R420_489	420	489	2.6711936988322518e+03
C420_489	420	489	3.3146932852045612e-10
R420_512	420	512	1.8477337822012360e+03
C420_512	420	512	4.7919174841582744e-10
R420_515	420	515	1.9647053115312781e+03
C420_515	420	515	4.5066238509321819e-10
R421_422	421	422	1.2730793583944399e+03
C421_422	421	422	6.9549378509809261e-10
R421_425	421	425	1.5615039417247215e+03
C421_425	421	425	5.6702948871331834e-10
R421_427	421	427	1.0681685259325495e+03
C421_427	421	427	8.2891300408519121e-10
R421_487	421	487	1.6992589415198611e+03
C421_487	421	487	5.2106171700238842e-10
R421_513	421	513	1.0508211792906370e+03
C421_513	421	513	8.4259700808248583e-10
R421_515	421	515	1.1035972742772271e+03
C421_515	421	515	8.0230243616710863e-10
R422_425	422	425	2.5375044640885030e+03
C422_425	422	425	3.4893289617051043e-10
R422_426	422	426	5.6499360333951090e+03
C422_426	422	426	1.5671306302700604e-10
R422_495	422	495	6.2644291250347133e+03
C422_495	422	495	1.4134069745662477e-10
R422_497	422	497	2.6760209119677620e+03
C422_497	422	497	3.3087139855305695e-10
R422_513	422	513	1.2900476718838083e+03
C422_513	422	513	6.8634578473139393e-10
R422_515	422	515	4.5822835817291625e+03
C422_515	422	515	1.9322653561434100e-10
R422_516	422	516	1.8018688310494126e+03
C422_516	422	516	4.9138914356175989e-10
R423_424	423	424	7.6459752615759078e+02
C423_424	423	424	1.1580194172868757e-09
R423_425	423	425	1.9811689667239541e+03
C423_425	423	425	4.4691734858138921e-10
R423_463	423	463	9.4120184657794107e+02
C423_463	423	463	9.4073209154788708e-10
R423_481	423	481	1.0766030292575776e+03
C423_481	423	481	8.2241899533812570e-10
R423_483	423	483	1.6061500392006492e+03
C423_483	423	483	5.5126778949036190e-10
R423_517	423	517	1.6646765901988822e+03
C423_517	423	517	5.3188636574400155e-10
R424_425	424	425	1.4936321810434940e+03
C424_425	424	425	5.9279573173190554e-10
R424_428	424	428	1.2311036066264926e+03
C424_428	424	428	7.1920736559797071e-10
R424_482	424	482	2.6366554716385040e+03
C424_482	424	482	3.3581133038582850e-10
R424_483	424	483	3.5274834237818445e+03
C424_483	424	483	2.5100579515997707e-10
R424_517	424	517	7.0276893588104167e+02
C424_517	424	517	1.2599002837112821e-09
R425_426	425	426	5.2237553316044514e+03
C425_426	425	426	1.6949851696596361e-10
R425_428	425	428	4.4004696373887064e+03
C425_428	425	428	2.0121006498420437e-10
R425_481	425	481	6.1800526642254372e+03
C425_481	425	481	1.4327042661390847e-10
R425_515	425	515	2.6566815751720192e+03
C425_515	425	515	3.3327997979685222e-10
R425_516	425	516	4.7798070348250130e+03
C425_516	425	516	1.8524153281690269e-10
R425_517	425	517	2.2206419815414488e+03
C425_517	425	517	3.9872198628136822e-10
R425_518	425	518	6.3378586078904909e+03
C425_518	425	518	1.3970314525440399e-10
R426_428	426	428	7.4874559695240832e+03
C426_428	426	428	1.1825362116370201e-10
R426_495	426	495	5.6398218003947522e+03
C426_495	426	495	1.5699410602619151e-10
R426_516	426	516	6.8992443340573664e+03
C426_516	426	516	1.2833561747178990e-10
R426_518	426	518	4.4988851591104685e+03
C426_518	426	518	1.9680848707751130e-10
R427_487	427	487	7.4932376229832414e+02
C427_487	427	487	1.1816237870052935e-09
R427_511	427	511	1.0830978741661561e+03
C427_511	427	511	8.1748732300084778e-10
R427_512	427	512	2.1854380646140371e+03
C427_512	427	512	4.0514476069417733e-10
R427_513	427	513	1.7715980266084432e+03
C427_513	427	513	4.9978537365784420e-10
R427_514	427	514	1.4248211105150667e+03
C427_514	427	514	6.2142452492153551e-10
R427_515	427	515	1.8027266285577628e+03
C427_515	427	515	4.9115532420373831e-10
R427_519	427	519	4.7272648812597927e+03
C427_519	427	519	1.8730043776688905e-10
R428_482	428	482	4.6311808714946465e+03
C428_482	428	482	1.9118639635731698e-10
R428_517	428	517	3.0719038975654753e+03
C428_517	428	517	2.8823127650630814e-10
R428_518	428	518	5.4523736355310339e+03
C428_518	428	518	1.6239143552636679e-10
R428_520	428	520	9.2411439221278724e+03
C428_520	428	520	9.5812681759004871e-11
R429_500	429	500	5.6026142563951071e+03
C429_500	429	500	1.5803672021312874e-10
R429_502	429	502	3.5021794658763870e+03
C429_502	429	502	2.5281936300726739e-10
R429_507	429	507	1.5700522155992660e+03
C429_507	429	507	5.6394225166711957e-10
R429_508	429	508	5.7018573219795844e+03
C429_508	429	508	1.5528602904300632e-10
R429_509	429	509	5.0182842854784421e+03
C429_509	429	509	1.7643854579186801e-10
R429_521	429	521	8.4060078386729128e+03
C429_521	429	521	1.0533166262664161e-10
R430_431	430	431	2.7608838514086001e+03
C430_431	430	431	3.2070120633588421e-10
R430_449	430	449	3.7669990669131153e+03
C430_449	430	449	2.3504619087298064e-10
R430_452	430	452	3.7701332041644805e+03
C430_452	430	452	2.3485079538356054e-10
R430_453	430	453	3.1398679353002340e+03
C430_453	430	453	2.8199236399263915e-10
R430_522	430	522	6.6630360646932868e+03
C430_522	430	522	1.3288518523736335e-10
R431_449	431	449	4.0249054206082983e+03
C431_449	431	449	2.1998499074449894e-10
R431_450	431	450	5.6344775779767224e+03
C431_450	431	450	1.5714301271883737e-10
R431_433	431	433	5.3811390741877804e+03
C431_433	431	433	1.6454114444786836e-10
R431_452	431	452	4.4386434134975088e+03
C431_452	431	452	1.9947959302329233e-10
R431_451	431	451	5.2785643124564021e+03
C431_451	431	451	1.6773856095881623e-10
R431_522	431	522	2.6787562905077475e+03
C431_522	431	522	3.3053353335557536e-10
R431_529	431	529	6.4225368236224822e+03
C431_529	431	529	1.3786122306739854e-10
R432_433	432	433	2.0846107415433007e+03
C432_433	432	433	4.2474058300423874e-10
R432_434	432	434	1.7868092070371074e+03
C432_434	432	434	4.9553068017161400e-10
R432_435	432	435	2.7621271594768264e+03
C432_435	432	435	3.2055685005744160e-10
R432_439	432	439	5.2975622041535935e+03
C432_439	432	439	1.6713702408360221e-10
R432_443	432	443	7.7757732943131132e+03
C432_443	432	443	1.1386890386163386e-10
R432_452	432	452	4.2893458774987712e+03
C432_452	432	452	2.0642279895048020e-10
R432_528	432	528	2.4799744270890319e+03
C432_528	432	528	3.5702738384254043e-10
R432_529	432	529	4.3160936632392577e+03
C432_529	432	529	2.0514355127212116e-10
R432_530	432	530	1.9403102610820295e+03
C432_530	432	530	4.5632845398974453e-10
R433_435	433	435	3.8011682100907060e+03
C433_435	433	435	2.3293333332356568e-10
R433_452	433	452	2.6712188708700464e+03
C433_452	433	452	3.3146620494321720e-10
R433_529	433	529	9.7037332332277572e+02
C433_529	433	529	9.1245169299185589e-10
R433_451	433	451	5.5301125725637166e+03
C433_451	433	451	1.6010863614111328e-10
R433_530	433	530	3.0109787091798771e+03
C433_530	433	530	2.9406344820723365e-10
R433_531	433	531	3.6021428893480861e+03
C433_531	433	531	2.4580334786781392e-10
R434_435	434	435	4.0472019687489915e+03
C434_435	434	435	2.1877306557391480e-10
R434_437	434	437	1.9421170569281182e+03
C434_437	434	437	4.5590392120878807e-10
R434_436	434	436	2.3508482270843092e+03
C434_436	434	436	3.7663800304035796e-10
R434_439	434	439	1.6534750331943069e+03
C434_439	434	439	5.3548965900590697e-10
R434_441	434	441	3.2456973877798973e+03
C434_441	434	441	2.7279769982057353e-10
R434_523	434	523	3.1264391574194665e+03
C434_523	434	523	2.8320358629042265e-10
R434_525	434	525	4.1442607393813914e+03
C434_525	434	525	2.1364939065879466e-10
R434_527	434	527	1.4804105034873062e+03
C434_527	434	527	5.9809004300785300e-10
R434_528	434	528	1.8687670155143571e+03
C434_528	434	528	4.7379837847592714e-10
R434_530	434	530	2.7923593475090961e+03
C434_530	434	530	3.1708625986473821e-10
R434_532	434	532	3.5371781367653962e+03
C434_532	434	532	2.5031783740178802e-10
R435_437	435	437	3.4938929034079506e+03
C435_437	435	437	2.5341898168554645e-10
R435_438	435	438	3.3047190114992318e+03
C435_438	435	438	2.6792558720395337e-10
R435_530	435	530	8.7047423362046857e+02
C435_530	435	530	1.0171682831062951e-09
R435_531	435	531	4.9408616451857915e+03
C435_531	435	531	1.7920331417551878e-10
R435_532	435	532	1.6260667103424728e+03
C435_532	435	532	5.4451565613413150e-10
R435_533	435	533	3.0947260138260758e+03
C435_533	435	533	2.8610570943737204e-10
R436_437	436	437	4.2578668126283983e+03
C436_437	436	437	2.0794891448317224e-10
R436_441	436	441	1.4971489825428598e+03
C436_441	436	441	5.9140325513640226e-10
R436_445	436	445	3.9516139146029418e+03
C436_445	436	445	2.2406510373596733e-10
R436_447	436	447	4.0100315316257565e+03
C436_447	436	447	2.2080095249052354e-10
R436_525	436	525	1.4418637268239825e+03
C436_525	436	525	6.1407937881225916e-10
R436_526	436	526	3.8995534066957439e+03
C436_526	436	526	2.2705645733167500e-10
R436_527	436	527	3.1454013175911659e+03
C436_527	436	527	2.8149628371685107e-10
R436_534	436	534	4.5498470440608835e+03
C436_534	436	534	1.9460407638445259e-10
R437_438	437	438	5.3931085675855911e+03
C437_438	437	438	1.6417596097020313e-10
R437_527	437	527	3.9898280123163499e+03
C437_527	437	527	2.2191903484730860e-10
R437_532	437	532	1.7082186410027382e+03
C437_532	437	532	5.1832872001692483e-10
R437_534	437	534	5.9205866964438619e+03
C437_534	437	534	1.4954916245577782e-10
R437_535	437	535	8.9456960160130238e+03
C437_535	437	535	9.8977070103329908e-11
R438_532	438	532	5.9113179545341773e+03
C438_532	438	532	1.4978365036528859e-10
R438_533	438	533	7.8490880703907760e+03
C438_533	438	533	1.1280530601256440e-10
R438_535	438	535	7.5672962874253208e+03
C438_535	438	535	1.1700596198027989e-10
R438_536	438	536	2.3054513715520890e+04
C438_536	438	536	3.8405441668627064e-11
R439_440	439	440	3.6003026519190139e+03
C439_440	439	440	2.4592898633898432e-10
R439_441	439	441	1.7618750527406210e+03
C439_441	439	441	5.0254345807480445e-10
R439_442	439	442	5.0445192251106173e+03
C439_442	439	442	1.7552094504716344e-10
R439_443	439	443	1.1865416893332128e+03
C439_443	439	443	7.4621801295289392e-10
R439_523	439	523	4.1371728625072110e+03
C439_523	439	523	2.1401541852989395e-10
R439_528	439	528	7.5032391808382827e+03
C439_528	439	528	1.1800487234382401e-10
R439_537	439	537	6.6923238620244620e+03
C439_537	439	537	1.3230363621884798e-10
R440_442	440	442	6.9122040626551882e+02
C440_442	440	442	1.2809500033190335e-09
R440_443	440	443	2.3231530509602176e+03
C440_443	440	443	3.8112804549576882e-10
R440_444	440	444	1.3763806094689455e+03
C440_444	440	444	6.4329501273751944e-10
R440_454	440	454	2.7131639124187614e+03
C440_454	440	454	3.2634179514449498e-10
R440_537	440	537	2.8130562623977635e+03
C440_537	440	537	3.1475331422816837e-10
R441_442	441	442	1.5829693200984427e+03
C441_442	441	442	5.5934045622876461e-10
R441_445	441	445	1.9227191834250452e+03
C441_445	441	445	4.6050343145937463e-10
R441_447	441	447	1.0867969970800284e+03
C441_447	441	447	8.1470484743601181e-10
R441_523	441	523	4.7354575709173741e+03
C441_523	441	523	1.8697639424282131e-10
R441_525	441	525	3.1196621040280806e+03
C441_525	441	525	2.8381880863211275e-10
R441_537	441	537	3.6702436435924737e+03
C441_537	441	537	2.4124250804051325e-10
R442_446	442	446	1.9376245904304544e+03
C442_446	442	446	4.5696095418736366e-10
R442_447	442	447	1.6433446691148572e+03
C442_447	442	447	5.3879067388638987e-10
R442_454	442	454	3.4056055429327221e+03
C442_454	442	454	2.5998864828529903e-10
R442_537	442	537	1.2259751918678026e+03
C442_537	442	537	7.2221590418240297e-10
R443_444	443	444	3.3625183152494378e+03
C443_444	443	444	2.6332013648357429e-10
R443_452	443	452	1.9461744485562519e+03
C443_452	443	452	4.5495345104178014e-10
R443_523	443	523	2.3496997697005631e+03
C443_523	443	523	3.7682209153590483e-10
R443_528	443	528	5.1705949800231265e+03
C443_528	443	528	1.7124117923002353e-10
R443_524	443	524	5.9601358068646887e+03
C443_524	443	524	1.4855681319882071e-10
R443_537	443	537	4.7248999049143058e+03
C443_537	443	537	1.8739418813488258e-10
R443_538	443	538	3.5155568055042772e+03
C443_538	443	538	2.5185733887551112e-10
R444_452	444	452	2.4550642802919274e+03
C444_452	444	452	3.6064993849966180e-10
R444_453	444	453	2.2779733788376020e+03
C444_453	444	453	3.8868706277498691e-10
R444_454	444	454	2.5773583229223909e+03
C444_454	444	454	3.4353732417619362e-10
R444_455	444	455	2.6355340561582129e+03
C444_455	444	455	3.3595421756403508e-10
R444_466	444	466	1.4547494271866015e+03
C444_466	444	466	6.0864006209808049e-10
R444_474	444	474	2.1307736565756400e+03
C444_474	444	474	4.1553863732432005e-10
R444_537	444	537	2.9307220671982491e+03
C444_537	444	537	3.0211625715380595e-10
R444_538	444	538	1.5923124928216987e+03
C444_538	444	538	5.5605842803567453e-10
R444_539	444	539	9.2279348361655809e+02
C444_539	444	539	9.5949830316304242e-10
R445_446	445	446	4.3765114805872345e+03
C445_446	445	446	2.0231154096760094e-10
R445_447	445	447	8.0526355880823883e+02
C445_447	445	447	1.0995391161253937e-09
R445_448	445	448	1.9299658486325031e+03
C445_448	445	448	4.5877432615057545e-10
R445_498	445	498	4.4161471054269123e+03
C445_498	445	498	2.0049576260988389e-10
R445_526	445	526	4.5008101361199379e+03
C445_526	445	526	1.9672431293964841e-10
R445_544	445	544	4.3349719065411291e+03
C445_544	445	544	2.0425017757646210e-10
R446_447	446	447	1.4459579486677314e+03
C446_447	446	447	6.1234061648597882e-10
R446_448	446	448	1.1044598716276516e+03
C446_448	446	448	8.0167582765605707e-10
R446_454	446	454	1.7314076590547108e+03
C446_454	446	454	5.1138666106132881e-10
R446_484	446	484	1.5226977965937697e+03
C446_484	446	484	5.8148030665090336e-10
R446_499	446	499	3.3135273404883701e+03
C446_499	446	499	2.6721336229249315e-10
R446_537	446	537	2.8355844259864057e+03
C446_537	446	537	3.1225266071631503e-10
R446_545	446	545	1.2022478951915609e+03
C446_545	446	545	7.3646939640424263e-10
R447_448	447	448	1.9318561145489036e+03
C447_448	447	448	4.5832542860302462e-10
R447_525	447	525	1.9316306703235514e+03
C447_525	447	525	4.5837892062031233e-10
R447_526	447	526	5.3580368116373274e+03
C447_526	447	526	1.6525059696807693e-10
R447_537	447	537	1.2335443014992391e+03
C447_537	447	537	7.1778433950355068e-10
R447_543	447	543	3.2675913361653415e+03
C447_543	447	543	2.7096986452996197e-10
R447_544	447	544	2.5147451553263099e+03
C447_544	447	544	3.5209085891850909e-10
R447_545	447	545	5.6734301421194059e+03
C447_545	447	545	1.5606410223097184e-10
R448_498	448	498	1.1628914335186462e+03
C448_498	448	498	7.6139419053154703e-10
R448_499	448	499	3.3921487605675834e+03
C448_499	448	499	2.6102003308128777e-10
R448_501	448	501	3.3173420615193349e+03
C448_501	448	501	2.6690608483542404e-10
R448_542	448	542	1.3070600476211025e+03
C448_542	448	542	6.7741247489852883e-10
R448_544	448	544	1.8325178920884507e+03
C448_544	448	544	4.8317060669509863e-10
R448_543	448	543	3.5625690290379807e+03
C448_543	448	543	2.4853378965658790e-10
R448_545	448	545	2.0568808985287687e+03
C448_545	448	545	4.3046672383088200e-10
R449_450	449	450	1.1770307769666097e+03
C449_450	449	450	7.5224777382785268e-10
R449_453	449	453	2.1237495682894000e+03
C449_453	449	453	4.1691298961071541e-10
R449_460	449	460	2.3372550903772217e+03
C449_460	449	460	3.7882847505408474e-10
R449_462	449	462	4.3410167342247178e+03
C449_462	449	462	2.0396576099772422e-10
R449_467	449	467	1.8772748808848780e+03
C449_467	449	467	4.7165111018938600e-10
R449_469	449	469	1.9430283899615170e+03
C449_469	449	469	4.5569008990009467e-10
R449_470	449	470	1.0913506640589246e+03
C449_470	449	470	8.1130548673235072e-10
R449_522	449	522	1.7762728113475362e+03
C449_522	449	522	4.9847004133801583e-10
R449_547	449	547	2.6381901142157681e+03
C449_547	449	547	3.3561598799455768e-10
R450_467	450	467	1.1417957980992517e+03
C450_467	450	467	7.7546158706658178e-10
R450_468	450	468	4.8832314191767045e+03
C450_468	450	468	1.8131821036023694e-10
R450_451	450	451	3.2314482641485579e+03
C450_451	450	451	2.7400060571085637e-10
R450_522	450	522	3.6851165923448571e+03
C450_522	450	522	2.4026886518035624e-10
R450_547	450	547	1.7379621636836955e+03
C450_547	450	547	5.0945803090632994e-10
R450_548	450	548	3.0605998262709086e+03
C450_548	450	548	2.8929583479027076e-10
R451_522	451	522	3.1489012142209194e+03
C451_522	451	522	2.8118341016901817e-10
R451_529	451	529	2.2651111536058256e+03
C451_529	451	529	3.9089418649080597e-10
R451_531	451	531	5.2884571632843245e+03
C451_531	451	531	1.6742478086938362e-10
R451_547	451	547	4.2312721098157772e+03
C451_547	451	547	2.0925593030190389e-10
R451_548	451	548	5.4358481998011048e+03
C451_548	451	548	1.6288511914891169e-10
R451_551	451	551	2.0644919572148842e+03
C451_551	451	551	4.2887974380606443e-10
R451_552	451	552	7.7598534540168412e+03
C451_552	451	552	1.1410251326868400e-10
R452_453	452	453	3.0710739813405630e+03
C452_453	452	453	2.8830916711211999e-10
R452_466	452	466	6.0211931748900170e+03
C452_466	452	466	1.4705038619130056e-10
R452_522	452	522	1.7650746798693217e+03
C452_522	452	522	5.0163247583697279e-10
R452_528	452	528	5.3509904353154625e+03
C452_528	452	528	1.6546820488715769e-10
R452_524	452	524	2.3910534118039445e+03
C452_524	452	524	3.7030489462466276e-10
R452_529	452	529	2.8622460146151329e+03
C452_529	452	529	3.0934405260026411e-10
R452_538	452	538	4.6781523522865655e+03
C452_538	452	538	1.8926676923363329e-10
R452_558	452	558	4.7751913267900227e+03
C452_558	452	558	1.8542058759668500e-10
R453_466	453	466	7.9231381774219153e+02
C453_466	453	466	1.1175102110715729e-09
R453_469	453	469	1.2410349577666343e+03
C453_469	453	469	7.1345192668335395e-10
R453_473	453	473	2.6344390929599672e+03
C453_473	453	473	3.3609385165370187e-10
R453_474	453	474	1.4005896021461256e+03
C453_474	453	474	6.3217574965805230e-10
R453_522	453	522	1.9420701848154577e+03
C453_522	453	522	4.5591492450832084e-10
R453_558	453	558	3.0572995404773997e+03
C453_558	453	558	2.8960812310910867e-10
R454_455	454	455	2.1078485343690609e+03
C454_455	454	455	4.2005806739099090e-10
R454_457	454	457	2.3751678167159057e+03
C454_457	454	457	3.7278156746172577e-10
R454_484	454	484	3.3313194361965434e+03
C454_484	454	484	2.6578621433881666e-10
R454_537	454	537	2.0358581286136332e+03
C454_537	454	537	4.3491182870534683e-10
R454_539	454	539	2.0632025726535671e+03
C454_539	454	539	4.2914776931536489e-10
R454_541	454	541	1.0388475818160932e+03
C454_541	454	541	8.5230865162349261e-10
R454_545	454	545	3.5531181253441450e+03
C454_545	454	545	2.4919486222097977e-10
R454_560	454	560	4.3216828739499206e+03
C454_560	454	560	2.0487824014970985e-10
R455_457	455	457	2.4261221758872916e+03
C455_457	455	457	3.6495226435831947e-10
R455_458	455	458	2.2299992231175070e+03
C455_458	455	458	3.9704891935441902e-10
R455_474	455	474	3.5716937484700247e+03
C455_474	455	474	2.4789885249240059e-10
R455_490	455	490	6.2404612257696308e+03
C455_490	455	490	1.4188354829346803e-10
R455_539	455	539	5.1461547314141235e+03
C455_539	455	539	1.7205444218283228e-10
R455_560	455	560	2.3025393425736906e+03
C455_560	455	560	3.8454013155332779e-10
R456_458	456	458	1.4464451077035849e+03
C456_458	456	458	6.1213438172272895e-10
R456_471	456	471	5.9745493437578016e+03
C456_471	456	471	1.4819842146338353e-10
R456_488	456	488	3.8261934751078666e+03
C456_488	456	488	2.3140983002043265e-10
R456_490	456	490	5.2439369002433723e+03
C456_490	456	490	1.6884619295455434e-10
R456_492	456	492	1.8013422893224658e+03
C456_492	456	492	4.9153277916604626e-10
R456_511	456	511	5.5077731774686617e+03
C456_511	456	511	1.6075803290558397e-10
R456_512	456	512	5.3382169202449004e+03
C456_512	456	512	1.6586414432543888e-10
R456_561	456	561	3.0823945687453761e+03
C456_561	456	561	2.8725030555072354e-10
R457_458	457	458	1.8866479769532536e+03
C457_458	457	458	4.6930789024556781e-10
R457_484	457	484	6.1147815072925232e+03
C457_484	457	484	1.4479974151881707e-10
R457_486	457	486	3.2619127661952684e+03
C457_486	457	486	2.7144158816140342e-10
R457_488	457	488	2.3052270829277236e+03
C457_488	457	488	3.8409178351986282e-10
R457_540	457	540	3.6860788411529879e+03
C457_540	457	540	2.4020614312824778e-10
R457_541	457	541	7.8716019395183430e+03
C457_541	457	541	1.1248266725161386e-10
R457_560	457	560	4.4508779429061660e+03
C457_560	457	560	1.9893126548464120e-10
R457_561	457	561	7.1856049416218984e+03
C457_561	457	561	1.2322118859767817e-10
R458_488	458	488	4.0054405110317025e+03
C458_488	458	488	2.2105403369776621e-10
R458_490	458	490	2.9744210200955099e+03
C458_490	458	490	2.9767769112644608e-10
R458_560	458	560	5.9229645275459661e+03
C458_560	458	560	1.4948912450550357e-10
R458_561	458	561	2.1906966165996628e+03
C458_561	458	561	4.0417225050282046e-10
R459_461	459	461	8.3359380970411785e+03
C459_461	459	461	1.0621705336490893e-10
R459_462	459	462	6.4212780587684938e+03
C459_462	459	462	1.3788824803980072e-10
R459_468	459	468	9.1681873899573457e+03
C459_468	459	468	9.6575118291088894e-11
R459_556	459	556	2.6643594550437487e+04
C459_556	459	556	3.3231956747572617e-11
R459_563	459	563	7.4425654989501245e+03
C459_563	459	563	1.1896687799723099e-10
R460_461	460	461	6.0608540434543620e+03
C460_461	460	461	1.4608812146800334e-10
R460_462	460	462	2.5178865974754635e+03
C460_462	460	462	3.5165157262751914e-10
R460_467	460	467	5.4669957304451164e+03
C460_467	460	467	1.6195710136907504e-10
R460_470	460	470	1.6902109993109163e+03
C460_470	460	470	5.2385103520269199e-10
R460_469	460	469	4.1044646422771448e+03
C460_469	460	469	2.1572089392120388e-10
R460_473	460	473	2.6486767841845249e+03
C460_473	460	473	3.3428721351993994e-10
R460_478	460	478	2.0775058686028592e+03
C460_478	460	478	4.2619315549536900e-10
R460_557	460	557	2.2798418175760212e+03
C460_557	460	557	3.8836851525137706e-10
R460_562	460	562	3.9318380209052812e+03
C460_562	460	562	2.2519207988536059e-10
R460_564	460	564	7.9786763234790060e+03
C460_564	460	564	1.1097314213567744e-10
R461_462	461	462	3.6807460581202481e+03
C461_462	461	462	2.4055416149849314e-10
R461_478	461	478	8.1835242489783695e+03
C461_478	461	478	1.0819529028835416e-10
R461_480	461	480	7.8038460306635179e+03
C461_480	461	480	1.1345928382248183e-10
R461_563	461	563	1.1669829339260090e+04
C461_563	461	563	7.5872470450038207e-11
R461_564	461	564	5.3725007034355012e+03
C461_564	461	564	1.6480570791434423e-10
R462_467	462	467	1.2159249854462162e+03
C462_467	462	467	7.2818536694109643e-10
R462_468	462	468	2.6491064909136417e+03
C462_468	462	468	3.3423298940112855e-10
R462_562	462	562	2.7757222309611548e+03
C462_562	462	562	3.1898681064834236e-10
R462_563	462	563	3.5460830427409514e+03
C462_563	462	563	2.4968924050227939e-10
R462_564	462	564	8.9545596788757957e+03
C462_564	462	564	9.8879097739305081e-11
R463_464	463	464	2.6694432406172505e+03
C463_464	463	464	3.3168668590805720e-10
R463_465	463	465	1.1017346964818635e+04
C463_465	463	465	8.0365879782799046e-11
R463_481	463	481	2.7775121115457946e+03
C463_481	463	481	3.1878124960082708e-10
R463_483	463	483	7.2947174922285567e+03
C463_483	463	483	1.2137807703221995e-10
R463_565	463	565	7.3422227140391260e+03
C463_565	463	565	1.2059274366698021e-10
R464_465	464	465	1.3386696927350149e+03
C464_465	464	465	6.6141691748545914e-10
R464_481	464	481	1.3892575647191507e+03
C464_481	464	481	6.3733234512132714e-10
R464_489	464	489	1.2730268788351570e+03
C464_489	464	489	6.9552245629736793e-10
R464_491	464	491	2.9078192513396480e+03
C464_491	464	491	3.0449581117948886e-10
R464_512	464	512	4.3090653633693373e+03
C464_512	464	512	2.0547815060472298e-10
R464_565	464	565	3.6773862639445997e+03
C464_565	464	565	2.4077394055152729e-10
R465_476	465	476	3.4045567225310456e+03
C465_476	465	476	2.6006874135489629e-10
R465_491	465	491	2.4910424321224395e+03
C465_491	465	491	3.5544106767607254e-10
R465_489	465	489	4.3266682790792083e+03
C465_489	465	489	2.0464216912151002e-10
R465_565	465	565	5.0757378762779326e+03
C465_565	465	565	1.7444139222360367e-10
R465_566	465	566	4.5156826940955152e+03
C465_566	465	566	1.9607639457434198e-10
R466_469	466	469	2.7978134552910415e+03
C466_469	466	469	3.1646812621676191e-10
R466_473	466	473	4.1716347835166143e+03
C466_473	466	473	2.1224743479428167e-10
R466_474	466	474	1.1526516675849496e+03
C466_474	466	474	7.6815815792392911e-10
R466_538	466	538	2.3090181099799847e+03
C466_538	466	538	3.8346116813595498e-10
R466_539	466	539	2.8303071212223913e+03
C466_539	466	539	3.1283487755123671e-10
R466_558	466	558	1.0562029587811746e+03
C466_558	466	558	8.3830363694658247e-10
R466_559	466	559	1.7213019858504804e+03
C466_559	466	559	5.1438898518584013e-10
R466_567	466	567	1.8967782076048736e+03
C466_567	466	567	4.6680143105294761e-10
R467_468	467	468	9.5139270989185741e+02
C467_468	467	468	9.3065541967485085e-10
R467_470	467	470	1.3319497938485902e+03
C467_470	467	470	6.6475387119632700e-10
R467_547	467	547	1.7774033313610141e+03
C467_547	467	547	4.9815298873216742e-10
R467_548	467	548	4.2152503680382806e+03
C467_548	467	548	2.1005129100126540e-10
R467_553	467	553	4.6181317157599615e+03
C467_553	467	553	1.9172661937692164e-10
R467_562	467	562	2.8043522016874613e+03
C467_562	467	562	3.1573023572688819e-10
R467_568	467	568	2.3381877464810218e+03
C467_568	467	568	3.7867736798833092e-10
R468_548	468	548	5.1980619568534084e+03
C468_548	468	548	1.7033632708679356e-10
R468_553	468	553	5.0556044172193024e+03
C468_553	468	553	1.7513608831503488e-10
R468_555	468	555	4.9401582508105776e+03
C468_555	468	555	1.7922882967458003e-10
R468_562	468	562	5.6842465253700830e+03
C468_562	468	562	1.5576713250352094e-10
R468_563	468	563	4.2236292881385662e+03
C468_563	468	563	2.0963458705681554e-10
R468_556	468	556	5.1444253529251246e+03
C468_556	468	556	1.7211228095603533e-10
R468_568	468	568	2.8395252606411827e+03
C468_568	468	568	3.1181930091372630e-10
R469_470	469	470	8.8188522748746709e+02
C469_470	469	470	1.0040068186906817e-09
R469_473	469	473	1.4254238077107223e+03
C469_473	469	473	6.2116177442132926e-10
R469_522	469	522	3.3972119966005125e+03
C469_522	469	522	2.6063100642115118e-10
R469_547	469	547	3.3136427456520069e+03
C469_547	469	547	2.6720405597791178e-10
R469_549	469	549	3.9853145594530761e+03
C469_549	469	549	2.2217036283868903e-10
R469_557	469	557	1.1142201505653745e+03
C469_557	469	557	7.9465335575803689e-10
R469_558	469	558	2.2037986828582439e+03
C469_558	469	558	4.0176935787603127e-10
R469_559	469	559	1.4196664930065760e+03
C469_559	469	559	6.2368083353496373e-10
R469_571	469	571	1.6233981083454512e+03
C469_571	469	571	5.4541075115727997e-10
R470_547	470	547	2.6545140707903711e+03
C470_547	470	547	3.3355211465741835e-10
R470_557	470	557	3.0693244256728908e+03
C470_557	470	557	2.8847350716465524e-10
R470_562	470	562	5.6648588861152675e+03
C470_562	470	562	1.5630023615772445e-10
R470_568	470	568	6.0627064585026646e+03
C470_568	470	568	1.4604348532465087e-10
R470_569	470	569	5.0396873501937107e+03
C470_569	470	569	1.7568922835381194e-10
R470_571	470	571	4.0388883106750454e+03
C470_571	470	571	2.1922338861408484e-10
R471_472	471	472	2.8133437603494949e+03
C471_472	471	472	3.1472114932375232e-10
R471_475	471	475	2.1845173790829649e+03
C471_475	471	475	4.0531551278923158e-10
R471_477	471	477	6.9867920130994426e+03
C471_477	471	477	1.2672751386329241e-10
R471_490	471	490	3.1051964481513173e+03
C471_490	471	490	2.8514098752983414e-10
R471_492	471	492	3.3854149954823538e+03
C471_492	471	492	2.6153921539354604e-10
R471_572	471	572	7.8027999546736764e+03
C471_572	471	572	1.1347449464850846e-10
R472_473	472	473	3.9688511377265313e+03
C472_473	472	473	2.2309196061386991e-10
R472_474	472	474	4.7376153744190133e+03
C472_474	472	474	1.8689123361108252e-10
R472_477	472	477	6.2013571180918725e+03
C472_477	472	477	1.4277822819087049e-10
R472_490	472	490	6.2080113504586307e+03
C472_490	472	490	1.4262518731293685e-10
R472_574	472	574	8.4063797229881529e+03
C472_574	472	574	1.0532700292835058e-10
R473_474	473	474	2.1118305355633397e+03
C473_474	473	474	4.1926601911919554e-10
R473_477	473	477	6.9131182894889280e+03
C473_477	473	477	1.2807806038068780e-10
R473_478	473	478	4.3077762109965352e+03
C473_478	473	478	2.0553964234255626e-10
R473_557	473	557	1.3488275495509431e+03
C473_557	473	557	6.5643586683470184e-10
R473_559	473	559	2.2031363579056347e+03
C473_559	473	559	4.0189014108128331e-10
R473_574	473	574	1.6592380837316441e+03
C473_574	473	574	5.3362973667328309e-10
R474_490	474	490	3.4086544457009768e+03
C474_490	474	490	2.5975609901340911e-10
R474_539	474	539	3.6249424818864245e+03
C474_539	474	539	2.4425733266786266e-10
R474_559	474	559	3.0624581841167487e+03
C474_559	474	559	2.8912028457798058e-10
R474_560	474	560	4.2437287961315269e+03
C474_560	474	560	2.0864169795843805e-10
R474_567	474	567	4.5907179043143778e+03
C474_567	474	567	1.9287152906256326e-10
R474_574	474	574	4.3581347613693733e+03
C474_574	474	574	2.0316461747543387e-10
R474_575	474	575	4.2408839431106408e+03
C474_575	474	575	2.0878165815840632e-10
R475_476	475	476	2.5272994952257663e+03
C475_476	475	476	3.5034185041092826e-10
R475_477	475	477	5.6443739450651092e+03
C475_477	475	477	1.5686749147336773e-10
R475_479	475	479	2.6211798131479059e+03
C475_479	475	479	3.3779398775265871e-10
R475_491	475	491	3.0451084460331804e+03
C475_491	475	491	2.9076756949442064e-10
R475_492	475	492	3.8123786418466025e+03
C475_492	475	492	2.3224838476986366e-10
R475_572	475	572	3.8638692179414793e+03
C475_572	475	572	2.2915340343007701e-10
R475_578	475	578	5.3385946638384239e+03
C475_578	475	578	1.6585240825595628e-10
R476_479	476	479	1.1809913672339717e+04
C476_479	476	479	7.4972502447139870e-11
R476_491	476	491	4.2991437196762627e+03
C476_491	476	491	2.0595235689554348e-10
R476_566	476	566	9.0505739661705156e+03
C476_566	476	566	9.7830124919098234e-11
R476_578	476	578	7.2904567489156580e+03
C476_578	476	578	1.2144901371669097e-10
R477_478	477	478	2.9069431748531701e+03
C477_478	477	478	3.0458757823662061e-10
R477_479	477	479	7.9850422586257309e+03
C477_479	477	479	1.1088467074091422e-10
R477_480	477	480	1.1562939447319610e+04
C477_480	477	480	7.6573849213164204e-11
R477_490	477	490	1.0227037675232657e+04
C477_490	477	490	8.6576270648172581e-11
R477_572	477	572	6.6229334891601020e+03
C477_572	477	572	1.3368981934503560e-10
R477_574	477	574	3.9308101249403358e+03
C477_574	477	574	2.2525096699079040e-10
R477_576	477	576	9.4025794002554321e+03
C477_576	477	576	9.4167647409172297e-11
R477_577	477	577	3.1728828573035698e+03
C477_577	477	577	2.7905813782626101e-10
R477_578	477	578	7.3309831339459888e+03
C477_578	477	578	1.2077763180221819e-10
R477_579	477	579	3.5294484293257287e+03
C477_579	477	579	2.5086604874097906e-10
R478_480	478	480	3.9665857244236199e+03
C478_480	478	480	2.2321937384289337e-10
R478_557	478	557	6.8261378629174651e+03
C478_557	478	557	1.2971006438501307e-10
R478_562	478	562	1.3068463608336455e+04
C478_562	478	562	6.7752324086144731e-11
R478_564	478	564	3.1855487470851599e+03
C478_564	478	564	2.7794858970850019e-10
R478_573	478	573	3.6193886492930760e+03
C478_573	478	573	2.4463213749452858e-10
R478_574	478	574	7.1086489844921643e+03
C478_574	478	574	1.2455514171983742e-10
R478_577	478	577	1.0282097954809849e+04
C478_577	478	577	8.6112657707740569e-11
R478_579	478	579	4.7210813434500224e+03
C478_579	478	579	1.8754575854288565e-10
R479_480	479	480	8.8221883367200371e+03
C479_480	479	480	1.0036271590515446e-10
R479_578	479	578	7.0869657700291609e+03
C479_578	479	578	1.2493622947135481e-10
R479_579	479	579	1.2395314075370821e+04
C479_579	479	579	7.1431734308314550e-11
R480_564	480	564	7.8091560379619050e+03
C480_564	480	564	1.1338213468853718e-10
R480_579	480	579	4.4908344563380588e+03
C480_579	480	579	1.9716130494420255e-10
R481_483	481	483	3.1668404106832841e+03
C481_483	481	483	2.7959059089717757e-10
R481_489	481	489	1.7112330982470651e+03
C481_489	481	489	5.1741564758594019e-10
R481_515	481	515	4.0651738821607764e+03
C481_515	481	515	2.1780588170791111e-10
R481_517	481	517	3.7358590904254270e+03
C481_517	481	517	2.3700540097168697e-10
R481_565	481	565	2.0774256910567888e+03
C481_565	481	565	4.2620960427690985e-10
R481_580	481	580	2.8883640657156907e+03
C481_580	481	580	3.0654680696583420e-10
R482_483	482	483	7.2867863755883373e+03
C482_483	482	483	1.2151018790207242e-10
R482_517	482	517	4.3931055763021313e+03
C482_517	482	517	2.0154734875397548e-10
R482_520	482	520	1.3997550181590237e+04
C482_520	482	520	6.3255267544210304e-11
R482_581	482	581	1.0674048457693885e+04
C482_581	482	581	8.2950605406122871e-11
R483_517	483	517	2.5791074169175918e+03
C483_517	483	517	3.4330434470938169e-10
R483_565	483	565	8.0993596426955592e+03
C483_565	483	565	1.0931960312424434e-10
R483_580	483	580	5.0606911119258011e+03
C483_580	483	580	1.7496005231646350e-10
R483_581	483	581	9.2801665527841669e+03
C483_581	483	581	9.5409794281586815e-11
R483_583	483	583	1.3185666015573343e+04
C483_583	483	583	6.7150099255831940e-11
R484_486	484	486	4.1274705580886466e+03
C484_486	484	486	2.1451849728275732e-10
R484_499	484	499	2.3379335085309563e+03
C484_499	484	499	3.7871854715678136e-10
R484_494	484	494	5.0047656852661366e+03
C484_494	484	494	1.7691513197244046e-10
R484_510	484	510	3.9081216460702076e+03
C484_510	484	510	2.2655865448567305e-10
R484_540	484	540	2.6616080016353817e+03
C484_540	484	540	3.3266310484337629e-10
R484_541	484	541	5.4845072163611048e+03
C484_541	484	541	1.6143998845669550e-10
R484_545	484	545	2.1900743874428726e+03
C484_545	484	545	4.0428708119536235e-10
R484_584	484	584	3.6108978395351219e+03
C484_584	484	584	2.4520737529754975e-10
R485_486	485	486	1.6231280737214429e+03
C485_486	485	486	5.4550148939876796e-10
R485_487	485	487	1.2447020318534153e+03
C485_487	485	487	7.1134999304337386e-10
R485_488	485	488	1.7706359943805980e+03
C485_488	485	488	5.0005691994855015e-10
R485_493	485	493	2.1597538921994369e+03
C485_493	485	493	4.0996281330847037e-10
R485_585	485	585	5.9184666855230098e+03
C485_585	485	585	1.4960273137395492e-10
R486_488	486	488	1.0372430410110171e+03
C486_488	486	488	8.5362711215393492e-10
R486_493	486	493	4.1579921649345415e+03
C486_493	486	493	2.1294383119982118e-10
R486_510	486	510	1.4038016647064553e+03
C486_510	486	510	6.3072925753022746e-10
R486_540	486	540	2.6964573763762119e+03
C486_540	486	540	3.2836372251131984e-10
R486_585	486	585	2.5733243477878136e+03
C486_585	486	585	3.4407585754246644e-10
R487_488	487	488	2.6992912967454135e+03
C487_488	487	488	3.2801898141470170e-10
R487_493	487	493	2.5353931160272755e+03
C487_493	487	493	3.4922346996325706e-10
R487_511	487	511	1.1670359294669067e+03
C487_511	487	511	7.5869025052592233e-10
R487_513	487	513	1.3896480573525084e+03
C487_513	487	513	6.3715325403099404e-10
R487_514	487	514	1.3036266197857283e+03
C487_514	487	514	6.7919661064111490e-10
R487_585	487	585	2.9717642808614669e+03
C487_585	487	585	2.9794381317596671e-10
R488_511	488	511	2.5474907148903653e+03
C488_511	488	511	3.4756506727370160e-10
R488_540	488	540	6.3647662698042523e+03
C488_540	488	540	1.3911253676362115e-10
R488_561	488	561	3.0787969581300372e+03
C488_561	488	561	2.8758596092604139e-10
R488_585	488	585	2.5760875930200232e+03
C488_585	488	585	3.4370678392266838e-10
R489_491	489	491	1.6791223304885489e+03
C489_491	489	491	5.2731046786947509e-10
R489_512	489	512	1.1495656442202103e+03
C489_512	489	512	7.7022028811639549e-10
R489_515	489	515	4.8356727679547994e+03
C489_515	489	515	1.8310146781798869e-10
R489_519	489	519	4.9534509078269130e+03
C489_519	489	519	1.7874786652290344e-10
R489_565	489	565	1.3411599182569287e+03
C489_565	489	565	6.6018881838547351e-10
R489_566	489	566	2.9374165036806207e+03
C489_566	489	566	3.0142772759346823e-10
R489_580	489	580	3.0712148389455683e+03
C489_580	489	580	2.8829594415608791e-10
R489_582	489	582	9.1582674845666713e+02
C489_582	489	582	9.6679724979870908e-10
R489_589	489	589	4.3257482069070820e+03
C489_589	489	589	2.0468569582626634e-10
R490_492	490	492	1.6493679058620266e+03
C490_492	490	492	5.3682309359429676e-10
R490_560	490	560	2.4140310307135360e+03
C490_560	490	560	3.6678019894313006e-10
R490_561	490	561	1.4700116538093971e+03
C490_561	490	561	6.0232092678008392e-10
R490_572	490	572	2.3612332399755660e+03
C490_572	490	572	3.7498149979845377e-10
R490_574	490	574	3.0012349323645544e+03
C490_574	490	574	2.9501815141223001e-10
R490_575	490	575	4.0875960442118721e+03
C490_575	490	575	2.1661112598290453e-10
R490_576	490	576	8.4113963815992486e+02
C490_576	490	576	1.0526418462895651e-09
R490_590	490	590	4.1967148708505101e+03
C490_590	490	590	2.1097901786226431e-10
R491_492	491	492	2.7461352096201294e+03
C491_492	491	492	3.2242359320045260e-10
R491_512	491	512	1.9404443927831505e+03
C491_512	491	512	4.5629691064223554e-10
R491_566	491	566	1.7714980388749746e+03
C491_566	491	566	4.9981358278121674e-10
R491_572	491	572	2.2807812952833792e+03
C491_572	491	572	3.8820854219167475e-10
R491_578	491	578	6.4717639433695322e+03
C491_578	491	578	1.3681258918708425e-10
R491_589	491	589	3.1054970189803153e+03
C491_589	491	589	2.8511338967271846e-10
R491_590	491	590	4.4350541460787254e+03
C491_590	491	590	1.9964103087283559e-10
R492_512	492	512	2.7391054644875817e+03
C492_512	492	512	3.2325107345424539e-10
R492_561	492	561	2.2527066415929103e+03
C492_561	492	561	3.9304664235992672e-10
R492_572	492	572	1.5047645064888557e+03
C492_572	492	572	5.8841019832797175e-10
R492_590	492	590	1.7630521521051230e+03
C492_590	492	590	5.0220793562050371e-10
R493_496	493	496	3.1140757976980126e+03
C493_496	493	496	2.8432794807195108e-10
R493_497	493	497	2.7341295998743099e+03
C493_497	493	497	3.2383936070210546e-10
R493_503	493	503	1.8040186472532077e+03
C493_503	493	503	4.9080356405857309e-10
R493_505	493	505	3.1394716521159007e+03
C493_505	493	505	2.8202795878193614e-10
R493_510	493	510	3.0872256086117209e+03
C493_510	493	510	2.8680080238715037e-10
R493_513	493	513	2.1955431817806648e+03
C493_513	493	513	4.0328005800454970e-10
R493_514	493	514	2.1596562869424743e+03
C493_514	493	514	4.0998134150019248e-10
R493_585	493	585	2.2656118927206712e+03
C493_585	493	585	3.9080779216635397e-10
R493_586	493	586	1.6456970752544903e+03
C493_586	493	586	5.3802051119467356e-10
R493_587	493	587	1.3760050060320207e+03
C493_587	493	587	6.4347061080342882e-10
R493_591	493	591	1.5916326697735383e+03
C493_591	493	591	5.5629593342412345e-10
R494_499	494	499	1.2509333492932169e+03
C494_499	494	499	7.0780652078727108e-10
R494_500	494	500	3.5852233953653135e+03
C494_500	494	500	2.4696335041342128e-10
R494_505	494	505	1.4506909088930254e+03
C494_505	494	505	6.1034282097737421e-10
R494_506	494	506	9.6400142057781284e+02
C494_506	494	506	9.1848285987928202e-10
R494_507	494	507	5.2257241100698293e+03
C494_507	494	507	1.6943465882437649e-10
R494_510	494	510	1.5350211865772437e+03
C494_510	494	510	5.7681209187365487e-10
R494_584	494	584	2.7560149642880770e+03
C494_584	494	584	3.2126777001325827e-10
R494_592	494	592	4.6171461375407762e+03
C494_592	494	592	1.9176754543264234e-10
R495_496	495	496	3.0624750415685503e+03
C495_496	495	496	2.8911869310990451e-10
R495_497	495	497	1.1381854152908240e+03
C495_497	495	497	7.7792139119421205e-10
R495_504	495	504	1.0152508217289860e+04
C495_504	495	504	8.7211826156625986e-11
R495_516	495	516	1.7635540547241392e+03
C495_516	495	516	5.0206500862742179e-10
R495_518	495	518	7.6243701426748130e+03
C495_518	495	518	1.1613008879830874e-10
R495_588	495	588	9.0544189580628245e+03
C495_588	495	588	9.7788581001274279e-11
R495_593	495	593	4.8984656427397504e+03
C495_593	495	593	1.8075431089576414e-10
R496_497	496	497	1.4199442526172400e+03
C496_497	496	497	6.2355883343166240e-10
R496_503	496	503	1.6453874036040436e+03
C496_503	496	503	5.3812176984009092e-10
R496_504	496	504	1.5305146365595340e+03
C496_504	496	504	5.7851049611021394e-10
R496_586	496	586	2.0723808954190490e+03
C496_586	496	586	4.2724712607474715e-10
R496_593	496	593	7.2171520148860573e+03
C496_593	496	593	1.2268257338542133e-10
R497_513	497	513	3.7793261019424413e+03
C497_513	497	513	2.3427954027172352e-10
R497_516	497	516	2.1278913738948581e+03
C497_516	497	516	4.1610149491763947e-10
R497_586	497	586	5.0295559080248358e+03
C497_586	497	586	1.7604313340811717e-10
R497_587	497	587	2.1885102944731611e+03
C497_587	497	587	4.0457601864429266e-10
R497_593	497	593	5.2985979516188681e+03
C497_593	497	593	1.6710435284667713e-10
R498_501	498	501	4.6415950121029800e+03
C498_501	498	501	1.9075743992986604e-10
R498_542	498	542	1.9973153544259524e+03
C498_542	498	542	4.4330444851282788e-10
R498_544	498	544	2.0698981385244929e+03
C498_544	498	544	4.2775959126721197e-10
R498_526	498	526	6.2036650293248194e+03
C498_526	498	526	1.4272511128737801e-10
R498_550	498	550	4.9939852580163915e+03
C498_550	498	550	1.7729703552462788e-10
R498_596	498	596	6.3914543968154612e+03
C498_596	498	596	1.3853165910737931e-10
R499_500	499	500	1.9137402057936788e+03
C499_500	499	500	4.6266404343675971e-10
R499_501	499	501	1.4072240933164460e+03
C499_501	499	501	6.2919529725596709e-10
R499_506	499	506	2.1046327017636481e+03
C499_506	499	506	4.2069990690443674e-10
R499_542	499	542	2.9836957163002207e+03
C499_542	499	542	2.9675237218824659e-10
R499_545	499	545	3.5744349412251140e+03
C499_545	499	545	2.4770874173374341e-10
R499_584	499	584	1.5011428617715383e+03
C499_584	499	584	5.8982979185278481e-10
R499_597	499	597	1.4905510966246393e+03
C499_597	499	597	5.9402108636532845e-10
R500_501	500	501	4.1370076982634600e+03
C500_501	500	501	2.1402396279602315e-10
R500_506	500	506	1.9353943026629456e+03
C500_506	500	506	4.5748754167651296e-10
R500_507	500	507	2.7073020713615456e+03
C500_507	500	507	3.2704838926773649e-10
R500_521	500	521	4.0949440663149362e+03
C500_521	500	521	2.1622243609710489e-10
R500_595	500	595	4.3008093576999554e+03
C500_595	500	595	2.0587259468146163e-10
R500_597	500	597	3.5212801394307812e+03
C500_597	500	597	2.5144798102974251e-10
R501_542	501	542	2.4342583930740307e+03
C501_542	501	542	3.6373245511618648e-10
R501_596	501	596	4.4000964370979445e+03
C501_596	501	596	2.0122713089533386e-10
R501_597	501	597	1.3330624728458918e+03
C501_597	501	597	6.6419901522676691e-10
R501_595	501	595	6.2407495812856750e+03
C501_595	501	595	1.4187699252588700e-10
R502_503	502	503	1.3790170473462142e+03
C502_503	502	503	6.4206514589787221e-10
R502_504	502	504	2.7818642541193435e+03
C502_504	502	504	3.1828252596757197e-10
R502_505	502	505	2.2747164676768748e+03
C502_505	502	505	3.8924358014793005e-10
R502_507	502	507	2.8700918844083512e+03
C502_507	502	507	3.0849840958402728e-10
R502_508	502	508	1.3397527814382770e+03
C502_508	502	508	6.6088221197754733e-10
R502_598	502	598	3.2574491493574210e+03
C502_598	502	598	2.7181353909228691e-10
R503_504	503	504	3.1780738779552453e+03
C503_504	503	504	2.7860232823463293e-10
R503_505	503	505	1.0711633835400182e+03
C503_505	503	505	8.2659545248254967e-10
R503_586	503	586	1.5754610565086050e+03
C503_586	503	586	5.6200613657958994e-10
R503_598	503	598	3.6618937105145087e+03
C503_598	503	598	2.4179259467790386e-10
R504_508	504	508	5.1785585296195795e+03
C504_508	504	508	1.7097784579158626e-10
R504_586	504	586	2.2544191635005523e+03
C504_586	504	586	3.9274807277860664e-10
R504_593	504	593	5.3647236163440975e+03
C504_593	504	593	1.6504462205704219e-10
R504_598	504	598	4.7110477173893132e+03
C504_598	504	598	1.8794519495775057e-10
R504_599	504	599	5.0712810378521999e+03
C504_599	504	599	1.7459469808342442e-10
R505_507	505	507	3.4076793922460715e+03
C505_507	505	507	2.5983042410465800e-10
R505_506	505	506	4.3927065766994147e+03
C505_506	505	506	2.0156565576143825e-10
R505_510	505	510	1.6411233299648850e+03
C505_510	505	510	5.3951995290868550e-10
R505_586	505	586	4.1103443140928621e+03
C505_586	505	586	2.1541231440495724e-10
R505_591	505	591	4.3281409034586086e+03
C505_591	505	591	2.0457254083213040e-10
R505_592	505	592	2.6635752629075910e+03
C505_592	505	592	3.3241740679535602e-10
R505_598	505	598	1.2470147042366332e+03
C505_598	505	598	7.1003074678418814e-10
R505_600	505	600	5.6992997009844375e+03
C505_600	505	600	1.5535571529025960e-10
R506_507	506	507	3.0505304742298540e+03
C506_507	506	507	2.9025075775502146e-10
R506_521	506	521	7.8537038778665919e+03
C506_521	506	521	1.1273900766685364e-10
R506_584	506	584	2.9198474782632261e+03
C506_584	506	584	3.0324144952484360e-10
R506_592	506	592	3.1529795022349754e+03
C506_592	506	592	2.8081970754087519e-10
R506_594	506	594	2.2380717525310970e+03
C506_594	506	594	3.9561679856718425e-10
R506_595	506	595	5.6787622798438524e+03
C506_595	506	595	1.5591756408657878e-10
R506_597	506	597	2.9399879421492947e+03
C506_597	506	597	3.0116408608557418e-10
R506_600	506	600	2.9972829333398990e+03
C506_600	506	600	2.9540714086453293e-10
R506_601	506	601	5.2815262534261465e+03
C506_601	506	601	1.6764449123501480e-10
R507_508	507	508	4.8218039868435853e+03
C507_508	507	508	1.8362811597399806e-10
R507_509	507	509	5.7171614712364217e+03
C507_509	507	509	1.5487034713898240e-10
R507_521	507	521	1.9524096136901107e+03
C507_521	507	521	4.5350052340017562e-10
R507_598	507	598	4.9086097154248955e+03
C507_598	507	598	1.8038076625192782e-10
R507_600	507	600	2.5951423321053967e+03
C507_600	507	600	3.4118312924350248e-10
R507_601	507	601	5.5990122833481373e+03
C507_601	507	601	1.5813838886071008e-10
R507_602	507	602	3.9410400823544192e+03
C507_602	507	602	2.2466627164345949e-10
R508_509	508	509	5.7454052610620756e+03
C508_509	508	509	1.5410902129057554e-10
R508_598	508	598	5.1051068878622700e+03
C508_598	508	598	1.7343785373135713e-10
R508_599	508	599	9.2688966644065349e+03
C508_599	508	599	9.5525801371817457e-11
R508_602	508	602	5.9733183130344341e+03
C508_602	508	602	1.4822896341685314e-10
R509_521	509	521	5.4201761078634327e+03
C509_521	509	521	1.6335609103465485e-10
R509_602	509	602	5.4004810578017041e+03
C509_602	509	602	1.6395183544267717e-10
R509_603	509	603	1.5467288458238445e+04
C509_603	509	603	5.7244602639345843e-11
R510_540	510	540	2.6509928748320999e+03
C510_540	510	540	3.3399515709980094e-10
R510_584	510	584	3.4541210804165007e+03
C510_584	510	584	2.5633692655418884e-10
R510_585	510	585	2.4836400173814777e+03
C510_585	510	585	3.5650044914057413e-10
R510_591	510	591	2.7193263920746026e+03
C510_591	510	591	3.2560224630648506e-10
R510_592	510	592	3.2351114685789980e+03
C510_592	510	592	2.7369034739594757e-10
R510_605	510	605	2.2385158077763754e+03
C510_605	510	605	3.9553831991006967e-10
R511_512	511	512	1.2455993216180466e+03
C511_512	511	512	7.1083755934438997e-10
R511_514	511	514	1.4494156320236991e+03
C511_514	511	514	6.1087983469845922e-10
R511_519	511	519	6.3681798452495377e+03
C511_519	511	519	1.3903796739668003e-10
R511_561	511	561	3.0515861288880956e+03
C511_561	511	561	2.9015034945863364e-10
R511_585	511	585	1.8268128940555455e+03
C511_585	511	585	4.8467951183241331e-10
R511_606	511	606	2.3970533366475079e+03
C511_606	511	606	3.6937800597225628e-10
R511_607	511	607	2.5506972661923223e+03
C511_607	511	607	3.4712813372076579e-10
R512_515	512	515	1.5628012710925657e+04
C512_515	512	515	5.6655878010708124e-11
R512_519	512	519	9.3212568196345619e+03
C512_519	512	519	9.4989205729738995e-11
R512_561	512	561	1.0240415736563302e+04
C512_561	512	561	8.6463167558580751e-11
R512_582	512	582	7.1813458996116960e+03
C512_582	512	582	1.2329426740854743e-10
R512_589	512	589	1.0144024434631476e+04
C512_589	512	589	8.7284764287160020e-11
R512_590	512	590	4.9225521957366673e+03
C512_590	512	590	1.7986986150534776e-10
R512_606	512	606	1.1414987694962016e+04
C512_606	512	606	7.7566336938828076e-11
R512_607	512	607	6.7286005456308239e+03
C512_607	512	607	1.3159033229799044e-10
R512_608	512	608	8.2116768497895409e+03
C512_608	512	608	1.0782435766730063e-10
R513_514	513	514	1.4345808500091080e+03
C513_514	513	514	6.1719685000282723e-10
R513_515	513	515	1.5255371160042971e+03
C513_515	513	515	5.8039805941863805e-10
R513_516	513	516	2.2212190388139802e+03
C513_516	513	516	3.9861840107978241e-10
R513_587	513	587	1.6935394413853303e+03
C513_587	513	587	5.2282147085734220e-10
R513_609	513	609	4.7806028138592919e+03
C513_609	513	609	1.8521069751561684e-10
R514_515	514	515	7.5516930264876237e+03
C514_515	514	515	1.1724771896770523e-10
R514_519	514	519	6.2298059767791556e+03
C514_519	514	519	1.4212622110548726e-10
R514_585	514	585	2.6648712967533734e+03
C514_585	514	585	3.3225573887140836e-10
R514_587	514	587	2.9219230715020312e+03
C514_587	514	587	3.0302604142307059e-10
R514_591	514	591	3.3440940653733755e+03
C514_591	514	591	2.6477089591112958e-10
R514_606	514	606	2.7312084156187120e+03
C514_606	514	606	3.2418572549668368e-10
R514_609	514	609	3.8427745045687066e+03
C514_609	514	609	2.3041132927454323e-10
R515_516	515	516	4.3147755167695550e+03
C515_516	515	516	2.0520622179735265e-10
R515_517	515	517	8.3280633262181527e+03
C515_517	515	517	1.0631748907486715e-10
R515_519	515	519	2.6364023832350590e+03
C515_519	515	519	3.3584356748059317e-10
R515_580	515	580	5.5454919810596921e+03
C515_580	515	580	1.5966460410078980e-10
R515_609	515	609	6.4899250711284776e+03
C515_609	515	609	1.3642973870976331e-10
R515_610	515	610	4.5481390942747639e+03
C515_610	515	610	1.9467715550181234e-10
R516_517	516	517	1.5031987045622451e+04
C516_517	516	517	5.8902311385230194e-11
R516_518	516	518	2.7860788525659696e+03
C516_518	516	518	3.1780104891307454e-10
R516_587	516	587	4.6702161739551566e+03
C516_587	516	587	1.8958839349617264e-10
R516_588	516	588	3.1160523040207913e+03
C516_588	516	588	2.8414759937036424e-10
R516_593	516	593	1.2674541822051395e+04
C516_593	516	593	6.9858050423529518e-11
R516_609	516	609	5.5326139059080488e+03
C516_609	516	609	1.6003624990973944e-10
R516_610	516	610	5.3110581284699292e+03
C516_610	516	610	1.6671231236459498e-10
R517_518	517	518	6.2030114363029288e+03
C517_518	517	518	1.4274014981144716e-10
R517_520	517	520	2.3775110743379328e+03
C517_520	517	520	3.7241415666026426e-10
R517_580	517	580	3.3082204791260792e+03
C517_580	517	580	2.6764201095021879e-10
R517_581	517	581	8.6767357820521120e+03
C517_581	517	581	1.0204514738497568e-10
R517_610	517	610	4.8556372246182646e+03
C517_610	517	610	1.8234862711960717e-10
R518_520	518	520	5.1747092097302248e+03
C518_520	518	520	1.7110503137743654e-10
R518_588	518	588	5.2178366559314100e+03
C518_588	518	588	1.6969078184797037e-10
R518_610	518	610	6.2055402687142550e+03
C518_610	518	610	1.4268198148095377e-10
R519_580	519	580	2.8237996655228199e+03
C519_580	519	580	3.1355580656465114e-10
R519_582	519	582	5.0365348166324229e+03
C519_582	519	582	1.7579919804704483e-10
R519_606	519	606	4.1992075622055409e+03
C519_606	519	606	2.1085377861982928e-10
R519_609	519	609	3.0572936483734429e+03
C519_609	519	609	2.8960868125018512e-10
R519_610	519	610	4.1140655361806657e+03
C519_610	519	610	2.1521747135851107e-10
R519_611	519	611	3.3348612594782312e+03
C519_611	519	611	2.6550393338958028e-10
R520_580	520	580	6.5988952069629049e+03
C520_580	520	580	1.3417682110874250e-10
R520_581	520	581	6.8825191866217037e+03
C520_581	520	581	1.2864748469151879e-10
R520_610	520	610	2.4326388492420665e+03
C520_610	520	610	3.6397461216894925e-10
R520_588	520	588	9.9410111000293891e+03
C520_588	520	588	8.9067276234847239e-11
R520_612	520	612	5.4973811824417608e+03
C520_612	520	612	1.6106192245281515e-10
R521_595	521	595	1.2282357070399492e+04
C521_595	521	595	7.2088669676756210e-11
R521_601	521	601	3.6324576738677224e+03
C521_601	521	601	2.4375198865214443e-10
R521_602	521	602	1.4568496462271012e+04
C521_602	521	602	6.0776263631118493e-11
R521_603	521	603	1.2390204279140520e+04
C521_603	521	603	7.1461193193613696e-11
R521_614	521	614	1.8763083828114224e+04
C521_614	521	614	4.7189406059856037e-11
R522_529	522	529	6.0055066266497770e+03
C522_529	522	529	1.4743448583853093e-10
R522_524	522	524	1.0885438430791675e+04
C522_524	522	524	8.1339744589011036e-11
R522_547	522	547	7.7158093192436909e+03
C522_547	522	547	1.1475384435586201e-10
R522_549	522	549	7.9356260734629859e+03
C522_549	522	549	1.1157516413996269e-10
R522_551	522	551	1.4271582728646064e+04
C522_551	522	551	6.2040685923557637e-11
R522_558	522	558	5.8597738159319661e+03
C522_558	522	558	1.5110118743707499e-10
R522_616	522	616	1.1771054398499575e+04
C522_616	522	616	7.5220005933611353e-11
R523_525	523	525	3.2691473701026739e+03
C523_525	523	525	2.7084088952288243e-10
R523_527	523	527	9.5367251887408001e+03
C523_527	523	527	9.2843063439149803e-11
R523_528	523	528	3.0636713318810939e+03
C523_528	523	528	2.8900579918158287e-10
R523_524	523	524	4.9063821108450184e+03
C523_524	523	524	1.8046266305734301e-10
R523_537	523	537	3.0636713318810926e+03
C523_537	523	537	2.8900579918158298e-10
R523_538	523	538	3.4492838821658302e+03
C523_538	523	538	2.5669640770305027e-10
R523_615	523	615	4.9820380481566272e+03
C523_615	523	615	1.7772220387349473e-10
R523_617	523	617	3.5590418718586402e+03
C523_617	523	617	2.4878009688534723e-10
R523_619	523	619	1.0724887818536519e+04
C523_619	523	619	8.2557393296895218e-11
R524_528	524	528	2.6802335110487597e+03
C524_528	524	528	3.3035135858499911e-10
R524_529	524	529	7.0249764126988839e+03
C524_529	524	529	1.2603868393058936e-10
R524_538	524	538	3.4280595583113409e+03
C524_538	524	538	2.5828570555412301e-10
R524_558	524	558	2.6802335110487616e+03
C524_558	524	558	3.3035135858499890e-10
R524_616	524	616	1.8249793518135975e+03
C524_616	524	616	4.8516646548362496e-10
R524_617	524	617	6.3142634594757992e+03
C524_617	524	617	1.4022518816050579e-10
R524_619	524	619	3.8712456805975876e+03
C524_619	524	619	2.2871676322111436e-10
R524_620	524	620	1.1622098697205796e+04
C524_620	524	620	7.6184070086487380e-11
R525_526	525	526	2.3672629011430868e+03
C525_526	525	526	3.7402638349650776e-10
R525_527	525	527	1.7058275923333124e+03
C525_527	525	527	5.1905525838568573e-10
R525_534	525	534	5.2335156968658157e+03
C525_534	525	534	1.6918240681503045e-10
R525_537	525	537	3.5710307184383687e+03
C525_537	525	537	2.4794487964729644e-10
R525_543	525	543	5.6183850193861108e+03
C525_543	525	543	1.5759311237034885e-10
R525_544	525	544	2.3842856493383356e+03
C525_544	525	544	3.7135600004375022e-10
R525_615	525	615	2.0692224879898818e+03
C525_615	525	615	4.2789926498437003e-10
R525_617	525	617	3.5618826837940633e+03
C525_617	525	617	2.4858168005602740e-10
R525_622	525	622	2.9032961653751208e+03
C525_622	525	622	3.0497018948998582e-10
R526_534	526	534	7.8200132799631674e+03
C526_534	526	534	1.1322471586700048e-10
R526_544	526	544	2.0291380940174292e+03
C526_544	526	544	4.3635215578008594e-10
R526_550	526	550	7.2195397744780103e+03
C526_550	526	550	1.2264199787776884e-10
R526_621	526	621	7.0832694585879535e+03
C526_621	526	621	1.2500142580718763e-10
R526_622	526	622	5.8088276593003475e+03
C526_622	526	622	1.5242641607422820e-10
R526_624	526	624	7.9638506038549795e+03
C526_624	526	624	1.1117973273775432e-10
R527_528	527	528	1.9615162838580729e+03
C527_528	527	528	4.5139507073501581e-10
R527_530	527	530	4.3189831581768512e+03
C527_530	527	530	2.0500630571427305e-10
R527_532	527	532	1.4069578359021398e+03
C527_532	527	532	6.2931436828188290e-10
R527_534	527	534	1.6345969032150763e+03
C527_534	527	534	5.4167408488201380e-10
R527_617	527	617	1.5037152728396716e+03
C527_617	527	617	5.8882076792898589e-10
R527_622	527	622	2.9311296460288322e+03
C527_622	527	622	3.0207424734678239e-10
R527_623	527	623	2.8569368208258770e+03
C527_623	527	623	3.0991892268868766e-10
R527_627	527	627	4.2010379604509089e+03
C527_627	527	627	2.1076190932703820e-10
R528_529	528	529	4.7367993642314841e+03
C528_529	528	529	1.8692342943337936e-10
R528_530	528	530	1.8576028371405625e+03
C528_530	528	530	4.7664590298695874e-10
R528_616	528	616	4.2947014955163477e+03
C528_616	528	616	2.0616538369997869e-10
R528_617	528	617	2.1945771270959372e+03
C528_617	528	617	4.0345758222298901e-10
R528_627	528	627	6.8947800012275147e+03
C528_627	528	627	1.2841871409129285e-10
R529_530	529	530	1.7845816822519789e+03
C529_530	529	530	4.9614920432371726e-10
R529_531	529	531	2.2409384034650184e+03
C529_531	529	531	3.9511071805049799e-10
R529_551	529	551	2.4751971134517421e+03
C529_551	529	551	3.5771647311969227e-10
R529_616	529	616	1.9389162120168096e+03
C529_616	529	616	4.5665654668956057e-10
R529_627	529	627	5.7964835828649530e+03
C529_627	529	627	1.5275102034574822e-10
R530_531	530	531	3.5106595316602184e+03
C530_531	530	531	2.5220867296159551e-10
R530_532	530	532	2.1051335084334446e+03
C530_532	530	532	4.2059982331424336e-10
R530_533	530	533	6.8005433899356367e+03
C530_533	530	533	1.3019824018921228e-10
R530_616	530	616	8.4354577506147016e+03
C530_616	530	616	1.0496392820359728e-10
R530_627	530	627	1.4443300758615833e+03
C530_627	530	627	6.1303077218815309e-10
R531_533	531	533	8.3609171121109139e+03
C531_533	531	533	1.0589972006987816e-10
R531_551	531	551	3.9376533614944369e+03
C531_551	531	551	2.2485950397725249e-10
R531_552	531	552	8.0394021399064914e+03
C531_552	531	552	1.1013490385123322e-10
R531_627	531	627	3.5493541296592371e+03
C531_627	531	627	2.4945912674681646e-10
R531_625	531	625	7.8110691967525900e+03
C531_625	531	625	1.1335436409500869e-10
R531_628	531	628	7.1151191291729228e+03
C531_628	531	628	1.2444187730738993e-10
R532_533	532	533	2.4016995001654100e+03
C532_533	532	533	3.6866343255641236e-10
R532_534	532	534	4.5657414163225703e+03
C532_534	532	534	1.9392661584701649e-10
R532_535	532	535	1.9301115003785783e+03
C532_535	532	535	4.5873970572494439e-10
R532_623	532	623	2.9519530024305222e+03
C532_623	532	623	2.9994338696143903e-10
R532_627	532	627	1.6675193306744711e+03
C532_627	532	627	5.3097962069313436e-10
R532_629	532	629	4.8488926984852869e+03
C532_629	532	629	1.8260226339440136e-10
R533_535	533	535	5.6680165021169532e+03
C533_535	533	535	1.5621316228866026e-10
R533_536	533	536	5.3486116643548312e+03
C533_536	533	536	1.6554179612641639e-10
R533_627	533	627	2.2126007886105735e+03
C533_627	533	627	4.0017105040263874e-10
R533_625	533	625	5.4334788000554481e+03
C533_625	533	625	1.6295614914168145e-10
R533_629	533	629	2.2151290160085241e+03
C533_629	533	629	3.9971431699967082e-10
R533_630	533	630	7.4974473372120374e+03
C533_630	533	630	1.1809603213955315e-10
R534_535	534	535	7.4531922478931019e+03
C534_535	534	535	1.1879725522312858e-10
R534_622	534	622	2.6124149732034502e+03
C534_622	534	622	3.3892731085301630e-10
R534_623	534	623	4.7673584858421609e+03
C534_623	534	623	1.8572523638183872e-10
R534_624	534	624	9.5805675095125462e+03
C534_624	534	624	9.2418197650699472e-11
R534_631	534	631	7.7124723740586278e+03
C534_631	534	631	1.1480349474938287e-10
R535_536	535	536	4.5022042706590819e+03
C535_536	535	536	1.9666339607695829e-10
R535_623	535	623	3.8080851261217758e+03
C535_623	535	623	2.3251023870932395e-10
R535_629	535	629	2.4103916802736589e+03
C535_629	535	629	3.6733398515525728e-10
R535_631	535	631	4.7402835298429682e+03
C535_631	535	631	1.8678603845650799e-10
R535_633	535	633	7.4483404560453018e+03
C535_633	535	633	1.1887463884406184e-10
R536_629	536	629	6.1445197023726223e+03
C536_629	536	629	1.4409894094051121e-10
R536_630	536	630	8.2890029820666332e+03
C536_630	536	630	1.0681848994572870e-10
R536_632	536	632	9.3021869557235714e+03
C536_632	536	632	9.5183937488507272e-11
R536_633	536	633	8.4679123976285318e+03
C536_633	536	633	1.0456163693284835e-10
R536_634	536	634	1.2472935829967040e+04
C536_634	536	634	7.0987199306575751e-11
R537_538	537	538	2.9730870423859510e+03
C537_538	537	538	2.9781125445605423e-10
R537_539	537	539	4.8687337603483311e+03
C537_539	537	539	1.8185812272401875e-10
R537_541	537	541	5.4592950822977446e+03
C537_541	537	541	1.6218555112931155e-10
R537_543	537	543	1.8996654284946183e+03
C537_543	537	543	4.6609195936236341e-10
R537_545	537	545	4.7944440703113769e+03
C537_545	537	545	1.8467600595922613e-10
R537_615	537	615	4.4135244304398211e+03
C537_615	537	615	2.0061490440458839e-10
R537_640	537	640	5.4674899068471668e+03
C537_640	537	640	1.6194246295565231e-10
R538_539	538	539	2.2478827763676913e+03
C538_539	538	539	3.9389010450568537e-10
R538_558	538	558	3.1302671903498426e+03
C538_558	538	558	2.8285725398445761e-10
R538_567	538	567	3.3276467460146428e+03
C538_567	538	567	2.6607955990533614e-10
R538_615	538	615	5.7028819898389556e+03
C538_615	538	615	1.5525812795663396e-10
R538_619	538	619	3.2269841174462636e+03
C538_619	538	619	2.7437965278883781e-10
R538_640	538	640	3.7389390696297050e+03
C538_640	538	640	2.3681016598852725e-10
R539_541	539	541	2.1510273163262286e+03
C539_541	539	541	4.1162600538807653e-10
R539_560	539	560	1.4123013952960853e+03
C539_560	539	560	6.2693330520598562e-10
R539_567	539	567	1.7238325126303498e+03
C539_567	539	567	5.1363387986514033e-10
R539_640	539	640	2.4232942694496573e+03
C539_640	539	640	3.6537815190768515e-10
R540_541	540	541	1.7465865031678502e+03
C540_541	540	541	5.0694241601780523e-10
R540_545	540	545	5.0180563813236713e+03
C540_545	540	545	1.7644655906923924e-10
R540_546	540	546	1.8769666740417272e+03
C540_546	540	546	4.7172855754194180e-10
R540_560	540	560	3.8891751290295520e+03
C540_560	540	560	2.2766235829573831e-10
R540_561	540	561	5.2086658697769408e+03
C540_561	540	561	1.6998955276390535e-10
R540_584	540	584	3.3240690064390915e+03
C540_584	540	584	2.6636594486601971e-10
R540_585	540	585	2.6019824094062074e+03
C540_585	540	585	3.4028622887656633e-10
R540_604	540	604	2.0099706063654646e+03
C540_604	540	604	4.4051329850094739e-10
R540_605	540	605	2.5621246927686684e+03
C540_605	540	605	3.4557989476429582e-10
R540_637	540	637	6.3252154437979079e+03
C540_637	540	637	1.3998239104538071e-10
R540_641	540	641	4.9655836134507463e+03
C540_641	540	641	1.7831112123489018e-10
R541_545	541	545	8.1615937950140460e+02
C541_545	541	545	1.0848601436656971e-09
R541_543	541	543	2.4672385278294919e+03
C541_543	541	543	3.5887036122078197e-10
R541_546	541	546	2.8418105008489288e+03
C541_546	541	546	3.1156855161014454e-10
R541_560	541	560	1.2158958721403583e+03
C541_560	541	560	7.2820280254869618e-10
R541_637	541	637	2.4665960718653719e+03
C541_637	541	637	3.5896383351912139e-10
R541_640	541	640	1.4157691738530327e+03
C541_640	541	640	6.2539769762772999e-10
R541_641	541	641	2.9731114913367787e+03
C541_641	541	641	2.9780880544842782e-10
R541_642	541	642	9.1041762062349142e+02
C541_642	541	642	9.7254134986274639e-10
R542_544	542	544	2.1882358645464701e+03
C542_544	542	544	4.0462675712680109e-10
R542_543	542	543	4.3469005163590291e+03
C542_543	542	543	2.0368968150244865e-10
R542_545	542	545	1.9661068014021873e+03
C542_545	542	545	4.5034114172665364e-10
R542_550	542	550	6.3561221291478587e+03
C542_550	542	550	1.3930172575502493e-10
R542_584	542	584	4.2531241627650461e+03
C542_584	542	584	2.0818079788302501e-10
R542_596	542	596	1.9661068014021896e+03
C542_596	542	596	4.5034114172665312e-10
R542_597	542	597	2.0140673861024700e+03
C542_597	542	597	4.3961725799722205e-10
R542_638	542	638	3.8834949578922119e+03
C542_638	542	638	2.2799534730967333e-10
R542_639	542	639	1.7153650362281899e+03
C542_639	542	639	5.1616930682398225e-10
R542_643	542	643	2.9108598366324022e+03
C542_643	542	643	3.0417774519997103e-10
R543_544	543	544	2.2511436809061820e+03
C543_544	543	544	3.9331953318216487e-10
R543_545	543	545	1.8020912247320537e+03
C543_545	543	545	4.9132850188072451e-10
R543_615	543	615	2.5229277146248746e+03
C543_615	543	615	3.5094892991480330e-10
R543_640	543	640	2.7515023817250908e+03
C543_640	543	640	3.2179466301056774e-10
R543_642	543	642	3.2164009253078839e+03
C543_642	543	642	2.7528246703735947e-10
R543_643	543	643	4.4498381238027023e+03
C543_643	543	643	1.9897775089026089e-10
R544_550	544	550	2.9863377848453115e+03
C544_550	544	550	2.9648982984885729e-10
R544_615	544	615	1.4968045771277075e+03
C544_615	544	615	5.9153933334375150e-10
R544_621	544	621	1.7405260552770687e+03
C544_621	544	621	5.0870757091829510e-10
R544_622	544	622	5.2235741938464025e+03
C544_622	544	622	1.6950439466200402e-10
R544_638	544	638	4.5863221586154968e+03
C544_638	544	638	1.9305638615829096e-10
R544_643	544	643	2.8476239065638274e+03
C544_643	544	643	3.1093248643512681e-10
R544_644	544	644	5.9096647103290516e+03
C544_644	544	644	1.4982555273439525e-10
R545_546	545	546	1.9990179348631484e+03
C545_546	545	546	4.4292688237467723e-10
R545_584	545	584	2.2427396181742329e+03
C545_584	545	584	3.9479339220876687e-10
R545_639	545	639	3.9077179219120267e+03
C545_639	545	639	2.2658206129340293e-10
R545_642	545	642	1.6056219503264281e+03
C545_642	545	642	5.5144910140272535e-10
R545_643	545	643	3.7796309735230461e+03
C545_643	545	643	2.3426064287823551e-10
R545_645	545	645	4.8139888915057181e+03
C545_645	545	645	1.8392622036629982e-10
R546_584	546	584	2.1679498254950104e+03
C546_584	546	584	4.0841294908558668e-10
R546_605	546	605	6.0773032239163258e+03
C546_605	546	605	1.4569271090762193e-10
R546_604	546	604	9.8127239310102559e+03
C546_604	546	604	9.0231702015165421e-11
R546_639	546	639	4.3276444039793978e+03
C546_639	546	639	2.0459601091204056e-10
R546_641	546	641	1.8066248545791766e+03
C546_641	546	641	4.9009553890270364e-10
R546_642	546	642	3.6948858106933985e+03
C546_642	546	642	2.3963359818522740e-10
R546_645	546	645	1.5245444098227399e+03
C546_645	546	645	5.8077598526824716e-10
R546_646	546	646	1.3563050678157585e+03
C546_646	546	646	6.5281683502510957e-10
R547_548	547	548	1.9425442267457074e+03
C547_548	547	548	4.5580366691744179e-10
R547_549	547	549	1.3872426129252017e+03
C547_549	547	549	6.3825806203643530e-10
R547_551	547	551	3.6353874954465487e+03
C547_551	547	551	2.4355554471401418e-10
R547_553	547	553	2.2257562695207016e+03
C547_553	547	553	3.9780581271401634e-10
R547_568	547	568	3.0120052307681581e+03
C547_568	547	568	2.9396322843509459e-10
R547_570	547	570	2.2383641291815661e+03
C547_570	547	570	3.9556512283090595e-10
R547_571	547	571	1.7658742559353720e+03
C547_571	547	571	5.0140534000310188e-10
R547_648	547	648	1.8864774927979199e+03
C547_648	547	648	4.6935030239178491e-10
R548_551	548	551	8.9637524908133691e+03
C548_551	548	551	9.8777691888239245e-11
R548_552	548	552	6.0876664193639335e+03
C548_552	548	552	1.4544469435506823e-10
R548_553	548	553	1.3479918240317206e+03
C548_553	548	553	6.5684284274944125e-10
R548_554	548	554	1.1581409244652335e+04
C548_554	548	554	7.6451730786461776e-11
R548_555	548	555	1.2373580393684788e+04
C548_555	548	555	7.1557201192299914e-11
R548_648	548	648	7.8393770404199049e+03
C548_648	548	648	1.1294504360930367e-10
R549_551	549	551	4.3588816286019492e+03
C549_551	549	551	2.0312980648295005e-10
R549_558	549	558	2.0178501701319740e+03
C549_558	549	558	4.3879312488403967e-10
R549_571	549	571	1.3398677129268324e+03
C549_571	549	571	6.6082552266736443e-10
R549_616	549	616	2.9949704797802242e+03
C549_616	549	616	2.9563522835289302e-10
R549_620	549	620	2.3703223424550192e+03
C549_620	549	620	3.7354361718707992e-10
R549_648	549	648	2.0235691097808492e+03
C549_648	549	648	4.3755302323027173e-10
R550_596	550	596	8.5181125516937518e+03
C550_596	550	596	1.0394541940208836e-10
R550_621	550	621	3.7488617130563257e+03
C550_621	550	621	2.3618336697144975e-10
R550_624	550	624	1.3119250102953783e+04
C550_624	550	624	6.7490045143712070e-11
R550_638	550	638	2.9352767711810106e+03
C550_638	550	638	3.0164745975342934e-10
R550_651	550	651	8.4790242760157325e+03
C550_651	550	651	1.0442460746392103e-10
R550_652	550	652	1.2415842029047752e+04
C550_652	550	652	7.1313631377436936e-11
R551_552	551	552	2.1118867139013360e+03
C551_552	551	552	4.1925486621597518e-10
R551_616	551	616	2.0999198045035519e+03
C551_616	551	616	4.2164409317017913e-10
R551_627	551	627	9.2619259386801295e+03
C551_627	551	627	9.5597696155425815e-11
R551_628	551	628	2.7091301800216534e+03
C551_628	551	628	3.2682769850983060e-10
R551_618	551	618	3.8171974758795627e+03
C551_618	551	618	2.3195519416924609e-10
R551_648	551	648	2.8192117123391540e+03
C551_648	551	648	3.1406608372996267e-10
R551_653	551	653	7.0121429389818250e+03
C551_653	551	653	1.2626935722855706e-10
R552_553	552	553	4.3785596581887303e+03
C552_553	552	553	2.0221690483172941e-10
R552_554	552	554	3.0231681527467699e+03
C552_554	552	554	2.9287778150730129e-10
R552_625	552	625	3.8233046503893970e+03
C552_625	552	625	2.3158467939765711e-10
R552_628	552	628	3.4845423399353535e+03
C552_628	552	628	2.5409901654873464e-10
R552_647	552	647	3.6574094019852328e+03
C552_647	552	647	2.4208905385855819e-10
R552_648	552	648	3.1260473209269662e+03
C552_648	552	648	2.8323908463338523e-10
R552_653	552	653	1.9776795847155188e+03
C552_653	552	653	4.4770588144963035e-10
R552_626	552	626	3.7502382282823892e+03
C552_626	552	626	2.3609667647847597e-10
R552_656	552	656	5.2114823660420770e+03
C552_656	552	656	1.6989768352079104e-10
R553_554	553	554	3.5353694002762263e+03
C553_554	553	554	2.5044590294604587e-10
R553_555	553	555	2.2930693203343958e+03
C553_555	553	555	3.8612822292301239e-10
R553_568	553	568	1.4901866193684236e+03
C553_568	553	568	5.9416637499755672e-10
R553_570	553	570	8.9546487684354770e+02
C553_570	553	570	9.8878113993821921e-10
R553_647	553	647	1.1527603181857669e+03
C553_647	553	647	7.6808575705788225e-10
R553_648	553	648	2.2499517160458413e+03
C553_648	553	648	3.9352790345922257e-10
R553_657	553	657	2.1714708821902063e+03
C553_657	553	657	4.0775070435526265e-10
R554_555	554	555	4.6083804349037846e+03
C554_555	554	555	1.9213231073412583e-10
R554_647	554	647	8.0325284375825515e+02
C554_647	554	647	1.1022914995947071e-09
R554_656	554	656	1.6126277283252700e+03
C554_656	554	656	5.4905342761253182e-10
R554_655	554	655	4.2337248852192733e+03
C554_655	554	655	2.0913469951511560e-10
R554_626	554	626	6.8022205081011734e+03
C554_626	554	626	1.3016613922549285e-10
R554_658	554	658	4.6575716074068378e+03
C554_658	554	658	1.9010309584761666e-10
R554_659	554	659	4.7378741917324724e+03
C554_659	554	659	1.8688102424607305e-10
R555_556	555	556	4.6977557350349116e+03
C555_556	555	556	1.8847697318460511e-10
R555_568	555	568	2.5775031114365647e+03
C555_568	555	568	3.4351802632995237e-10
R555_647	555	647	2.8445598793364138e+03
C555_647	555	647	3.1126740840714968e-10
R555_657	555	657	4.6915744180643414e+03
C555_657	555	657	1.8872529833285853e-10
R555_659	555	659	4.3217391806990208e+03
C555_659	555	659	2.0487557084756504e-10
R555_662	555	662	1.8132120532907377e+03
C555_662	555	662	4.8831507605141005e-10
R555_660	555	660	4.7377265819776430e+03
C555_660	555	660	1.8688684675644671e-10
R555_664	555	664	5.0347798939014328e+03
C555_664	555	664	1.7586047461031950e-10
R556_563	556	563	4.9988057914501915e+03
C556_563	556	563	1.7712606143139106e-10
R556_568	556	568	8.1889683882446925e+03
C556_568	556	568	1.0812336056529700e-10
R556_660	556	660	1.6163561359567742e+04
C556_660	556	660	5.4778694002104411e-11
R556_664	556	664	4.8316658388456171e+03
C556_664	556	664	1.8325331495017966e-10
R557_559	557	559	1.0660944828924635e+03
C557_559	557	559	8.3052562029749474e-10
R557_562	557	562	3.3253705337605811e+03
C557_562	557	562	2.6626169105392938e-10
R557_569	557	569	1.2109394243286413e+03
C557_569	557	569	7.3118338036676476e-10
R557_571	557	571	2.0649930013341391e+03
C557_571	557	571	4.2877568162601703e-10
R557_573	557	573	2.4131077065687095e+03
C557_573	557	573	3.6692053955561359e-10
R557_574	557	574	1.7368543287876164e+03
C557_574	557	574	5.0978298353786111e-10
R557_666	557	666	1.6966424369641652e+03
C557_666	557	666	5.2186528075078505e-10
R558_559	558	559	1.7030220970764951e+03
C558_559	558	559	5.1991033071148073e-10
R558_567	558	567	1.2278456494435254e+03
C558_567	558	567	7.2111570546451225e-10
R558_571	558	571	1.7933607756708861e+03
C558_571	558	571	4.9372039006973929e-10
R558_616	558	616	2.5088430104127333e+03
C558_616	558	616	3.5291916553771875e-10
R558_619	558	619	2.8473617466395031e+03
C558_619	558	619	3.1096111435260511e-10
R558_620	558	620	9.6838826391999601e+02
C558_620	558	620	9.1432209031102984e-10
R558_667	558	667	3.9876469308943615e+03
C558_667	558	667	2.2204041557445900e-10
R559_567	559	567	2.8637547759425966e+03
C559_567	559	567	3.0918107553694681e-10
R559_571	559	571	3.3721079600089411e+03
C559_571	559	571	2.6257130323243050e-10
R559_574	559	574	3.1971673787612817e+03
C559_574	559	574	2.7693851362985222e-10
R559_575	559	575	2.9479713283085543e+03
C559_575	559	575	3.0034850515592480e-10
R559_666	559	666	3.4122456286696779e+03
C559_666	559	666	2.5948272136704173e-10
R559_667	559	667	3.7845517761779229e+03
C559_667	559	667	2.3395604924031409e-10
R560_561	560	561	3.1186049760039314e+03
C560_561	560	561	2.8391501601287890e-10
R560_567	560	567	4.8157334745072849e+03
C560_567	560	567	1.8385958990194956e-10
R560_575	560	575	3.1415013180600376e+03
C560_575	560	575	2.8184574572986977e-10
R560_576	560	576	7.4779804607173355e+03
C560_576	560	576	1.1840346285353427e-10
R560_604	560	604	7.8378386965880673e+03
C560_604	560	604	1.1296721149485210e-10
R560_637	560	637	1.4871496875962782e+03
C560_637	560	637	5.9537973149907141e-10
R560_640	560	640	8.5474891212895236e+03
C560_640	560	640	1.0358817298692517e-10
R560_669	560	669	5.7651735331271375e+03
C560_669	560	669	1.5358059503539913e-10
R561_576	561	576	3.7007201099663666e+03
C561_576	561	576	2.3925580843455005e-10
R561_585	561	585	4.7953371432878785e+03
C561_585	561	585	1.8464161230860213e-10
R561_590	561	590	1.3856857232749669e+03
C561_590	561	590	6.3897517801322056e-10
R561_604	561	604	2.9569163371184222e+03
C561_604	561	604	2.9943991670824872e-10
R561_607	561	607	1.8873680398232837e+03
C561_607	561	607	4.6912884133764557e-10
R561_669	561	669	3.2141144050438475e+03
C561_669	561	669	2.7547830292242537e-10
R562_563	562	563	1.8207117033932666e+03
C562_563	562	563	4.8630366908162456e-10
R562_564	562	564	2.8361819042096163e+03
C562_564	562	564	3.1218688067426608e-10
R562_568	562	568	1.0360197524648670e+03
C562_568	562	568	8.5463503914229279e-10
R562_569	562	569	2.1848540440719189e+03
C562_569	562	569	4.0525305756802076e-10
R562_573	562	573	2.8778862788222759e+03
C562_573	562	573	3.0766288029363765e-10
R562_661	562	661	3.1951359090944547e+03
C562_661	562	661	2.7711459133234179e-10
R562_663	562	663	5.1100419150872485e+03
C562_663	562	663	1.7327035598002187e-10
R562_664	562	664	6.3014879307646452e+03
C562_664	562	664	1.4050947830547701e-10
R562_670	562	670	2.2767211194825618e+03
C562_670	562	670	3.8890085137051496e-10
R563_564	563	564	6.6509017471953048e+03
C563_564	563	564	1.3312762920808184e-10
R563_568	563	568	7.5794650960048493e+03
C563_568	563	568	1.1681810925769760e-10
R563_664	563	664	6.8232971197905235e+03
C563_664	563	664	1.2976406657302103e-10
R563_670	563	670	9.3585240949115869e+03
C563_670	563	670	9.4610942144330168e-11
R564_573	564	573	2.6385883037821127e+03
C564_573	564	573	3.3556534015968089e-10
R564_579	564	579	5.9306924864575485e+03
C564_579	564	579	1.4929433345630568e-10
R564_670	564	670	6.4737528887111148e+03
C564_670	564	670	1.3677055595433479e-10
R564_671	564	671	7.9121326288888567e+03
C564_671	564	671	1.1190646355789717e-10
R565_566	565	566	4.0178326546434369e+03
C565_566	565	566	2.2037223991315703e-10
R565_580	565	580	2.7643046017722700e+03
C565_580	565	580	3.2030434747760228e-10
R565_582	565	582	2.1952335269522532e+03
C565_582	565	582	4.0333694380536768e-10
R565_583	565	583	4.0728844482939930e+03
C565_583	565	583	2.1739354330832412e-10
R565_673	565	673	6.0173279782672225e+03
C565_673	565	673	1.4714484317588572e-10
R566_578	566	578	4.3113090683832361e+03
C566_578	566	578	2.0537121501985866e-10
R566_572	566	572	9.8806285313772096e+03
C566_572	566	572	8.9611584818540502e-11
R566_582	566	582	6.2016855885106061e+03
C566_582	566	582	1.4277066598480071e-10
R566_589	566	589	2.1408788405122805e+03
C566_589	566	589	4.1357724918619519e-10
R566_673	566	673	5.3319558754921936e+03
C566_673	566	673	1.6605891015897930e-10
R566_674	566	674	9.2107076289050219e+03
C566_674	566	674	9.6129289667319460e-11
R567_575	567	575	2.4523478025761729e+03
C567_575	567	575	3.6104943220936054e-10
R567_619	567	619	4.8161720703877209e+03
C567_619	567	619	1.8384284630194296e-10
R567_620	567	620	5.8803847289552396e+03
C567_620	567	620	1.5057157354690827e-10
R567_637	567	637	5.0507285718285721e+03
C567_637	567	637	1.7530516025719474e-10
R567_640	567	640	2.1725128525762411e+03
C567_640	567	640	4.0755514088215395e-10
R567_665	567	665	2.4123491898633106e+03
C567_665	567	665	3.6703591064698638e-10
R567_667	567	667	2.5364243222921746e+03
C567_667	567	667	3.4908149000079153e-10
R567_675	567	675	3.2169918564219938e+03
C567_675	567	675	2.7523190024011484e-10
R568_569	568	569	3.0470324445807987e+03
C568_569	568	569	2.9058396909252905e-10
R568_570	568	570	1.6569604584181955e+03
C568_570	568	570	5.3436325363205009e-10
R568_571	568	571	4.8603289589328060e+03
C568_571	568	571	1.8217260378491203e-10
R568_657	568	657	1.4284726357417057e+03
C568_657	568	657	6.1983601193750837e-10
R568_661	568	661	3.7779596421742458e+03
C568_661	568	661	2.3436427743056422e-10
R568_662	568	662	6.1563186826582796e+03
C568_662	568	662	1.4382276606214919e-10
R568_663	568	663	2.9262340272241836e+03
C568_663	568	663	3.0257962058485988e-10
R568_664	568	664	4.8589882204389005e+03
C568_664	568	664	1.8222287059177564e-10
R568_676	568	676	4.9140990135284856e+03
C568_676	568	676	1.8017927177748096e-10
R569_571	569	571	1.3552529296125101e+03
C569_571	569	571	6.5332364339780945e-10
R569_573	569	573	5.2689550583638566e+03
C569_573	569	573	1.6804447407356423e-10
R569_661	569	661	2.0716618089880949e+03
C569_661	569	661	4.2739542615427355e-10
R569_666	569	666	2.1154734788948131e+03
C569_666	569	666	4.1854402361147511e-10
R569_676	569	676	3.8427451044855384e+03
C569_676	569	676	2.3041309210607633e-10
R570_571	570	571	3.9261075414600459e+03
C570_571	570	571	2.2552076639518880e-10
R570_648	570	648	9.2492100792376232e+02
C570_648	570	648	9.5729124337608499e-10
R570_647	570	647	4.5735943854695115e+03
C570_647	570	647	1.9359363928576835e-10
R570_657	570	657	1.1317020111503839e+03
C570_657	570	657	7.8237802263863172e-10
R570_676	570	676	3.0151363658974055e+03
C570_676	570	676	2.9365795581072162e-10
R571_620	571	620	1.7501123566814001e+03
C571_620	571	620	5.0592110747617923e-10
R571_648	571	648	2.2754766628587154e+03
C571_648	571	648	3.8911354097898554e-10
R571_666	571	666	2.5368299356026596e+03
C571_666	571	666	3.4902567542023908e-10
R571_667	571	667	2.0117678190909367e+03
C571_667	571	667	4.4011976595793079e-10
R571_676	571	676	8.5476502910593729e+02
C571_676	571	676	1.0358621978558549e-09
R571_678	571	678	4.1853694793528284e+03
C571_678	571	678	2.1155092425362407e-10
R572_576	572	576	1.6488098743644903e+03
C572_576	572	576	5.3700477869910380e-10
R572_577	572	577	5.3997566787752621e+03
C572_577	572	577	1.6397382963204649e-10
R572_578	572	578	2.5550674525989534e+03
C572_578	572	578	3.4653440589185757e-10
R572_589	572	589	2.3041303163018974e+03
C572_589	572	589	3.8427461130804750e-10
R572_590	572	590	9.7048166845765320e+02
C572_590	572	590	9.1234982635700903e-10
R572_681	572	681	3.2905746381700210e+03
C572_681	572	681	2.6907725217027927e-10
R573_574	573	574	6.0594897948462722e+03
C573_574	573	574	1.4612101211112985e-10
R573_577	573	577	2.9229229795932993e+03
C573_577	573	577	3.0292237868792511e-10
R573_579	573	579	7.1273787987792930e+03
C573_579	573	579	1.2422782718545080e-10
R573_661	573	661	5.7832342541008029e+03
C573_661	573	661	1.5310097132450812e-10
R573_666	573	666	2.1453935085875814e+03
C573_666	573	666	4.1270693611957217e-10
R573_670	573	670	6.2419321033573169e+03
C573_670	573	670	1.4185011420162104e-10
R573_671	573	671	2.0349260975877944e+03
C573_671	573	671	4.3511102577610906e-10
R573_680	573	680	3.1680218211561969e+03
C573_680	573	680	2.7948632669987694e-10
R573_682	573	682	6.0409626978012757e+03
C573_682	573	682	1.4656915230121603e-10
R574_575	574	575	8.5069361136242969e+02
C574_575	574	575	1.0408198320450018e-09
R574_576	574	576	1.3552006198879144e+03
C574_576	574	576	6.5334886119903853e-10
R574_577	574	577	1.0549646567671518e+03
C574_577	574	577	8.3928762543883645e-10
R574_666	574	666	1.5123062834970099e+03
C574_666	574	666	5.8547583340894754e-10
R574_668	574	668	3.0303623242466933e+03
C574_668	574	668	2.9218248082598606e-10
R574_683	574	683	3.3321613742734116e+03
C574_683	574	683	2.6571905806724875e-10
R575_576	575	576	2.5165192914651134e+03
C575_576	575	576	3.5184263625672863e-10
R575_637	575	637	3.3610049620385544e+03
C575_637	575	637	2.6343870113270109e-10
R575_665	575	665	1.9879660508712711e+03
C575_665	575	665	4.4538928686027886e-10
R575_666	575	666	5.1361210865363455e+03
C575_666	575	666	1.7239055831861266e-10
R575_667	575	667	4.0115379490555292e+03
C575_667	575	667	2.2071803705819656e-10
R575_668	575	668	1.5158143724919298e+03
C575_668	575	668	5.8412085131796973e-10
R575_669	575	669	2.7840763659334702e+03
C575_669	575	669	3.1802963184996141e-10
R575_683	575	683	4.5131867331076764e+03
C575_683	575	683	1.9618483215081181e-10
R576_577	576	577	3.6571897556621057e+03
C576_577	576	577	2.4210359342967754e-10
R576_590	576	590	3.6072643246299340e+03
C576_590	576	590	2.4545436708213351e-10
R576_669	576	669	1.7451813269294378e+03
C576_669	576	669	5.0735059333797244e-10
R576_681	576	681	4.9918036946727898e+03
C576_681	576	681	1.7737451948379130e-10
R576_683	576	683	3.1180234403697618e+03
C576_683	576	683	2.8396796837261738e-10
R577_578	577	578	4.9977449843595323e+03
C577_578	577	578	1.7716365770380897e-10
R577_579	577	579	2.7051024341122866e+03
C577_579	577	579	3.2731432663493997e-10
R577_666	577	666	6.1601153062924022e+03
C577_666	577	666	1.4373412471606938e-10
R577_668	577	668	6.6424874305198364e+03
C577_668	577	668	1.3329626754456768e-10
R577_671	577	671	5.0774187224816706e+03
C577_671	577	671	1.7438364454354817e-10
R577_681	577	681	3.1601643503612581e+03
C577_681	577	681	2.8018124487695784e-10
R577_682	577	682	1.7770750474687982e+03
C577_682	577	682	4.9824501388456208e-10
R577_683	577	683	2.6032117981103106e+03
C577_683	577	683	3.4012552583801742e-10
R577_684	577	684	2.6052343277111108e+03
C577_684	577	684	3.3986147513951477e-10
R578_579	578	579	3.8571357008153136e+03
C578_579	578	579	2.2955344337842252e-10
R578_589	578	589	4.8142571639035568e+03
C578_589	578	589	1.8391597115723530e-10
R578_674	578	674	4.0179430971549914e+03
C578_674	578	674	2.2036618246956853e-10
R578_681	578	681	3.8049591705407674e+03
C578_681	578	681	2.3270125696885278e-10
R578_684	578	684	4.3144020672110164e+03
C578_684	578	684	2.0522398420608175e-10
R579_671	579	671	8.0552678725823753e+03
C579_671	579	671	1.0991798109082010e-10
R579_684	579	684	1.2332221179815751e+04
C579_684	579	684	7.1797186312971117e-11
R580_581	580	581	6.1261836100419214e+03
C580_581	580	581	1.4453023906247908e-10
R580_582	580	582	2.6989506928208966e+03
C580_582	580	582	3.2806037696619634e-10
R580_583	580	583	3.2746566477308193e+03
C580_583	580	583	2.7038522720040069e-10
R580_610	580	610	2.0121245918949637e+03
C580_610	580	610	4.4004172766763757e-10
R580_611	580	611	4.7754927258447706e+03
C580_611	580	611	1.8540888501581211e-10
R580_612	580	612	5.6110097477713680e+03
C580_612	580	612	1.5780025726237220e-10
R580_685	580	685	4.9845695190437791e+03
C580_685	580	685	1.7763194561079279e-10
R581_583	581	583	7.6218611191580776e+03
C581_583	581	583	1.1616831740405747e-10
R581_612	581	612	7.8579260449663443e+03
C581_612	581	612	1.1267843151402328e-10
R581_685	581	685	9.3874008857682584e+03
C581_685	581	685	9.4319907339031059e-11
R581_686	581	686	1.1045788716657824e+04
C581_686	581	686	8.0158946039292459e-11
R582_583	582	583	5.8457207849284687e+03
C582_583	582	583	1.5146443257823757e-10
R582_589	582	589	3.5130032311502086e+03
C582_589	582	589	2.5204041198963005e-10
R582_606	582	606	9.3761404509079239e+03
C582_606	582	606	9.4433182431078241e-11
R582_608	582	608	1.7272931953779471e+03
C582_608	582	608	5.1260479927165036e-10
R582_611	582	611	2.9874134175231870e+03
C582_611	582	611	2.9638307724884136e-10
R582_673	582	673	2.6532689059906966e+03
C582_673	582	673	3.3370864886738498e-10
R582_685	582	685	9.4756156463801472e+03
C582_685	582	685	9.3441821063969147e-11
R582_688	582	688	4.7541605121977009e+03
C582_688	582	688	1.8624082620439299e-10
R583_673	583	673	1.1519744392308849e+04
C583_673	583	673	7.6860974648981740e-11
R583_685	583	685	4.1862368066923145e+03
C583_685	583	685	2.1150709398104954e-10
R583_686	583	686	1.8507923563083466e+04
C583_686	583	686	4.7839984787169024e-11
R583_687	583	687	1.1776542643808221e+04
C583_687	583	687	7.5184951006442342e-11
R583_688	583	688	1.4509393935423583e+04
C583_688	583	688	6.1023829502507162e-11
R584_592	584	592	3.4348510355818967e+03
C584_592	584	592	2.5777501630431011e-10
R584_594	584	594	1.9949361807939083e+03
C584_594	584	594	4.4383313622977005e-10
R584_597	584	597	3.2124187858833884e+03
C584_597	584	597	2.7562370933418548e-10
R584_605	584	605	3.5937866090967013e+03
C584_605	584	605	2.4637489033400071e-10
R584_639	584	639	2.5079033716970312e+03
C584_639	584	639	3.5305139412164074e-10
R584_646	584	646	3.8784177044404000e+03
C584_646	584	646	2.2829381700848883e-10
R584_689	584	689	7.0179302391545816e+03
C584_689	584	689	1.2616522985082603e-10
R585_591	585	591	1.8876205828861155e+03
C585_591	585	591	4.6906607701120819e-10
R585_604	585	604	6.5442925917326829e+03
C585_604	585	604	1.3529633177137249e-10
R585_605	585	605	4.9423790647687429e+03
C585_605	585	605	1.7914829479827231e-10
R585_606	585	606	5.4036679545373836e+03
C585_606	585	606	1.6385514231245956e-10
R585_607	585	607	7.9162777444300746e+03
C585_607	585	607	1.1184786717759928e-10
R585_690	585	690	5.1707012054617699e+03
C585_690	585	690	1.7123766129915600e-10
R586_587	586	587	3.1245916723621053e+03
C586_587	586	587	2.8337103677635029e-10
R586_591	586	591	3.8564636781037225e+03
C586_591	586	591	2.2959344508473961e-10
R586_593	586	593	3.2627176791561183e+03
C586_593	586	593	2.7137462347922419e-10
R586_598	586	598	2.6404094873042886e+03
C586_598	586	598	3.3533388891280021e-10
R586_599	586	599	6.5586846134560692e+03
C586_599	586	599	1.3499944484042397e-10
R586_691	586	691	5.0607448884787682e+03
C586_691	586	691	1.7495819315368651e-10
R587_591	587	591	4.0070923281067812e+03
C587_591	587	591	2.2096291006060521e-10
R587_588	587	588	1.1669049580750630e+04
C587_588	587	588	7.5877540460586846e-11
R587_593	587	593	6.9358029708922450e+03
C587_593	587	593	1.2765916007358793e-10
R587_609	587	609	3.3346025496923171e+03
C587_609	587	609	2.6552453208604946e-10
R587_691	587	691	5.2780378644737084e+03
C587_691	587	691	1.6775529172682207e-10
R588_593	588	593	7.1952615084231902e+03
C588_593	588	593	1.2305581675710849e-10
R588_609	588	609	4.1376679250874486e+03
C588_609	588	609	2.1398981207059699e-10
R588_610	588	610	2.5295031070939576e+03
C588_610	588	610	3.5003664522761602e-10
R588_612	588	612	1.4826105285890457e+04
C588_612	588	612	5.9720254552800570e-11
R588_691	588	691	9.5244638721011070e+03
C588_691	588	691	9.2962584938093293e-11
R588_693	588	693	5.8233291210898751e+03
C588_693	588	693	1.5204683837864343e-10
R589_590	589	590	2.8247198491654140e+03
C589_590	589	590	3.1345366230268963e-10
R589_608	589	608	1.6610011936335914e+03
C589_608	589	608	5.3306330247907036e-10
R589_673	589	673	5.5833741012674664e+03
C589_673	589	673	1.5858131044792495e-10
R589_672	589	672	4.3631132334996701e+03
C589_672	589	672	2.0293279919985072e-10
R589_674	589	674	4.3219431260037318e+03
C589_674	589	674	2.0486590311027510e-10
R589_681	589	681	3.5863973125707780e+03
C589_681	589	681	2.4688251315505250e-10
R589_694	589	694	6.0206251537628950e+03
C589_694	589	694	1.4706425978814055e-10
R590_607	590	607	1.7175411109395247e+03
C590_607	590	607	5.1551533530144178e-10
R590_608	590	608	3.4371389318957918e+03
C590_608	590	608	2.5760343100580969e-10
R590_669	590	669	4.0855032849286727e+03
C590_669	590	669	2.1672208292336699e-10
R590_681	590	681	5.4383311093722941e+03
C590_681	590	681	1.6281075276459168e-10
R590_694	590	694	2.7716949628267516e+03
C590_694	590	694	3.1945029794945164e-10
R591_592	591	592	6.0733273671993184e+03
C591_592	591	592	1.4578808751228341e-10
R591_598	591	598	5.7370564740708496e+03
C591_598	591	598	1.5433328671274738e-10
R591_605	591	605	3.1820122740698521e+03
C591_605	591	605	2.7825750042363384e-10
R591_606	591	606	4.7679646638904924e+03
C591_606	591	606	1.8570162409247579e-10
R591_609	591	609	7.2713760923184263e+03
C591_609	591	609	1.2176770537771626e-10
R591_690	591	690	4.5293049167130466e+03
C591_690	591	690	1.9548668018194624e-10
R591_691	591	691	3.9405614388446684e+03
C591_691	591	691	2.2469356091542012e-10
R591_692	591	692	4.7923132747199707e+03
C591_692	591	692	1.8475811804096586e-10
R591_698	591	698	4.2232431224941820e+03
C591_698	591	698	2.0965375566090671e-10
R592_594	592	594	8.3339945513628427e+03
C592_594	592	594	1.0624182392286412e-10
R592_598	592	598	4.5997636540688436e+03
C592_598	592	598	1.9249223401223654e-10
R592_600	592	600	2.7848278902955958e+03
C592_600	592	600	3.1794380715068793e-10
R592_605	592	605	3.3417934683547155e+03
C592_605	592	605	2.6495317262557327e-10
R592_689	592	689	2.8742019817043479e+03
C592_689	592	689	3.0805725809671993e-10
R592_698	592	698	3.4615656139786911e+03
C592_698	592	698	2.5578564165429988e-10
R593_599	593	599	5.5421039388537729e+03
C593_599	593	599	1.5976221151188365e-10
R593_691	593	691	1.2898596299915196e+03
C593_691	593	691	6.8644584349525025e-10
R593_693	593	693	8.0390060430474814e+03
C593_693	593	693	1.1014033040387533e-10
R593_699	593	699	7.0127217330785943e+03
C593_699	593	699	1.2625893560320978e-10
R594_597	594	597	2.1702425180390160e+03
C594_597	594	597	4.0798149254768319e-10
R594_595	594	595	4.7526036616325500e+03
C594_595	594	595	1.8630183468651641e-10
R594_600	594	600	6.3696715782779711e+03
C594_600	594	600	1.3900540566635796e-10
R594_601	594	601	4.7564253328974601e+03
C594_601	594	601	1.8615214572508209e-10
R594_613	594	613	2.6310038254257893e+03
C594_613	594	613	3.3653268503199844e-10
R594_639	594	639	2.3012798383224226e+03
C594_639	594	639	3.8475059267257515e-10
R594_646	594	646	7.0528108727522585e+03
C594_646	594	646	1.2554126257953631e-10
R594_689	594	689	2.6927417042278062e+03
C594_689	594	689	3.2881682647460250e-10
R594_700	594	700	1.8939415391721188e+03
C594_700	594	700	4.6750058720768913e-10
R594_701	594	701	5.8090740706890510e+03
C594_701	594	701	1.5241995039580808e-10
R595_597	595	597	2.2643844930362361e+03
C595_597	595	597	3.9101962781628663e-10
R595_596	595	596	9.1618511812333036e+03
C595_596	595	596	9.6641908298363263e-11
R595_601	595	601	5.7829701149328548e+03
C595_601	595	601	1.5310796426453266e-10
R595_613	595	613	5.2160121763077805e+03
C595_613	595	613	1.6975013703414219e-10
R595_614	595	614	9.0604558252407787e+03
C595_614	595	614	9.7723425705954508e-11
R595_650	595	650	9.6275235869049520e+03
C595_650	595	650	9.1967448711766151e-11
R595_701	595	701	9.9827411924279404e+03
C595_701	595	701	8.8694955086244594e-11
R596_597	596	597	4.4591614259610933e+03
C596_597	596	597	1.9856172430653005e-10
R596_638	596	638	5.1639378620489651e+03
C596_638	596	638	1.7146193570746812e-10
R596_639	596	639	8.7946055554571012e+03
C596_639	596	639	1.0067748645652366e-10
R596_652	596	652	8.5148880687429173e+03
C596_652	596	652	1.0398478224866644e-10
R596_701	596	701	3.8622427850614768e+03
C596_701	596	701	2.2924990244648913e-10
R596_650	596	650	1.2658469680009803e+04
C596_650	596	650	6.9946747441221064e-11
R597_639	597	639	2.8664609262590438e+03
C597_639	597	639	3.0888918582104691e-10
R597_701	597	701	6.7271708865627843e+03
C597_701	597	701	1.3161829788932276e-10
R598_599	598	599	1.8823154624279505e+03
C598_599	598	599	4.7038809348031449e-10
R598_600	598	600	2.1270249463596174e+03
C598_600	598	600	4.1627099071658079e-10
R598_602	598	602	5.8890066176407345e+03
C598_602	598	602	1.5035112697066697e-10
R598_691	598	691	9.5174863156725569e+03
C598_691	598	691	9.3030738614456475e-11
R598_698	598	698	2.6633326898388791e+03
C598_698	598	698	3.3244768296429549e-10
R598_703	598	703	8.7536532087630821e+03
C598_703	598	703	1.0114848744677564e-10
R599_602	599	602	1.2813631273044282e+04
C599_602	599	602	6.9099755005642580e-11
R599_691	599	691	9.4120648704302548e+03
C599_691	599	691	9.4072745342173231e-11
R599_698	599	698	9.4785831821648335e+03
C599_698	599	698	9.3412566486310816e-11
R599_699	599	699	9.6946516553486417e+03
C599_699	599	699	9.1330644274516591e-11
R599_703	599	703	8.7624209091772573e+03
C599_703	599	703	1.0104727801567524e-10
R600_601	600	601	1.3706826603322800e+03
C600_601	600	601	6.4596920011037221e-10
R600_602	600	602	2.6374166794564640e+03
C600_602	600	602	3.3571440895053147e-10
R600_689	600	689	2.9620956990012032e+03
C600_689	600	689	2.9891633210856649e-10
R600_698	600	698	3.7961533168719816e+03
C600_698	600	698	2.3324104897575166e-10
R600_703	600	703	5.4769036881374668e+03
C600_703	600	703	1.6166411390759821e-10
R600_704	600	704	2.0401141211856693e+03
C600_704	600	704	4.3400453558226147e-10
R601_602	601	602	3.2309949642304932e+03
C601_602	601	602	2.7403904726012937e-10
R601_603	601	603	4.4588865454936158e+03
C601_603	601	603	1.9857396519650198e-10
R601_613	601	613	1.3011607580628893e+03
C601_613	601	613	6.8048377282617439e-10
R601_614	601	614	1.7108378202521906e+03
C601_614	601	614	5.1753519311928851e-10
R601_689	601	689	6.8444519536176767e+03
C601_689	601	689	1.2936299176327867e-10
R601_704	601	704	2.3842825162286922e+03
C601_704	601	704	3.7135648803083108e-10
R601_705	601	705	3.6181576691269615e+03
C601_705	601	705	2.4471536695459883e-10
R602_603	602	603	5.4550844581452211e+03
C602_603	602	603	1.6231073753183478e-10
R602_703	602	703	4.0400284515292228e+03
C602_703	602	703	2.1916152134147798e-10
R602_704	602	704	5.2309803308075116e+03
C602_704	602	704	1.6926440661330434e-10
R602_705	602	705	5.2935414597452454e+03
C602_705	602	705	1.6726397411509293e-10
R603_614	603	614	6.4295930093808238e+03
C603_614	603	614	1.3770992664826021e-10
R603_705	603	705	6.3700919005244714e+03
C603_705	603	705	1.3899623357507610e-10
R603_706	603	706	1.8233785715829239e+04
C603_706	603	706	4.8559240275119831e-11
R604_605	604	605	1.0075778032236603e+04
C604_605	604	605	8.7875971351013982e-11
R604_607	604	607	8.4256563241010263e+03
C604_607	604	607	1.0508603100358114e-10
R604_637	604	637	1.1006481039389242e+04
C604_637	604	637	8.0445219369508175e-11
R604_641	604	641	1.1264415604080265e+04
C604_641	604	641	7.8603170623363555e-11
R604_646	604	646	2.1071425052355953e+04
C604_646	604	646	4.2019881403370163e-11
R604_669	604	669	7.0937093350639598e+03
C604_669	604	669	1.2481746007316727e-10
R604_690	604	690	4.5548795785692782e+03
C604_690	604	690	1.9438906483189980e-10
R604_694	604	694	1.4636165825933202e+04
C604_694	604	694	6.0495268517056842e-11
R604_695	604	695	1.4262700420975125e+04
C604_695	604	695	6.2079322678465471e-11
R604_697	604	697	7.2251752426669127e+03
C604_697	604	697	1.2254633997959329e-10
R604_707	604	707	9.0087256530067352e+03
C604_707	604	707	9.8284576065926076e-11
R605_646	605	646	2.8533237240668191e+03
C605_646	605	646	3.1031136573526251e-10
R605_689	605	689	3.4654668079537332e+03
C605_689	605	689	2.5549769504871304e-10
R605_690	605	690	3.3903647635648326e+03
C605_690	605	690	2.6115738082678084e-10
R605_698	605	698	3.1057713330099737e+03
C605_698	605	698	2.8508820732848097e-10
R605_707	605	707	3.5335079739929515e+03
C605_707	605	707	2.5057783602493329e-10
R606_607	606	607	1.9476922239453327e+03
C606_607	606	607	4.5459892010374004e-10
R606_608	606	608	4.7481508716231319e+03
C606_608	606	608	1.8647654753171818e-10
R606_609	606	609	3.4238570717927628e+03
C606_609	606	609	2.5860272877465262e-10
R606_611	606	611	3.1417515425715369e+03
C606_611	606	611	2.8182329815147672e-10
R606_690	606	690	2.0754024402450514e+03
C606_690	606	690	4.2662510389814079e-10
R606_692	606	692	2.4482993111153796e+03
C606_692	606	692	3.6164646114964874e-10
R606_710	606	710	6.2992841346986925e+03
C606_710	606	710	1.4055863535711925e-10
R607_608	607	608	2.3595472836422905e+03
C607_608	607	608	3.7524943358339177e-10
R607_669	607	669	7.4218049976484899e+03
C607_669	607	669	1.1929965580886782e-10
R607_690	607	690	3.6991640834597674e+03
C607_690	607	690	2.3935644965277739e-10
R607_694	607	694	1.8829376356478454e+03
C607_694	607	694	4.7023266460727049e-10
R607_710	607	710	8.8731238141222384e+03
C607_710	607	710	9.9786591537333232e-11
R608_611	608	611	2.6450958306947041e+03
C608_611	608	611	3.3473977442528231e-10
R608_673	608	673	3.9903163629047617e+03
C608_673	608	673	2.2189187552423967e-10
R608_672	608	672	1.7227260211565947e+03
C608_672	608	672	5.1396378229984142e-10
R608_688	608	688	2.0304043196736648e+03
C608_688	608	688	4.3608003249436953e-10
R608_694	608	694	1.2063642851731213e+03
C608_694	608	694	7.3395639491510354e-10
R608_710	608	710	2.0897583791310462e+03
C608_710	608	710	4.2369433258029135e-10
R609_610	609	610	1.1186539073610941e+03
C609_610	609	610	7.9150376704865230e-10
R609_611	609	611	2.8975582062233593e+03
C609_611	609	611	3.0557411402411257e-10
R609_691	609	691	1.7112237553507928e+03
C609_691	609	691	5.1741847255883459e-10
R609_692	609	692	2.0750035277101069e+03
C609_692	609	692	4.2670712115709680e-10
R609_693	609	693	2.4396446524266489e+03
C609_693	609	693	3.6292940482922292e-10
R609_712	609	712	4.5634613566869411e+03
C609_712	609	712	1.9402350814312836e-10
R610_611	610	611	6.7270036132902524e+03
C610_611	610	611	1.3162157070210519e-10
R610_612	610	612	2.5795917173381631e+03
C610_612	610	612	3.4323989170412149e-10
R610_693	610	693	8.6390082194962542e+03
C610_693	610	693	1.0249079051711209e-10
R610_712	610	712	1.3134981907173589e+04
C610_712	610	712	6.7409212129666830e-11
R611_612	611	612	8.2939008080428921e+03
C611_612	611	612	1.0675541005281590e-10
R611_685	611	685	2.1638293321146248e+03
C611_685	611	685	4.0919067347826149e-10
R611_688	611	688	2.5060599675500584e+03
C611_688	611	688	3.5331109118094714e-10
R611_692	611	692	5.8890457323198862e+03
C611_692	611	692	1.5035012834773908e-10
R611_710	611	710	2.4436715987476505e+03
C611_710	611	710	3.6233133050847155e-10
R611_712	611	712	1.9446796547782963e+03
C611_712	611	712	4.5530315469924650e-10
R611_713	611	713	3.6594600112096373e+03
C611_713	611	713	2.4195339721920456e-10
R612_685	612	685	2.5669927330345731e+03
C612_685	612	685	3.4492453769173750e-10
R612_686	612	686	1.1350235628098742e+04
C612_686	612	686	7.8008845869952658e-11
R612_693	612	693	8.4637764304244884e+03
C612_693	612	693	1.0461273274152318e-10
R612_712	612	712	7.6681396394740914e+03
C612_712	612	712	1.1546722195068493e-10
R612_714	612	714	7.2859096584694371e+03
C612_714	612	714	1.2152480928318313e-10
R613_614	613	614	2.3117139802110096e+03
C613_614	613	614	3.8301398411717885e-10
R613_650	613	650	3.5145838003289832e+03
C613_650	613	650	2.5192706505308549e-10
R613_689	613	689	6.1294223372124279e+03
C613_689	613	689	1.4445387068933412e-10
R613_700	613	700	2.7740567762532251e+03
C613_700	613	700	3.1917832009764758e-10
R613_701	613	701	4.2217853754775888e+03
C613_701	613	701	2.0972614734112038e-10
R613_702	613	702	2.1674926698649647e+03
C613_702	613	702	4.0849908929803299e-10
R613_704	613	704	5.1182619590829754e+03
C613_704	613	704	1.7299207988538319e-10
R613_705	613	705	9.8089827895709841e+03
C613_705	613	705	9.0266116344029751e-11
R613_708	613	708	1.9782715631625013e+03
C613_708	613	708	4.4757190983656117e-10
R613_716	613	716	8.1136233586914159e+03
C613_716	613	716	1.0912741971828508e-10
R614_650	614	650	5.7219488630331907e+03
C614_650	614	650	1.5474077152633654e-10
R614_705	614	705	3.8704814764328189e+03
C614_705	614	705	2.2876192202217573e-10
R614_706	614	706	4.1073334227880696e+03
C614_706	614	706	2.1557022295476934e-10
R614_708	614	708	4.6703988426738160e+03
C614_708	614	708	1.8958097831171424e-10
R614_716	614	716	3.9061856258327371e+03
C614_716	614	716	2.2667094360402872e-10
R615_617	615	617	2.7134404697681489e+03
C615_617	615	617	3.2630853396818945e-10
R615_619	615	619	2.7764974304836092e+03
C615_619	615	619	3.1889774936538591e-10
R615_621	615	621	6.5072281386165960e+03
C615_621	615	621	1.3606696474118635e-10
R615_622	615	622	5.1809143047194302e+03
C615_622	615	622	1.7090010172402367e-10
R615_640	615	640	2.7148028099072162e+03
C615_640	615	640	3.2614478608494621e-10
R615_643	615	643	9.0523686361420641e+03
C615_643	615	643	9.7810729687356997e-11
R615_644	615	644	2.5322775319295738e+03
C615_644	615	644	3.4965313656805944e-10
R615_717	615	717	4.1216886911789325e+03
C615_717	615	717	2.1481942185370202e-10
R616_617	616	617	4.5089465774700539e+03
C616_617	616	617	1.9636932185539531e-10
R616_619	616	619	4.6262765262081748e+03
C616_619	616	619	1.9138907427691398e-10
R616_620	616	620	2.2728153458950997e+03
C616_620	616	620	3.8956916728811370e-10
R616_627	616	627	3.7827262178953256e+03
C616_627	616	627	2.3406895733327462e-10
R616_618	616	618	2.3417879571831236e+03
C616_618	616	618	3.7809519815152160e-10
R616_628	616	628	5.0278404430168093e+03
C616_628	616	628	1.7610319812947963e-10
R616_648	616	648	8.2651265381812900e+03
C616_648	616	648	1.0712706909080585e-10
R616_718	616	718	3.1140361750755524e+03
C616_718	616	718	2.8433156582662954e-10
R617_619	617	619	2.0407602282877440e+03
C617_619	617	619	4.3386712923295832e-10
R617_622	617	622	2.8837051024214179e+03
C617_622	617	622	3.0704206923118554e-10
R617_623	617	623	6.1626847536691530e+03
C617_623	617	623	1.4367419673265576e-10
R617_627	617	627	6.0515142910361801e+03
C617_627	617	627	1.4631359013917043e-10
R617_717	617	717	5.8623170034418081e+03
C617_717	617	717	1.5103563679346656e-10
R617_718	617	718	2.9640852224939231e+03
C617_718	617	718	2.9871569649236533e-10
R618_628	618	628	2.1171359774481643e+03
C618_628	618	628	4.1821535845194827e-10
R618_648	618	648	3.1548515057056252e+03
C618_648	618	648	2.8065307672918954e-10
R618_620	618	620	3.6585308178934642e+03
C618_620	618	620	2.4201484852048151e-10
R618_653	618	653	2.5930405191729965e+03
C618_653	618	653	3.4145967837879693e-10
R618_677	618	677	2.2003172578983367e+03
C618_677	618	677	4.0240505250852771e-10
R618_718	618	718	2.7635184224489562e+03
C618_718	618	718	3.2039546923496369e-10
R618_719	618	719	2.6962614334878476e+03
C618_719	618	719	3.2838758538137538e-10
R619_620	619	620	1.7697325679851531e+03
C619_620	619	620	5.0031219276709838e-10
R619_640	619	640	3.6103310975640347e+03
C619_640	619	640	2.4524586742124853e-10
R619_644	619	644	6.9590571283283425e+03
C619_644	619	644	1.2723257840429446e-10
R619_675	619	675	3.7056394439123651e+03
C619_675	619	675	2.3893819004829748e-10
R619_715	619	715	3.6459665453036655e+03
C619_715	619	715	2.4284884973519559e-10
R619_717	619	717	3.7073826843304450e+03
C619_717	619	717	2.3882583943715728e-10
R619_718	619	718	2.9668945687051109e+03
C619_718	619	718	2.9843284322922110e-10
R619_720	619	720	3.3029629579879861e+03
C619_720	619	720	2.6806803253989762e-10
R620_648	620	648	2.3183681392925650e+03
C620_648	620	648	3.8191466087442860e-10
R620_667	620	667	2.7230493595623998e+03
C620_667	620	667	3.2515708119308159e-10
R620_675	620	675	2.3660624934089660e+03
C620_675	620	675	3.7421614355769187e-10
R620_676	620	676	3.4188760219261508e+03
C620_676	620	676	2.5897949385165669e-10
R620_677	620	677	1.3833266091721916e+03
C620_677	620	677	6.4006488115619437e-10
R620_678	620	678	7.0001629617123365e+02
C620_678	620	678	1.2648545277343291e-09
R620_718	620	718	3.2384090727911025e+03
C620_718	620	718	2.7341165424072877e-10
R620_720	620	720	2.5865341742550768e+03
C620_720	620	720	3.4231860940132413e-10
R621_622	621	622	1.6953082384860936e+03
C621_622	621	622	5.2227598592376137e-10
R621_624	621	624	2.1141271290365789e+03
C621_624	621	624	4.1881056703694576e-10
R621_638	621	638	2.0121809940993344e+03
C621_638	621	638	4.4002939312937863e-10
R621_643	621	643	5.2574347872420431e+03
C621_643	621	643	1.6841269887904306e-10
R621_644	621	644	1.3599893261685863e+03
C621_644	621	644	6.5104833152950942e-10
R621_649	621	649	1.3789602246906427e+03
C621_649	621	649	6.4209160340258222e-10
R621_651	621	651	3.3242253447865187e+03
C621_651	621	651	2.6635341767327189e-10
R621_717	621	717	2.0258177894522571e+03
C621_717	621	717	4.3706733463891658e-10
R621_721	621	721	2.1359594534372409e+03
C621_721	621	721	4.1452977034520074e-10
R622_623	622	623	9.4212619284905395e+02
C622_623	622	623	9.3980911306842364e-10
R622_624	622	624	1.5484239910149911e+03
C622_624	622	624	5.7181933813852149e-10
R622_631	622	631	3.6687706267929329e+03
C622_631	622	631	2.4133936726210424e-10
R622_717	622	717	1.3751459571864623e+03
C622_717	622	717	6.4387258463207772e-10
R622_718	622	718	4.6277481936211179e+03
C622_718	622	718	1.9132821075279339e-10
R622_721	622	721	1.3998294447320816e+03
C622_721	622	721	6.3251904368211350e-10
R622_722	622	722	3.1169425106590429e+03
C622_722	622	722	2.8406644609970309e-10
R623_627	623	627	2.9537202751291570e+03
C623_627	623	627	2.9976392455148227e-10
R623_629	623	629	2.3543527638542155e+03
C623_629	623	629	3.7607736414593907e-10
R623_631	623	631	2.6991502376227254e+03
C623_631	623	631	3.2803612387276075e-10
R623_718	623	718	5.1772292993644542e+03
C623_718	623	718	1.7102174358178267e-10
R623_721	623	721	5.9014173308444524e+03
C623_721	623	721	1.5003493772119018e-10
R623_722	623	722	1.5032549137426513e+03
C623_722	623	722	5.8900108930665279e-10
R623_723	623	723	4.3184687945691721e+03
C623_723	623	723	2.0503072357810867e-10
R624_631	624	631	4.0199709930126096e+03
C624_631	624	631	2.2025501757077547e-10
R624_651	624	651	4.0150629061396903e+03
C624_651	624	651	2.2052426136239344e-10
R624_721	624	721	1.8607096512820460e+03
C624_721	624	721	4.7585005059222366e-10
R624_724	624	724	6.5494415280075591e+03
C624_724	624	724	1.3518996664275255e-10
R625_627	625	627	5.5596068031759833e+03
C625_627	625	627	1.5925924495131478e-10
R625_628	625	628	2.3143368435373404e+03
C625_628	625	628	3.8257991016842850e-10
R625_629	625	629	5.2747174205993815e+03
C625_629	625	629	1.6786089397740426e-10
R625_630	625	630	6.4780719146320080e+03
C625_630	625	630	1.3667936901103340e-10
R625_653	625	653	7.2540176242072230e+03
C625_653	625	653	1.2205908884826646e-10
R625_626	625	626	6.2574847491301452e+03
C625_626	625	626	1.4149755328178505e-10
R625_636	625	636	8.6664441763910600e+03
C625_636	625	636	1.0216632839014169e-10
R625_729	625	729	3.2080379258153503e+03
C625_729	625	729	2.7600009793368113e-10
R626_653	626	653	5.6158834718878579e+03
C626_653	626	653	1.5766331088104900e-10
R626_656	626	656	3.3223736422542174e+03
C626_656	626	656	2.6650186795343307e-10
R626_655	626	655	1.5120383642167406e+04
C626_655	626	655	5.8557957433749427e-11
R626_654	626	654	5.7185966096781822e+03
C626_654	626	654	1.5483148089192243e-10
R626_727	626	727	9.3209751128912230e+03
C626_727	626	727	9.4992076577421216e-11
R626_636	626	636	1.0035724662082395e+04
C626_636	626	636	8.8226691296677863e-11
R626_729	626	729	1.2765948338038033e+04
C626_729	626	729	6.9357854054740585e-11
R627_628	627	628	1.3306985305707406e+03
C627_628	627	628	6.6537894298285678e-10
R627_629	627	629	1.6938352169273958e+03
C627_629	627	629	5.2273017637816207e-10
R627_718	627	718	3.0881714312736076e+03
C627_718	627	718	2.8671296312550891e-10
R627_722	627	722	6.0945744299709777e+03
C627_722	627	722	1.4527983731658460e-10
R627_730	627	730	4.7942610510811628e+03
C627_730	627	730	1.8468305590083119e-10
R628_629	628	629	1.2103638070090788e+04
C628_629	628	629	7.3153111202816938e-11
R628_653	628	653	3.5211932577163789e+03
C628_653	628	653	2.5145418524237036e-10
R628_718	628	718	5.3768549076227509e+03
C628_718	628	718	1.6467224742195377e-10
R628_719	628	719	6.0817513299549873e+03
C628_719	628	719	1.4558615334023418e-10
R628_729	628	729	8.4430629314251000e+03
C628_729	628	729	1.0486938080308145e-10
R628_730	628	730	3.7157012262484664e+03
C628_730	628	730	2.3829116707372006e-10
R629_630	629	630	2.2008106729134574e+03
C629_630	629	630	4.0231483452771199e-10
R629_631	629	631	6.0892264779407897e+03
C629_631	629	631	1.4540743145415479e-10
R629_632	629	632	1.7867307586351128e+03
C629_632	629	632	4.9555243699748763e-10
R629_633	629	633	2.4066862872351207e+03
C629_633	629	633	3.6789954153816950e-10
R629_722	629	722	4.7598169600822730e+03
C629_722	629	722	1.8601950224671993e-10
R629_723	629	723	3.7130139784316348e+03
C629_723	629	723	2.3846362735052190e-10
R629_729	629	729	2.6022703275737122e+03
C629_729	629	729	3.4024857921872437e-10
R629_730	629	730	2.2124732185832268e+03
C629_730	629	730	4.0019412405226062e-10
R629_731	629	731	3.5944928996423128e+03
C629_731	629	731	2.4632647953988389e-10
R630_632	630	632	1.3434488955772792e+03
C630_632	630	632	6.5906398420874536e-10
R630_634	630	634	9.4956910730413947e+03
C630_634	630	634	9.3244269941946140e-11
R630_635	630	635	5.7455977607761224e+03
C630_635	630	635	1.5410385804320502e-10
R630_636	630	636	6.6703386181505057e+03
C630_636	630	636	1.3273970519138372e-10
R630_729	630	729	4.5433916879342132e+03
C630_729	630	729	1.9488057436284612e-10
R630_732	630	732	4.1773941192400880e+03
C630_732	630	732	2.1195481116372786e-10
R631_633	631	633	6.2173601592051964e+03
C631_633	631	633	1.4241072722626196e-10
R631_721	631	721	4.4777094770570329e+03
C631_721	631	721	1.9773922051815211e-10
R631_723	631	723	2.5784115175797265e+03
C631_723	631	723	3.4339700069720246e-10
R631_724	631	724	5.6822235751809085e+03
C631_724	631	724	1.5582258775726024e-10
R631_734	631	734	9.8513011568767379e+03
C631_734	631	734	8.9878358970066628e-11
R632_633	632	633	4.4451576970434153e+03
C632_633	632	633	1.9918725994556142e-10
R632_634	632	634	4.8608415013341464e+03
C632_634	632	634	1.8215339493315731e-10
R632_635	632	635	6.2258791549457064e+03
C632_635	632	635	1.4221586376225151e-10
R632_729	632	729	7.4485440813532869e+03
C632_729	632	729	1.1887138909690562e-10
R632_731	632	731	2.1506463117536150e+03
C632_731	632	731	4.1169892829939041e-10
R632_732	632	732	2.6524259175546063e+03
C632_732	632	732	3.3381470744951421e-10
R632_735	632	735	6.0061284699409434e+03
C632_735	632	735	1.4741922123898662e-10
R632_736	632	736	9.5547601391605731e+03
C632_736	632	736	9.2667818846762584e-11
R633_634	633	634	9.4728981866096656e+03
C633_634	633	634	9.3468626418003337e-11
R633_723	633	723	7.6647737868882468e+03
C633_723	633	723	1.1551792738027608e-10
R633_731	633	731	4.4609515028383621e+03
C633_731	633	731	1.9848204606946208e-10
R633_734	633	734	6.1612239078052298e+03
C633_734	633	734	1.4370826234351330e-10
R633_736	633	736	6.6392209919380830e+03
C633_736	633	736	1.3336184814079126e-10
R634_635	634	635	1.0501351851418996e+04
C634_635	634	635	8.4314742923346357e-11
R634_735	634	735	1.2405316069416724e+04
C634_735	634	735	7.1374141275034104e-11
R634_736	634	736	1.1457599257917936e+04
C634_736	634	736	7.7277862645450696e-11
R634_737	634	737	1.6248994399902398e+04
C634_737	634	737	5.4490681694451091e-11
R635_732	635	732	1.8517629029125485e+03
C635_732	635	732	4.7814910878026967e-10
R635_636	635	636	9.4425314030592417e+03
C635_636	635	636	9.3769217586413045e-11
R635_733	635	733	6.0233821656182954e+03
C635_733	635	733	1.4699694579467425e-10
R635_735	635	735	1.9918039394215002e+03
C635_735	635	735	4.4453109273253135e-10
R635_737	635	737	9.1652006787591836e+03
C635_737	635	737	9.6606589722798218e-11
R635_740	635	740	3.4476570586692178e+03
C635_740	635	740	2.5681753336620096e-10
R635_741	635	741	4.5818579008628221e+03
C635_741	635	741	1.9324448746724869e-10
R636_654	636	654	7.7800838709424506e+03
C636_654	636	654	1.1380581448574330e-10
R636_727	636	727	8.0845166532333469e+03
C636_727	636	727	1.0952031143950738e-10
R636_729	636	729	2.9856803150238488e+03
C636_729	636	729	2.9655511919497912e-10
R636_732	636	732	3.0184753022853643e+03
C636_732	636	732	2.9333312120514192e-10
R636_733	636	733	6.7500073287653722e+03
C636_733	636	733	1.3117301042426421e-10
R636_750	636	750	4.7345549744660466e+03
C636_750	636	750	1.8701203945780689e-10
R637_640	637	640	4.9566444848291030e+03
C637_640	637	640	1.7863269887723804e-10
R637_641	637	641	2.5478008892856737e+03
C637_641	637	641	3.4752275400462899e-10
R637_642	637	642	7.3614482043479220e+03
C637_642	637	642	1.2027779821598710e-10
R637_665	637	665	1.3265312676957114e+03
C637_665	637	665	6.6746921332509687e-10
R637_669	637	669	3.2619777082620335e+03
C637_669	637	669	2.7143618408469964e-10
R637_695	637	695	2.1929265360564004e+03
C637_695	637	695	4.0376126018898599e-10
R637_756	637	756	5.2475296669306763e+03
C637_756	637	756	1.6873059094449844e-10
R638_639	638	639	3.9391229283291286e+03
C638_639	638	639	2.2477561574235289e-10
R638_643	638	643	1.7609309316757663e+03
C638_643	638	643	5.0281289616362363e-10
R638_649	638	649	2.0120006138215751e+03
C638_649	638	649	4.4006884273173452e-10
R638_651	638	651	4.3598905452696490e+03
C638_651	638	651	2.0308280047549655e-10
R638_652	638	652	2.0365416834537903e+03
C638_652	638	652	4.3476585276585644e-10
R638_701	638	701	2.2216570936829689e+03
C638_701	638	701	3.9853980356265986e-10
R638_753	638	753	3.2780427518624060e+03
C638_753	638	753	2.7010592866641324e-10
R638_754	638	754	3.3723429670787623e+03
C638_754	638	754	2.6255300553460014e-10
R638_757	638	757	1.5437089335372555e+03
C638_757	638	757	5.7356588568231646e-10
R639_643	639	643	2.0118902619789794e+03
C639_643	639	643	4.4009298043376640e-10
R639_645	639	645	1.0276514600105832e+03
C639_645	639	645	8.6159443756434854e-10
R639_646	639	646	3.8358135544161064e+03
C639_646	639	646	2.3082946267829744e-10
R639_700	639	700	1.8838603878010260e+03
C639_700	639	700	4.7000233532885267e-10
R639_701	639	701	2.5143441175330590e+03
C639_701	639	701	3.5214701739741411e-10
R639_757	639	757	3.0091576299414555e+03
C639_757	639	757	2.9424140925353462e-10
R640_642	640	642	1.7121089713856752e+03
C640_642	640	642	5.1715095037636357e-10
R640_643	640	643	6.8198724413239424e+03
C640_643	640	643	1.2982922911210838e-10
R640_644	640	644	1.0633897053371567e+04
C640_644	640	644	8.3263809801437809e-11
R640_665	640	665	9.7750918575792912e+03
C640_665	640	665	9.0579075327407264e-11
R640_675	640	675	6.2791050488228902e+03
C640_675	640	675	1.4101034698662742e-10
R640_715	640	715	4.6082167289006675e+03
C640_715	640	715	1.9213913619710002e-10
R640_756	640	756	5.7086754250316635e+03
C640_756	640	756	1.5510056462793010e-10
R640_758	640	758	1.1108491102582868e+04
C640_758	640	758	7.9706485203389051e-11
R641_642	641	642	2.1881881330210654e+03
C641_642	641	642	4.0463558335707159e-10
R641_645	641	645	2.9651733054104093e+03
C641_645	641	645	2.9860608150101008e-10
R641_646	641	646	3.4657036133574943e+03
C641_646	641	646	2.5548023734269264e-10
R641_695	641	695	4.2978313267117364e+03
C641_695	641	695	2.0601524685181923e-10
R641_696	641	696	2.1498048980831322e+03
C641_696	641	696	4.1186006343621292e-10
R641_707	641	707	7.5954754195285568e+03
C641_707	641	707	1.1657187111994594e-10
R641_756	641	756	5.3310572463371391e+03
C641_756	641	756	1.6608690186329426e-10
R641_758	641	758	7.9232353825841783e+03
C641_758	641	758	1.1174965010457876e-10
R642_643	642	643	2.2584120834123701e+03
C642_643	642	643	3.9205368595184261e-10
R642_645	642	645	2.2550101970571714e+03
C642_645	642	645	3.9264513431269059e-10
R642_756	642	756	5.9640948878700801e+03
C642_756	642	756	1.4845819832625164e-10
R642_758	642	758	4.1917015154885057e+03
C642_758	642	758	2.1123135281182163e-10
R643_644	643	644	2.1658452387139964e+03
C643_644	643	644	4.0880981054109424e-10
R643_645	643	645	1.3509763806524281e+03
C643_645	643	645	6.5539175545941385e-10
R643_649	643	649	3.7173185568351596e+03
C643_649	643	649	2.3818749137653289e-10
R643_715	643	715	5.5533836426283533e+03
C643_715	643	715	1.5943771197498998e-10
R643_757	643	757	8.6394062143443909e+02
C643_757	643	757	1.0248606903445514e-09
R643_758	643	758	1.9263799766469735e+03
C643_758	643	758	4.5962831447259226e-10
R643_759	643	759	3.9846287437740243e+03
C643_759	643	759	2.2220860176333004e-10
R644_649	644	649	2.3628424117761083e+03
C644_649	644	649	3.7472612531719617e-10
R644_715	644	715	1.9271655756779708e+03
C644_715	644	715	4.5944094937899282e-10
R644_717	644	717	8.2574275073359365e+02
C644_717	644	717	1.0722695184588541e-09
R644_759	644	759	3.5394514357224512e+03
C644_759	644	759	2.5015706466933734e-10
R645_646	645	646	1.0126159318971874e+03
C645_646	645	646	8.7438756769422230e-10
R645_696	645	696	3.6037587245319460e+03
C645_696	645	696	2.4569313580087070e-10
R645_700	645	700	2.7063606713326453e+03
C645_700	645	700	3.2716215213991004e-10
R645_757	645	757	2.0517534978086674e+03
C645_757	645	757	4.3154247459339198e-10
R645_758	645	758	2.4312144697679046e+03
C645_758	645	758	3.6418785455177313e-10
R645_761	645	761	2.1673157916634505e+03
C645_761	645	761	4.0853242757965899e-10
R646_689	646	689	1.3397352910066322e+03
C646_689	646	689	6.6089083988727813e-10
R646_696	646	696	2.7082012994175707e+03
C646_696	646	696	3.2693979649534152e-10
R646_700	646	700	1.7091825238313613e+03
C646_700	646	700	5.1803641176672889e-10
R646_707	646	707	8.2667093648103798e+02
C646_707	646	707	1.0710655747364718e-09
R646_755	646	755	3.8813055929406473e+03
C646_755	646	755	2.2812395481314525e-10
R646_761	646	761	3.0407668334282248e+03
C646_761	646	761	2.9118272797712685e-10
R646_762	646	762	1.9083919171915629e+03
C646_762	646	762	4.6396066432884730e-10
R647_648	647	648	2.0381425789006480e+03
C647_648	647	648	4.3442435817104868e-10
R647_653	647	653	4.7851110528625704e+03
C647_653	647	653	1.8503620332287188e-10
R647_656	647	656	1.7321609241104845e+03
C647_656	647	656	5.1116427427474069e-10
R647_657	647	657	1.0998908032499855e+03
C647_657	647	657	8.0500607795223116e-10
R647_658	647	658	3.5699156106085720e+03
C647_658	647	658	2.4802232833427138e-10
R647_659	647	659	4.8455350402127669e+03
C647_659	647	659	1.8272879555136216e-10
R647_662	647	662	2.1751690525246167e+03
C647_662	647	662	4.0705745637210866e-10
R647_763	647	763	1.4728703152472183e+03
C647_763	647	763	6.0115189540729133e-10
R648_653	648	653	2.1877224491636894e+03
C648_653	648	653	4.0472171505963798e-10
R648_657	648	657	3.2363096796878926e+03
C648_657	648	657	2.7358901629753468e-10
R648_676	648	676	1.6546121346957580e+03
C648_676	648	676	5.3512165366949078e-10
R648_677	648	677	3.4204889290966389e+03
C648_677	648	677	2.5885737391754748e-10
R648_763	648	763	4.1077249710962178e+03
C648_763	648	763	2.1554967480301169e-10
R648_765	648	765	4.2247623765947001e+03
C648_765	648	765	2.0957836270395809e-10
R649_651	649	651	7.4342014685472486e+03
C649_651	649	651	1.1910072459645405e-10
R649_717	649	717	4.6772663482333255e+03
C649_717	649	717	1.8930262161239463e-10
R649_721	649	721	5.7784679692596037e+03
C649_721	649	721	1.5322725442284473e-10
R649_753	649	753	2.1488207503078797e+03
C649_753	649	753	4.1204869302064346e-10
R649_757	649	757	5.8733819135802669e+03
C649_757	649	757	1.5075109957565674e-10
R649_759	649	759	1.7632568414578452e+03
C649_759	649	759	5.0214963633315251e-10
R649_766	649	766	3.5547008130466147e+03
C649_766	649	766	2.4908391121140159e-10
R649_767	649	767	7.6464709745162863e+03
C649_767	649	767	1.1579443440652197e-10
R650_701	650	701	3.0509111706809636e+03
C650_701	650	701	2.9021453990821194e-10
R650_652	650	652	1.3960023363974413e+04
C650_652	650	652	6.3425308010940304e-11
R650_702	650	702	4.0392032343437186e+03
C650_702	650	702	2.1920629647244306e-10
R650_716	650	716	8.3174714757851816e+03
C650_716	650	716	1.0645287865161151e-10
R650_770	650	770	9.3284763818546435e+03
C650_770	650	770	9.4915690993470179e-11
R651_652	651	652	1.0801453220152636e+04
C651_652	651	652	8.1972190561177849e-11
R651_721	651	721	7.5702070316599502e+03
C651_721	651	721	1.1696097319360244e-10
R651_724	651	724	1.0589923900029286e+04
C651_724	651	724	8.3609550933368988e-11
R651_753	651	753	6.7836456016177399e+03
C651_753	651	753	1.3052255876823052e-10
R651_767	651	767	5.0578283036178600e+03
C651_767	651	767	1.7505908238653748e-10
R651_769	651	769	1.4271527440112348e+04
C651_769	651	769	6.2040926271941486e-11
R651_771	651	771	1.0832037256480142e+04
C651_771	651	771	8.1740743752548348e-11
R652_701	652	701	7.2234976215610368e+03
C652_701	652	701	1.2257480075263820e-10
R652_753	652	753	1.3448105910869612e+04
C652_753	652	753	6.5839664527355379e-11
R652_754	652	754	5.1735497779113784e+03
C652_754	652	754	1.7114337731518913e-10
R652_770	652	770	1.3937252529885920e+04
C652_770	652	770	6.3528932965904104e-11
R652_771	652	771	1.5106341341998226e+04
C652_771	652	771	5.8612390760586306e-11
R653_656	653	656	1.7261708453399403e+03
C653_656	653	656	5.1293809305742970e-10
R653_654	653	654	8.1314802005156525e+02
C653_654	653	654	1.0888777441084491e-09
R653_677	653	677	2.7782497825896812e+03
C653_677	653	677	3.1869660793230675e-10
R653_719	653	719	1.7620140128112550e+03
C653_719	653	719	5.0250382531710615e-10
R653_725	653	725	1.5021513325104431e+03
C653_725	653	725	5.8943380905588264e-10
R653_726	653	726	5.9636182866760037e+03
C653_726	653	726	1.4847006282716226e-10
R653_729	653	729	4.0325738134626099e+03
C653_729	653	729	2.1956666453173402e-10
R653_730	653	730	5.1538399997369070e+03
C653_730	653	730	1.7179787920176002e-10
R653_763	653	763	4.1147856576742715e+03
C653_763	653	763	2.1517980652252248e-10
R653_765	653	765	3.2220791207394741e+03
C653_765	653	765	2.7479734311949316e-10
R653_774	653	774	2.9498978790160782e+03
C653_774	653	774	3.0015235035706613e-10
R654_656	654	656	3.8307270491158811e+03
C654_656	654	656	2.3113596201127191e-10
R654_725	654	725	1.7922763898973678e+03
C654_725	654	725	4.9401910703666762e-10
R654_719	654	719	3.5104407074681094e+03
C654_719	654	719	2.5222439445177371e-10
R654_726	654	726	1.5062148840407137e+03
C654_726	654	726	5.8784360125607854e-10
R654_727	654	727	4.2469557946478217e+03
C654_727	654	727	2.0848316406208872e-10
R654_729	654	729	1.6467521280020637e+03
C654_729	654	729	5.3767580842554731e-10
R654_730	654	730	4.1795786255322701e+03
C654_730	654	730	2.1184403047023473e-10
R654_750	654	750	1.4996739041830961e+03
C654_750	654	750	5.9040754075287201e-10
R654_751	654	751	1.7306415249770223e+03
C654_751	654	751	5.1161304575293595e-10
R654_752	654	752	1.4176771436944357e+03
C654_752	654	752	6.2455601096355268e-10
R654_774	654	774	4.0197352504259215e+03
C654_774	654	774	2.2026793471191497e-10
R655_656	655	656	1.0584083587726548e+03
C655_656	655	656	8.3655686801901697e-10
R655_658	655	658	8.6464185779165553e+02
C655_658	655	658	1.0240295143256309e-09
R655_659	655	659	5.8773264732848847e+03
C655_659	655	659	1.5064992317929422e-10
R655_679	655	679	6.1657255563613699e+03
C655_679	655	679	1.4360333972154926e-10
R655_726	655	726	3.3803914705226889e+03
C655_726	655	726	2.6192788303394144e-10
R655_727	655	727	2.9663192163158024e+03
C655_727	655	727	2.9849072777800998e-10
R655_728	655	728	3.9458460504446775e+03
C655_728	655	728	2.2439263224682016e-10
R655_775	655	775	3.7445882072869431e+03
C655_775	655	775	2.3645291089070388e-10
R656_658	656	658	1.7576430952191533e+03
C656_658	656	658	5.0375345490126413e-10
R656_726	656	726	1.3694809992453866e+03
C656_726	656	726	6.4653601049440247e-10
R656_727	656	727	5.9166911246303362e+03
C656_727	656	727	1.4964762618993725e-10
R656_763	656	763	2.8519359399532204e+03
C656_763	656	763	3.1046236673693424e-10
R656_774	656	774	5.1376753469550640e+03
C656_774	656	774	1.7233840636208347e-10
R656_776	656	776	4.3031781346624202e+03
C656_776	656	776	2.0575926768354904e-10
R657_662	657	662	1.2146354597614804e+03
C657_662	657	662	7.2895844970133740e-10
R657_663	657	663	1.1483415518707745e+03
C657_663	657	663	7.7104131628569533e-10
R657_661	657	661	2.9927406847306429e+03
C657_661	657	661	2.9585549667484495e-10
R657_676	657	676	1.3952976054988173e+03
C657_676	657	676	6.3457342592046060e-10
R657_763	657	763	9.0608552383728068e+02
C657_763	657	763	9.7719117942668701e-10
R657_764	657	764	1.7780640279772131e+03
C657_764	657	764	4.9796788404030813e-10
R657_777	657	777	2.5752800842739530e+03
C657_777	657	777	3.4381455714539321e-10
R658_659	658	659	2.2263967397323845e+03
C658_659	658	659	3.9769137544031271e-10
R658_662	658	662	5.0120449423362761e+03
C658_662	658	662	1.7665818880053330e-10
R658_679	658	679	3.8238811840738995e+03
C658_679	658	679	2.3154976294443586e-10
R658_726	658	726	7.1482288682638509e+03
C658_726	658	726	1.2386547745148637e-10
R658_728	658	728	1.0254949286472334e+04
C658_728	658	728	8.6340629969568656e-11
R658_763	658	763	5.4201145391285372e+03
C658_763	658	763	1.6335794664633792e-10
R658_772	658	772	2.0609715030644570e+03
C658_772	658	772	4.2961233592190446e-10
R658_773	658	773	1.1982961161620211e+04
C658_773	658	773	7.3889814859441870e-11
R658_775	658	775	3.9443559685379128e+03
C658_775	658	775	2.2447740233450726e-10
R658_776	658	776	2.4505831010770239e+03
C658_776	658	776	3.6130942929903548e-10
R658_777	658	777	7.5704963422564078e+03
C658_777	658	777	1.1695650346699705e-10
R658_778	658	778	2.2072896894432497e+03
C658_778	658	778	4.0113392724782376e-10
R659_662	659	662	3.1956978869015834e+03
C659_662	659	662	2.7706585948850927e-10
R659_660	659	660	8.9253851537774917e+03
C659_660	659	660	9.9202305160496533e-11
R659_679	659	679	1.3276092440894410e+04
C659_679	659	679	6.6692724959690733e-11
R659_773	659	773	7.0806506322430942e+03
C659_773	659	773	1.2504765842676613e-10
R659_778	659	778	8.5438514857601058e+03
C659_778	659	778	1.0363227675196751e-10
R659_779	659	779	9.4820160031804135e+03
C659_779	659	779	9.3378747874188058e-11
R660_662	660	662	7.9184484182171282e+03
C660_662	660	662	1.1181720646976896e-10
R660_664	660	664	8.7494727047392171e+03
C660_664	660	664	1.0119681626304250e-10
R660_773	660	773	2.6682574486301342e+04
C660_773	660	773	3.3183408975568231e-11
R660_779	660	779	7.7208975862594680e+03
C660_779	660	779	1.1467821866666640e-10
R661_663	661	663	1.9367073120404655e+03
C661_663	661	663	4.5717738359088728e-10
R661_666	661	666	4.1171576540399328e+03
C661_666	661	666	2.1505583611334120e-10
R661_670	661	670	6.1396806803133977e+03
C661_670	661	670	1.4421251328901428e-10
R661_676	661	676	2.7247060837807526e+03
C661_676	661	676	3.2495937340566623e-10
R661_680	661	680	2.9718955708208573e+03
C661_680	661	680	2.9793065085912206e-10
R661_709	661	709	3.4359321435688166e+03
C661_709	661	709	2.5769390800027206e-10
R661_764	661	764	3.5258336115776669e+03
C661_764	661	764	2.5112324608642304e-10
R661_780	661	780	2.6142420104515268e+03
C661_780	661	780	3.3869044187958420e-10
R662_663	662	663	4.5451126150923228e+03
C662_663	662	663	1.9480678625209706e-10
R662_664	662	664	5.4809550100924325e+03
C662_664	662	664	1.6154461769338041e-10
R662_763	662	763	6.7730962156867927e+03
C662_763	662	763	1.3072585321456540e-10
R662_777	662	777	3.8396217946315101e+03
C662_777	662	777	2.3060051980587684e-10
R662_778	662	778	5.0636293140871903e+03
C662_778	662	778	1.7485853066628211e-10
R662_779	662	779	5.7396155889829251e+03
C662_779	662	779	1.5426447433161609e-10
R662_781	662	781	1.0097655147327703e+04
C662_781	662	781	8.7685583314292701e-11
R663_664	663	664	5.3672207475409350e+03
C663_664	663	664	1.6496783407048549e-10
R663_670	663	670	5.6438047276941170e+03
C663_670	663	670	1.5688331266233487e-10
R663_764	663	764	3.9054599216065744e+03
C663_764	663	764	2.2671306311492465e-10
R663_777	663	777	3.7957325237340624e+03
C663_777	663	777	2.3326690596969848e-10
R663_780	663	780	2.4721393843222659e+03
C663_780	663	780	3.5815892393249364e-10
R663_781	663	781	4.3453771162396706e+03
C663_781	663	781	2.0376109092833092e-10
R664_670	664	670	6.4557897278252894e+03
C664_670	664	670	1.3715111845785972e-10
R664_779	664	779	1.2143999863015209e+04
C664_779	664	779	7.2909979552664549e-11
R664_781	664	781	7.1307392620738501e+03
C664_781	664	781	1.2416928303763160e-10
R665_667	665	667	1.4478660009966613e+03
C665_667	665	667	6.1153365096666961e-10
R665_668	665	668	1.1170958496435051e+03
C665_668	665	668	7.9260770862460962e-10
R665_669	665	669	3.4019412057527570e+03
C665_669	665	669	2.6026869018275142e-10
R665_675	665	675	1.7052922072046058e+03
C665_675	665	675	5.1921821841396888e-10
R665_695	665	695	1.1665197715867530e+03
C665_695	665	695	7.5902595332406010e-10
R665_756	665	756	1.3165859329636914e+03
C665_756	665	756	6.7251119697662607e-10
R665_782	665	782	1.3210806027157580e+03
C665_782	665	782	6.7022313391010061e-10
R666_667	666	667	1.3388713449122617e+03
C666_667	666	667	6.6131729913005386e-10
R666_668	666	668	1.3952969798159972e+03
C666_668	666	668	6.3457371047758099e-10
R666_676	666	676	3.8634114165498781e+03
C666_676	666	676	2.2918055734553393e-10
R666_680	666	680	1.9340733320278914e+03
C666_680	666	680	4.5780000532432308e-10
R666_682	666	682	3.0453189596104635e+03
C666_682	666	682	2.9074746962244530e-10
R666_709	666	709	3.0610336871958066e+03
C666_709	666	709	2.8925483094278729e-10
R666_783	666	783	3.0206726029006736e+03
C666_783	666	783	2.9311974453959527e-10
R667_668	667	668	1.6556623255716370e+03
C667_668	667	668	5.3478222462681144e-10
R667_675	667	675	1.6732151953215082e+03
C667_675	667	675	5.2917208986371119e-10
R667_676	667	676	3.6190408221440352e+03
C667_676	667	676	2.4465564916602676e-10
R667_678	667	678	1.1598748570383332e+03
C667_678	667	678	7.6337440744328298e-10
R667_709	667	709	2.7916900278647413e+03
C667_709	667	709	3.1716228265400356e-10
R667_782	667	782	1.8366724158846864e+03
C667_782	667	782	4.8207768246658864e-10
R667_783	667	783	3.5289733604573662e+03
C667_783	667	783	2.5089982022002198e-10
R668_669	668	669	4.0372189405216559e+03
C668_669	668	669	2.1931403640586156e-10
R668_682	668	682	3.3875791079584610e+03
C668_682	668	682	2.6137213434215608e-10
R668_683	668	683	1.4099605230641648e+03
C668_683	668	683	6.2797416467787612e-10
R668_695	668	695	4.8829450601650969e+03
C668_695	668	695	1.8132884371835696e-10
R668_782	668	782	2.3119712685785207e+03
C668_782	668	782	3.8297136029912085e-10
R668_783	668	783	1.8273312995635879e+03
C668_783	668	783	4.8454201047804528e-10
R668_784	668	784	2.0565138814478564e+03
C668_784	668	784	4.3054354735336629e-10
R669_681	669	681	5.3151637414693823e+03
C669_681	669	681	1.6658353811226616e-10
R669_683	669	683	2.2295931500140978e+03
C669_683	669	683	3.9712123339381521e-10
R669_694	669	694	2.7287329254974966e+03
C669_694	669	694	3.2447982483979171e-10
R669_695	669	695	3.4336453879654632e+03
C669_695	669	695	2.5786552822352950e-10
R669_697	669	697	4.6931193102382258e+03
C669_697	669	697	1.8866317329040069e-10
R669_784	669	784	5.3422688958235167e+03
C669_784	669	784	1.6573834057514469e-10
R669_785	669	785	4.6797923111243244e+03
C669_785	669	785	1.8920044370244233e-10
R670_671	670	671	8.6852605900995677e+03
C670_671	670	671	1.0194498743184514e-10
R670_680	670	680	6.1198660678618135e+03
C670_680	670	680	1.4467943773307963e-10
R670_780	670	780	6.3807392605741306e+03
C670_780	670	780	1.3876429447147341e-10
R670_781	670	781	8.5681867247338032e+03
C670_781	670	781	1.0333794187095153e-10
R670_786	670	786	8.3203597230894029e+03
C670_786	670	786	1.0641592565318061e-10
R671_680	671	680	4.2743439836764210e+03
C671_680	671	680	2.0714729209473670e-10
R671_682	671	682	5.0633240583476327e+03
C671_682	671	682	1.7486907247033843e-10
R671_684	671	684	8.8428342595723316e+03
C671_684	671	684	1.0012839274258001e-10
R671_786	671	786	1.6073072180494439e+04
C671_786	671	786	5.5087090492538493e-11
R671_787	671	787	9.3054135101442989e+03
C671_787	671	787	9.5150933457686818e-11
R672_673	672	673	3.7108663724545936e+03
C672_673	672	673	2.3860163445183023e-10
R672_674	672	674	2.7670583417550156e+03
C672_674	672	674	3.1998558481366188e-10
R672_681	672	681	2.1058929636455964e+03
C672_681	672	681	4.2044814099535989e-10
R672_688	672	688	1.2589395037639270e+03
C672_688	672	688	7.0330526530687969e-10
R672_694	672	694	1.7393974955157985e+03
C672_694	672	694	5.0903763169869306e-10
R672_710	672	710	1.9139784068238812e+03
C672_710	672	710	4.6260646334526477e-10
R672_785	672	785	1.7946723202921755e+03
C672_785	672	785	4.9335957973422835e-10
R672_788	672	788	9.8641661689955890e+02
C672_788	672	788	8.9761138096293575e-10
R672_789	672	789	4.0331378988454235e+03
C672_789	672	789	2.1953595535463122e-10
R672_790	672	790	1.7393974955158164e+03
C672_790	672	790	5.0903763169868779e-10
R673_674	673	674	8.3874665065187892e+03
C673_674	673	674	1.0556450878365323e-10
R673_687	673	687	1.3558675983729307e+04
C673_687	673	687	6.5302746578096631e-11
R673_688	673	688	3.2148167852901202e+03
C673_688	673	688	2.7541811581654270e-10
R673_790	673	790	8.9129691369779684e+03
C673_790	673	790	9.9340496762923870e-11
R674_681	674	681	1.4216865454777135e+03
C674_681	674	681	6.2279465506405463e-10
R674_684	674	684	5.1198322078622759e+03
C674_684	674	684	1.7293902334148876e-10
R674_789	674	789	3.7675085747264734e+03
C674_789	674	789	2.3501440385289170e-10
R674_790	674	790	5.7872816683948668e+03
C674_790	674	790	1.5299389807401159e-10
R675_678	675	678	1.0240007243865723e+03
C675_678	675	678	8.6466616733148337e-10
R675_715	675	715	1.1494767357685939e+03
C675_715	675	715	7.7027986226095112e-10
R675_720	675	720	1.7960984440677985e+03
C675_720	675	720	4.9296784629171348e-10
R675_756	675	756	8.4740523702389908e+02
C675_756	675	756	1.0448587559000759e-09
R675_782	675	782	1.7765637662805400e+03
C675_782	675	782	4.9838840491142964e-10
R675_792	675	792	1.4598946935347012e+03
C675_792	675	792	6.0649496543906295e-10
R676_677	676	677	4.3676161236933685e+03
C676_677	676	677	2.0272358115375470e-10
R676_678	676	678	2.1380099529618510e+03
C676_678	676	678	4.1413220760427352e-10
R676_709	676	709	3.1065317043641026e+03
C676_709	676	709	2.8501842761049271e-10
R676_763	676	763	6.1631532839202846e+03
C676_763	676	763	1.4366327444914678e-10
R676_764	676	764	2.0917692012662819e+03
C676_764	676	764	4.2328703432673146e-10
R676_765	676	765	2.8681984618067022e+03
C676_765	676	765	3.0870206280714179e-10
R676_793	676	793	5.0228793093750210e+03
C676_793	676	793	1.7627713651160168e-10
R677_678	677	678	2.1258884416073333e+03
C677_678	677	678	4.1649353012642384e-10
R677_718	677	718	6.1043419152834058e+03
C677_718	677	718	1.4504737676688490e-10
R677_719	677	719	2.0898992654763688e+03
C677_719	677	719	4.2366577008111387e-10
R677_720	677	720	2.0199596229592646e+03
C677_720	677	720	4.3833489127017847e-10
R677_725	677	725	2.5618269359025826e+03
C677_725	677	725	3.4562006093828870e-10
R677_765	677	765	2.2098708037931265e+03
C677_765	677	765	4.0066540549801621e-10
R677_791	677	791	4.0099741488786981e+03
C677_791	677	791	2.2080411215308916e-10
R677_792	677	792	6.8936973791538358e+03
C677_792	677	792	1.2843888163374537e-10
R677_793	677	793	4.0911388896572721e+03
C677_793	677	793	2.1642354502762296e-10
R678_709	678	709	7.1915691846532827e+03
C678_709	678	709	1.2311899655911991e-10
R678_720	678	720	4.9295483192696438e+03
C678_720	678	720	1.7961458623681422e-10
R678_782	678	782	7.2444075262283186e+03
C678_782	678	782	1.2222100682413968e-10
R678_792	678	792	4.5954182453534004e+03
C678_792	678	792	1.9267425388217495e-10
R678_793	678	793	3.6989523807856108e+03
C678_793	678	793	2.3937014877492108e-10
R679_728	679	728	6.7559155718938337e+03
C679_728	679	728	1.3105829584128411e-10
R679_772	679	772	1.8996833465465527e+03
C679_772	679	772	4.6608756312445895e-10
R679_773	679	773	6.4279935209379191e+03
C679_773	679	773	1.3774419324100488e-10
R679_794	679	794	1.0454427809851104e+04
C679_794	679	794	8.4693184342970792e-11
R679_795	679	795	1.0049548219288188e+04
C679_795	679	795	8.8105331939261485e-11
R680_682	680	682	1.0393931986349983e+03
C680_682	680	682	8.5186124256228763e-10
R680_709	680	709	1.5182941670672071e+03
C680_709	680	709	5.8316682030749515e-10
R680_780	680	780	1.8845334134448722e+03
C680_780	680	780	4.6983448283969690e-10
R680_783	680	783	2.6978228985965129e+03
C680_783	680	783	3.2819751888110265e-10
R680_786	680	786	1.4599990078516203e+03
C680_786	680	786	6.0645163245890721e-10
R680_787	680	787	3.2338327104896030e+03
C680_787	680	787	2.7379857307644943e-10
R680_797	680	797	3.7925234928459522e+03
C680_797	680	797	2.3346428397087446e-10
R680_798	680	798	1.6583091444630602e+03
C680_798	680	798	5.3392866140570397e-10
R681_683	681	683	1.2603034557677249e+03
C681_683	681	683	7.0254411955146109e-10
R681_682	681	682	3.8021907181080683e+03
C681_682	681	682	2.3287069148929368e-10
R681_684	681	684	1.6581324052571565e+03
C681_684	681	684	5.3398557249876689e-10
R681_694	681	694	1.9897588863085978e+03
C681_694	681	694	4.4498797708230343e-10
R681_785	681	785	9.1645973746388211e+02
C681_785	681	785	9.6612949320634464e-10
R681_789	681	789	2.3904473777789958e+03
C681_789	681	789	3.7039877553073646e-10
R681_799	681	799	2.5699183598840705e+03
C681_799	681	799	3.4453187133148519e-10
R682_683	682	683	1.9727142479730271e+03
C682_683	682	683	4.4883276055301571e-10
R682_684	682	684	3.2514170273457726e+03
C682_684	682	684	2.7231781535658426e-10
R682_783	682	783	2.3690615184165604e+03
C682_783	682	783	3.7374241859780765e-10
R682_784	682	784	4.2095323496590299e+03
C682_784	682	784	2.1033661417799023e-10
R682_787	682	787	2.4383131669909303e+03
C682_787	682	787	3.6312758905890512e-10
R682_798	682	798	3.8083488600914766e+03
C682_798	682	798	2.3249413702050717e-10
R682_799	682	799	1.5133486050819954e+03
C682_799	682	799	5.8507258587126837e-10
R683_784	683	784	2.1357887764905222e+03
C683_784	683	784	4.1456289659640372e-10
R683_785	683	785	4.0747997881282495e+03
C683_785	683	785	2.1729135852996480e-10
R683_799	683	799	4.8233300557990860e+03
C683_799	683	799	1.8357001728203563e-10
R684_787	684	787	6.8625026538130214e+03
C684_787	684	787	1.2902272339494595e-10
R684_789	684	789	5.9301734353173479e+03
C684_789	684	789	1.4930740076282738e-10
R684_799	684	799	7.1395562361743032e+03
C684_799	684	799	1.2401594054456909e-10
R685_686	685	686	1.7550674806544921e+03
C685_686	685	686	5.0449272831937697e-10
R685_687	685	687	2.1204803563784822e+03
C685_687	685	687	4.1755575760776470e-10
R685_688	685	688	3.3337334442866700e+03
C685_688	685	688	2.6559375441891579e-10
R685_712	685	712	4.4794542746756570e+03
C685_712	685	712	1.9766219887669472e-10
R685_713	685	713	1.5105235369449513e+03
C685_713	685	713	5.8616682232623015e-10
R685_714	685	714	2.1918609572229811e+03
C685_714	685	714	4.0395754976255322e-10
R685_800	685	800	6.5283117198419241e+03
C685_800	685	800	1.3562752817223616e-10
R686_687	686	687	6.4392505342454206e+03
C686_687	686	687	1.3750339064944573e-10
R686_714	686	714	6.3490865531429363e+03
C686_714	686	714	1.3945608935850759e-10
R686_800	686	800	6.1034015868719644e+03
C686_800	686	800	1.4506972367744582e-10
R687_688	687	688	1.3204309522215071e+03
C687_688	687	688	6.7055288291323523e-10
R687_713	687	713	2.1044263691471183e+03
C687_713	687	713	4.2074115525307861e-10
R687_790	687	790	6.2481337321692808e+03
C687_790	687	790	1.4170931987920060e-10
R687_800	687	800	4.7955042126149183e+03
C687_800	687	800	1.8463517962737729e-10
R687_801	687	801	4.4475836347725035e+03
C687_801	687	801	1.9907861310972059e-10
R688_710	688	710	1.2284394022759041e+03
C688_710	688	710	7.2076716202655440e-10
R688_713	688	713	1.2198147570467220e+03
C688_713	688	713	7.2586331374091302e-10
R688_788	688	788	1.8946466728853711e+03
C688_788	688	788	4.6732659675885079e-10
R688_790	688	790	1.6191817611673944e+03
C688_790	688	790	5.4683100003648308e-10
R688_801	688	801	4.0687953079494414e+03
C688_801	688	801	2.1761202387598760e-10
R688_802	688	802	3.9497236814488206e+03
C688_802	688	802	2.2417233536073961e-10
R689_698	689	698	1.2523326958468092e+03
C689_698	689	698	7.0701562343327045e-10
R689_700	689	700	1.5027992350161719e+03
C689_700	689	700	5.8917968619439170e-10
R689_704	689	704	1.3433459966247026e+03
C689_704	689	704	6.5911446784723172e-10
R689_707	689	707	2.5462765230138043e+03
C689_707	689	707	3.4773080366464182e-10
R689_708	689	708	3.6795972094237281e+03
C689_708	689	708	2.4062926763624437e-10
R689_762	689	762	2.0521915442874492e+03
C689_762	689	762	4.3145036054976553e-10
R689_803	689	803	1.5064619563513522e+03
C689_803	689	803	5.8774719000835758e-10
R690_692	690	692	1.0710643896663553e+03
C690_692	690	692	8.2667185114408898e-10
R690_694	690	694	3.8727920147723521e+03
C690_694	690	694	2.2862544085059682e-10
R690_697	690	697	1.8699253519535871e+03
C690_697	690	697	4.7350488123762101e-10
R690_698	690	698	4.0615132643810198e+03
C690_698	690	698	2.1800218885532532e-10
R690_707	690	707	1.8893935183805463e+03
C690_707	690	707	4.6862592312633625e-10
R690_710	690	710	2.3878277316713256e+03
C690_710	690	710	3.7080513386962959e-10
R690_711	690	711	3.4286417059712526e+03
C690_711	690	711	2.5824185133079748e-10
R690_804	690	804	2.5657214728637550e+03
C690_804	690	804	3.4509544043053555e-10
R690_805	690	805	4.9977990645289256e+03
C690_805	690	805	1.7716174065182358e-10
R691_692	691	692	1.0079804419315045e+03
C691_692	691	692	8.7840869214024621e-10
R691_693	691	693	1.3011729012141584e+03
C691_693	691	693	6.8047742223481050e-10
R691_698	691	698	2.3457065088981203e+03
C691_698	691	698	3.7746358222620088e-10
R691_699	691	699	1.3068339255449598e+03
C691_699	691	699	6.7752968789111719e-10
R691_804	691	804	3.7585983618643900e+03
C691_804	691	804	2.3557153397491581e-10
R691_806	691	806	5.3212177660113639e+03
C691_806	691	806	1.6639401367023645e-10
R692_693	692	693	4.2147134343043872e+03
C692_693	692	693	2.1007805050122778e-10
R692_698	692	698	3.8699212159334311e+03
C692_698	692	698	2.2879504059527366e-10
R692_710	692	710	3.3825833294989752e+03
C692_710	692	710	2.6175815802626435e-10
R692_712	692	712	1.5669082614551326e+03
C692_712	692	712	5.6507378477776542e-10
R692_804	692	804	1.4758427273936259e+03
C692_804	692	804	5.9994114905703484e-10
R692_805	692	805	2.8010979153882422e+03
C692_805	692	805	3.1609704781679431e-10
R692_806	692	806	4.2428320401633782e+03
C692_806	692	806	2.0868579602455947e-10
R693_699	693	699	7.1141183959395648e+03
C693_699	693	699	1.2445938237482234e-10
R693_712	693	712	1.5906496249441482e+03
C693_712	693	712	5.5663973248105431e-10
R693_714	693	714	7.3601275401882931e+03
C693_714	693	714	1.2029938025739001e-10
R693_806	693	806	3.2928270412234451e+03
C693_806	693	806	2.6889319439353972e-10
R694_697	694	697	1.3033321488785023e+03
C694_697	694	697	6.7935006626046145e-10
R694_710	694	710	1.5831303870635359e+03
C694_710	694	710	5.5928354918530501e-10
R694_785	694	785	1.5528483766334239e+03
C694_785	694	785	5.7019010678916925e-10
R694_807	694	807	6.4345360674275844e+03
C694_807	694	807	1.3760413686731811e-10
R695_697	695	697	3.2961480670490660e+03
C695_697	695	697	2.6862227172115076e-10
R695_696	695	696	1.9479267608670589e+03
C695_696	695	696	4.5454418486754785e-10
R695_707	695	707	5.2264671412951511e+03
C695_707	695	707	1.6941057080492578e-10
R695_711	695	711	7.3913178787658098e+03
C695_711	695	711	1.1979173352071360e-10
R695_755	695	755	6.0968553719571546e+03
C695_755	695	755	1.4522548554662062e-10
R695_756	695	756	2.9382149294072256e+03
C695_756	695	756	3.0134581811502479e-10
R695_782	695	782	2.2624756745218451e+03
C695_782	695	782	3.9134952550909782e-10
R695_784	695	784	3.1819749761780809e+03
C695_784	695	784	2.7826076205146345e-10
R695_808	695	808	3.0318578544053594e+03
C695_808	695	808	2.9203835543063676e-10
R696_707	696	707	8.1653084081649658e+03
C696_707	696	707	1.0843666123065460e-10
R696_755	696	755	2.4472559073554462e+03
C696_755	696	755	3.6180065151290257e-10
R696_756	696	756	3.5597919909313605e+03
C696_756	696	756	2.4872767396399047e-10
R696_758	696	758	4.1434932747681951e+03
C696_758	696	758	2.1368896314898308e-10
R696_760	696	760	2.0688389362436701e+03
C696_760	696	760	4.2797859523449842e-10
R696_761	696	761	3.4449701956088520e+03
C696_761	696	761	2.5701783511178222e-10
R696_782	696	782	1.0120886745894788e+04
C696_782	696	782	8.7484308828882185e-11
R696_808	696	808	5.8929398485936808e+03
C696_808	696	808	1.5025077541073163e-10
R697_707	697	707	4.2196298805844935e+03
C697_707	697	707	2.0983328082257158e-10
R697_710	697	710	4.2467016492215362e+03
C697_710	697	710	2.0849564081392584e-10
R697_711	697	711	1.4695509590370318e+03
C697_711	697	711	6.0250975051603367e-10
R697_784	697	784	6.3008083264313500e+03
C697_784	697	784	1.4052463363878951e-10
R697_785	697	785	4.7610722170273175e+03
C697_785	697	785	1.8597045819498849e-10
R697_807	697	807	2.1807471227371739e+03
C697_807	697	807	4.0601625583651486e-10
R697_808	697	808	7.6256457689895142e+03
C697_808	697	808	1.1611066243080005e-10
R698_699	698	699	2.5517172579312114e+03
C698_699	698	699	3.4698937703538824e-10
R698_703	698	703	2.0640091630606262e+03
C698_703	698	703	4.2898006343491838e-10
R698_704	698	704	3.9648259282298059e+03
C698_704	698	704	2.2331845022394641e-10
R698_707	698	707	3.4483491734967315e+03
C698_707	698	707	2.5676598776746223e-10
R698_803	698	803	2.0029825185056427e+03
C698_803	698	803	4.4205017942971414e-10
R698_804	698	804	9.7116944607558764e+02
C698_804	698	804	9.1170370451613918e-10
R698_809	698	809	5.4831289572684136e+03
C698_809	698	809	1.6148056859510712e-10
R699_703	699	703	6.7704909799647221e+03
C699_703	699	703	1.3077615557278442e-10
R699_804	699	804	3.5238764501183632e+03
C699_804	699	804	2.5126271997142798e-10
R699_806	699	806	4.5085853861163341e+03
C699_806	699	806	1.9638505337539895e-10
R699_809	699	809	4.1592652415309549e+03
C699_809	699	809	2.1287865290699573e-10
R700_701	700	701	1.6659033873151473e+03
C700_701	700	701	5.3149467636714812e-10
R700_702	700	702	2.6528572171448209e+03
C700_702	700	702	3.3376043609800675e-10
R700_708	700	708	2.4725416901810804e+03
C700_708	700	708	3.5810064809671824e-10
R700_757	700	757	2.7955000525731539e+03
C700_757	700	757	3.1673001790323879e-10
R700_761	700	761	2.8434702573978757e+03
C700_761	700	761	3.1138668653079809e-10
R700_762	700	762	1.7551277606443080e+03
C700_762	700	762	5.0447540148015356e-10
R700_810	700	810	2.0881785975240277e+03
C700_810	700	810	4.2401487245863415e-10
R701_702	701	702	9.9280706733202794e+02
C701_702	701	702	8.9183368132077010e-10
R701_754	701	754	1.2805956178625397e+03
C701_754	701	754	6.9141169105190695e-10
R701_757	701	757	1.7581247418474338e+03
C701_757	701	757	5.0361544924827342e-10
R701_770	701	770	3.8268572992718550e+03
C701_770	701	770	2.3136968861328349e-10
R701_810	701	810	2.5151518904054278e+03
C701_810	701	810	3.5203392092446384e-10
R701_811	701	811	3.0595389401291854e+03
C701_811	701	811	2.8939614727133177e-10
R702_708	702	708	1.8787781301002062e+03
C702_708	702	708	4.7127373238732311e-10
R702_716	702	716	2.4260244767055824e+03
C702_716	702	716	3.6496696146378278e-10
R702_770	702	770	4.5582465485846751e+03
C702_770	702	770	1.9424547844497805e-10
R702_810	702	810	1.2806261011896420e+03
C702_810	702	810	6.9139523306411404e-10
R702_811	702	811	1.5831094372666666e+03
C702_811	702	811	5.5929095036457410e-10
R702_812	702	812	3.5103472938497393e+03
C702_812	702	812	2.5223110637835952e-10
R703_704	703	704	1.8251424238810077e+03
C703_704	703	704	4.8512311703172918e-10
R703_705	703	705	7.4672386007979103e+03
C703_705	703	705	1.1857378999586127e-10
R703_803	703	803	5.4541243468615230e+03
C703_803	703	803	1.6233930973896812e-10
R703_809	703	809	5.5115944137895967e+03
C703_809	703	809	1.6064657796385537e-10
R703_813	703	813	5.0703719107481393e+03
C703_813	703	813	1.7462600323717785e-10
R704_705	704	705	1.3851690948573671e+03
C704_705	704	705	6.3921349746196357e-10
R704_708	704	708	1.6634132833476481e+03
C704_708	704	708	5.3229031568034580e-10
R704_803	704	803	2.3419167179620549e+03
C704_803	704	803	3.7807441012270290e-10
R704_813	704	813	3.4475727714658606e+03
C704_813	704	813	2.5682381211159530e-10
R705_706	705	706	5.6911241435221418e+03
C705_706	705	706	1.5557889080803447e-10
R705_708	705	708	3.1098745125625924e+03
C705_708	705	708	2.8471206092827172e-10
R705_813	705	813	5.5384350093350986e+03
C705_813	705	813	1.5986804579409451e-10
R705_814	705	814	8.3314151116819176e+03
C705_814	705	814	1.0627471681953617e-10
R706_708	706	708	1.2066418062031022e+04
C706_708	706	708	7.3378758894996062e-11
R706_716	706	716	8.3643051922772956e+03
C706_716	706	716	1.0585682388986725e-10
R706_814	706	814	8.3819702501217234e+03
C706_814	706	814	1.0563372993206960e-10
R706_815	706	815	2.4401395157856809e+04
C706_815	706	815	3.6285580229002238e-11
R707_711	707	711	3.0819762376846684e+03
C707_711	707	711	2.8728929537924345e-10
R707_755	707	755	3.5181808143605699e+03
C707_755	707	755	2.5166949296235222e-10
R707_762	707	762	6.0788261675423337e+03
C707_762	707	762	1.4565621014590956e-10
R707_803	707	803	8.3828446612167772e+03
C707_803	707	803	1.0562271132094208e-10
R707_804	707	804	6.1955584280334078e+03
C707_804	707	804	1.4291186048600456e-10
R707_816	707	816	7.6616460089387938e+03
C707_816	707	816	1.1556508623172980e-10
R708_716	708	716	8.8984375314572990e+03
C708_716	708	716	9.9502724896355492e-11
R708_762	708	762	1.1826278217620771e+04
C708_762	708	762	7.4868759672908323e-11
R708_803	708	803	1.0866203503439845e+04
C708_803	708	803	8.1483729015355626e-11
R708_810	708	810	5.3614952129252542e+03
C708_810	708	810	1.6514400303211534e-10
R708_812	708	812	8.0050476369356720e+03
C708_812	708	812	1.1060755936224983e-10
R708_813	708	813	9.1124610355855039e+03
C708_813	708	813	9.7165713877108419e-11
R708_814	708	814	6.3609653705931823e+03
C708_814	708	814	1.3919566136821016e-10
R708_818	708	818	5.6267800270883517e+03
C708_818	708	818	1.5735798759458013e-10
R709_764	709	764	4.0639702538529514e+03
C709_764	709	764	2.1787038939582684e-10
R709_780	709	780	7.1348675315779938e+03
C709_780	709	780	1.2409743807873823e-10
R709_782	709	782	9.7790168560760503e+03
C709_782	709	782	9.0542719654875922e-11
R709_783	709	783	3.5312745418831805e+03
C709_783	709	783	2.5073631947852409e-10
R709_793	709	793	5.1270060410567412e+03
C709_793	709	793	1.7269704279839384e-10
R709_797	709	797	5.6808086435466330e+03
C709_797	709	797	1.5586139883550392e-10
R709_798	709	798	7.1235296408987379e+03
C709_798	709	798	1.2429495297057419e-10
R709_819	709	819	5.3442211749707312e+03
C709_819	709	819	1.6567779526917674e-10
R709_820	709	820	9.1301553703003028e+03
C709_820	709	820	9.6977405727420542e-11
R710_711	710	711	8.6487102612069721e+03
C710_711	710	711	1.0237581731364826e-10
R710_712	710	712	4.2424430210566316e+03
C710_712	710	712	2.0870493187660442e-10
R710_713	710	713	5.1359065158678031e+03
C710_713	710	713	1.7239776054420507e-10
R710_785	710	785	8.9068256126473643e+03
C710_785	710	785	9.9409017331914289e-11
R710_788	710	788	3.3335190601714835e+03
C710_788	710	788	2.6561083519182042e-10
R710_802	710	802	3.1615655943558008e+03
C710_802	710	802	2.8005706517071733e-10
R710_805	710	805	4.0524556097116970e+03
C710_805	710	805	2.1848944614670099e-10
R710_807	710	807	2.4378983214800996e+03
C710_807	710	807	3.6318938074597132e-10
R710_822	710	822	8.7187147392031929e+03
C710_822	710	822	1.0155381936270561e-10
R711_755	711	755	2.1818696094812435e+03
C711_755	711	755	4.0580737632186704e-10
R711_804	711	804	5.4734400793210334e+03
C711_804	711	804	1.6176641542951429e-10
R711_805	711	805	2.0979608888609537e+03
C711_805	711	805	4.2203779222057897e-10
R711_807	711	807	1.7010910184195088e+03
C711_807	711	807	5.2050053295951605e-10
R711_808	711	808	3.4426855969823287e+03
C711_808	711	808	2.5718839457082872e-10
R711_816	711	816	1.1928307294757997e+03
C711_816	711	816	7.4228367849737203e-10
R711_822	711	822	7.6387291269423476e+03
C711_822	711	822	1.1591179199915130e-10
R712_713	712	713	3.5855642556234884e+03
C712_713	712	713	2.4693987293947856e-10
R712_714	712	714	4.0340627254570300e+03
C712_714	712	714	2.1948562577189192e-10
R712_802	712	802	1.0872744566920628e+04
C712_802	712	802	8.1434708251475806e-11
R712_805	712	805	8.6804495555151952e+03
C712_805	712	805	1.0200148921289934e-10
R712_806	712	806	4.0977332179834002e+03
C712_806	712	806	2.1607526273653737e-10
R712_822	712	822	1.0705705998968950e+04
C712_822	712	822	8.2705314510343684e-11
R712_823	712	823	1.1722581938982194e+04
C712_823	712	823	7.5531037983674442e-11
R713_714	713	714	5.1639770280502253e+03
C713_714	713	714	1.7146063526047673e-10
R713_800	713	800	7.8894505432001279e+03
C713_800	713	800	1.1222819344030714e-10
R713_801	713	801	7.7631234834785464e+03
C713_801	713	801	1.1405445032329389e-10
R713_802	713	802	3.6150711612027139e+03
C713_802	713	802	2.4492430223847274e-10
R713_823	713	823	8.0072692560321584e+03
C713_823	713	823	1.1057687126394344e-10
R714_800	714	800	1.0567197384274372e+04
C714_800	714	800	8.3789367180520387e-11
R714_806	714	806	1.7105652766379721e+04
C714_806	714	806	5.1761765177429830e-11
R714_823	714	823	1.0354070682268793e+04
C714_823	714	823	8.5514075465629936e-11
R715_717	715	717	4.8681575356455196e+03
C715_717	715	717	1.8187964855631836e-10
R715_720	715	720	4.8945056809233911e+03
C715_720	715	720	1.8090055246048015e-10
R715_756	715	756	6.0851969195569973e+03
C715_756	715	756	1.4550371884505239e-10
R715_758	715	758	3.6943032651753470e+03
C715_758	715	758	2.3967138541290667e-10
R715_759	715	759	3.9131790518315615e+03
C715_759	715	759	2.2626584931900322e-10
R715_792	715	792	4.7245426915883845e+03
C715_792	715	792	1.8740835663870858e-10
R715_825	715	825	6.1762009584620873e+03
C715_825	715	825	1.4335977531412364e-10
R716_770	716	770	1.4304080179842409e+04
C716_770	716	770	6.1899735639607893e-11
R716_811	716	811	1.4129190827813929e+04
C716_811	716	811	6.2665922804086880e-11
R716_812	716	812	6.3773837946932226e+03
C716_812	716	812	1.3883730542244905e-10
R716_814	716	814	1.6555778691299314e+04
C716_814	716	814	5.3480950561710577e-11
R716_815	716	815	1.4592215746785832e+04
C716_815	716	815	6.0677473323064577e-11
R716_827	716	827	1.4636893652474313e+04
C716_827	716	827	6.0492260360880821e-11
R717_718	717	718	4.2612292828785476e+03
C717_718	717	718	2.0778482520468403e-10
R717_720	717	720	5.0495781232471863e+03
C717_720	717	720	1.7534510014286540e-10
R717_721	717	721	3.8712959721828829e+03
C717_721	717	721	2.2871379198649715e-10
R717_722	717	722	4.6470471707430643e+03
C717_722	717	722	1.9053363333052231e-10
R717_759	717	759	6.1181457396353680e+03
C717_759	717	759	1.4472011935968849e-10
R717_766	717	766	4.0687913142176208e+03
C717_766	717	766	2.1761223747358869e-10
R717_825	717	825	5.2459131633571724e+03
C717_825	717	825	1.6878258448589489e-10
R717_828	717	828	7.1611877414000983e+03
C717_828	717	828	1.2364133069452109e-10
R718_719	718	719	1.3361933937940437e+03
C718_719	718	719	6.6264268766207925e-10
R718_720	718	720	2.2289003001432607e+03
C718_720	718	720	3.9724467785440679e-10
R718_722	718	722	1.7123291988617605e+03
C718_722	718	722	5.1708443813757666e-10
R718_730	718	730	4.0805847765939161e+03
C718_730	718	730	2.1698330758344483e-10
R718_828	718	828	7.1598537489220334e+03
C718_828	718	828	1.2366436700376821e-10
R719_720	719	720	2.6772911778196194e+03
C719_720	719	720	3.3071441352191035e-10
R719_725	719	725	1.2631623737609373e+03
C719_725	719	725	7.0095405000368694e-10
R719_730	719	730	1.0741773416211374e+03
C719_730	719	730	8.2427616687923715e-10
R719_722	719	722	4.6958511178225008e+03
C719_722	719	722	1.8855341864215128e-10
R719_752	719	752	1.6085955903465908e+03
C719_752	719	752	5.5042969594938788e-10
R719_791	719	791	4.1579557627306895e+03
C719_791	719	791	2.1294569548727269e-10
R719_828	719	828	2.2135471694960297e+03
C719_828	719	828	3.9999996110387293e-10
R720_791	720	791	6.8782429119219241e+03
C720_791	720	791	1.2872746616222597e-10
R720_792	720	792	3.4440675110948891e+03
C720_792	720	792	2.5708519906989869e-10
R720_825	720	825	4.4725492169367235e+03
C720_825	720	825	1.9796736464007633e-10
R720_828	720	828	6.1898379414163346e+03
C720_828	720	828	1.4304393589622833e-10
R721_722	721	722	5.7432664596799550e+03
C721_722	721	722	1.5416641173032745e-10
R721_723	721	723	5.0799550215322824e+03
C721_723	721	723	1.7429657899469524e-10
R721_724	721	724	4.4629254934251558e+03
C721_724	721	724	1.9839425574198169e-10
R721_766	721	766	5.9724856521628908e+03
C721_766	721	766	1.4824962892616616e-10
R721_767	721	767	5.9205971305992398e+03
C721_767	721	767	1.4954889889803808e-10
R721_831	721	831	7.1686736887305988e+03
C721_831	721	831	1.2351221720301049e-10
R722_723	722	723	1.9518948826813519e+03
C722_723	722	723	4.5362011528186653e-10
R722_730	722	730	1.3339724947150391e+03
C722_730	722	730	6.6374590571235261e-10
R722_766	722	766	8.7790184607131159e+03
C722_766	722	766	1.0085623873128043e-10
R722_828	722	828	2.4166752536416684e+03
C722_828	722	828	3.6637888370221434e-10
R722_830	722	830	4.6631275410786684e+03
C722_830	722	830	1.8987659546090527e-10
R722_831	722	831	5.9893497084592973e+03
C722_831	722	831	1.4783220629936562e-10
R723_724	723	724	3.8849267210960206e+03
C723_724	723	724	2.2791132118193581e-10
R723_730	723	730	4.7548614947947035e+03
C723_730	723	730	1.8621336976256736e-10
R723_731	723	731	2.4820044961574386e+03
C723_731	723	731	3.5673536573796606e-10
R723_734	723	734	2.3829669912934314e+03
C723_734	723	734	3.7156149662795395e-10
R723_829	723	829	4.5120918607032054e+03
C723_829	723	829	1.9623243697924367e-10
R723_830	723	830	1.4275765453394724e+03
C723_830	723	830	6.2022508326476508e-10
R723_831	723	831	1.6502726102988725e+03
C723_831	723	831	5.3652879904469018e-10
R724_734	724	734	8.3881178360542817e+03
C724_734	724	734	1.0555631179789144e-10
R724_767	724	767	4.7717423659163405e+03
C724_767	724	767	1.8555460747930993e-10
R724_769	724	769	1.1049459467309180e+04
C724_769	724	769	8.0132316365301975e-11
R724_831	724	831	6.4327274226462278e+03
C724_831	724	831	1.3764282605585143e-10
R724_832	724	832	9.3789935514066565e+03
C724_832	724	832	9.4404455749647628e-11
R725_752	725	752	1.5954052147751527e+03
C725_752	725	752	5.5498049868464669e-10
R725_751	725	751	4.7029919846039720e+03
C725_751	725	751	1.8826712539561327e-10
R725_765	725	765	2.6613691102662360e+03
C725_765	725	765	3.3269296554337225e-10
R725_774	725	774	1.3135024496015110e+03
C725_774	725	774	6.7408993562868313e-10
R725_791	725	791	2.1325346405273144e+03
C725_791	725	791	4.1519549782368914e-10
R725_838	725	838	4.1153185821117031e+03
C725_838	725	838	2.1515194122484271e-10
R726_727	726	727	4.7593026420764900e+03
C726_727	726	727	1.8603960459923408e-10
R726_750	726	750	8.5640935039819215e+03
C726_750	726	750	1.0338733238822298e-10
R726_751	726	751	3.9053912696948405e+03
C726_751	726	751	2.2671704844805088e-10
R726_774	726	774	2.3889720846569012e+03
C726_774	726	774	3.7062751272255323e-10
R726_775	726	775	2.3877412228087869e+03
C726_775	726	775	3.7081856829462025e-10
R726_776	726	776	4.3634257152829623e+03
C726_776	726	776	2.0291826639761691e-10
R726_837	726	837	6.6368578494685025e+03
C726_837	726	837	1.3340933341986626e-10
R726_839	726	839	1.4400044744946792e+03
C726_839	726	839	6.1487224337320750e-10
R726_840	726	840	6.2717995701201771e+03
C726_840	726	840	1.4117459778502361e-10
R727_733	727	733	4.7850469283275279e+03
C727_733	727	733	1.8503868299771766e-10
R727_750	727	750	3.5295352393289636e+03
C727_750	727	750	2.5085987861346190e-10
R727_728	727	728	5.3436125668876566e+03
C727_728	727	728	1.6569666505887888e-10
R727_775	727	775	6.8974793438745110e+03
C727_775	727	775	1.2836845716490905e-10
R727_837	727	837	4.7845567630836094e+03
C727_837	727	837	1.8505763972363333e-10
R727_835	727	835	5.6369108027037173e+03
C727_835	727	835	1.5707518048277670e-10
R727_840	727	840	3.8288251349865845e+03
C727_840	727	840	2.3125077549489667e-10
R728_772	728	772	9.4017563786680203e+03
C728_772	728	772	9.4175890763236356e-11
R728_775	728	775	5.7223842262530015e+03
C728_775	728	775	1.5472899873411147e-10
R728_795	728	795	8.3205053737543549e+03
C728_795	728	795	1.0641406283960895e-10
R728_836	728	836	8.2474102960723994e+03
C728_836	728	836	1.0735718848881037e-10
R728_837	728	837	6.1436656489976458e+03
C728_837	728	837	1.4411897265998814e-10
R728_835	728	835	1.3604131784905141e+04
C728_835	728	835	6.5084548995801560e-11
R728_843	728	843	7.6699054191212272e+03
C728_843	728	843	1.1544063887575892e-10
R728_844	728	844	1.5707693680052229e+04
C728_844	728	844	5.6368477749500910e-11
R729_730	729	730	8.6401453409054329e+02
C729_730	729	730	1.0247730180048265e-09
R729_731	729	731	2.7788239784103357e+03
C729_731	729	731	3.1863075480099897e-10
R729_732	729	732	1.1775366838633902e+03
C729_732	729	732	7.5192458445967237e-10
R729_750	729	750	2.6052867834236354e+03
C729_750	729	750	3.3985463225528738e-10
R729_752	729	752	4.0691294647589816e+03
C729_752	729	752	2.1759415358204738e-10
R729_830	729	830	6.9733538209706448e+03
C729_830	729	830	1.2697172758355110e-10
R729_847	729	847	3.3891630498769664e+03
C729_847	729	847	2.6124998079751364e-10
R730_731	730	731	6.1333889448787886e+03
C730_731	730	731	1.4436044895527137e-10
R730_752	730	752	2.7800761838064136e+03
C730_752	730	752	3.1848723673741408e-10
R730_828	730	828	4.3447715368033378e+03
C730_828	730	828	2.0378949139209423e-10
R730_830	730	830	2.7628574112350047e+03
C730_830	730	830	3.2047212357014669e-10
R730_847	730	847	7.0301150881524072e+03
C730_847	730	847	1.2594655572455187e-10
R731_732	731	732	2.7041564167744041e+03
C731_732	731	732	3.2742883370487619e-10
R731_734	731	734	7.9143976290197324e+03
C731_734	731	734	1.1187443734864089e-10
R731_735	731	735	3.7592936529133126e+03
C731_735	731	735	2.3552796441263202e-10
R731_736	731	736	5.0961583039730522e+03
C731_736	731	736	1.7374240141043350e-10
R731_740	731	740	8.8347125331628067e+03
C731_740	731	740	1.0022044049270521e-10
R731_768	731	768	5.2341857727334800e+03
C731_768	731	768	1.6916074823183102e-10
R731_829	731	829	2.7099288476117631e+03
C731_829	731	829	3.2673137616890267e-10
R731_830	731	830	2.8168847627643167e+03
C731_830	731	830	3.1432552492175958e-10
R731_847	731	847	3.9519708977817118e+03
C731_847	731	847	2.2404486384173432e-10
R732_733	732	733	5.3835555698410481e+03
C732_733	732	733	1.6446728750422140e-10
R732_735	732	735	3.6976601181744513e+03
C732_735	732	735	2.3945380413631273e-10
R732_740	732	740	2.0543410827587700e+03
C732_740	732	740	4.3099891694273726e-10
R732_750	732	750	2.4703898395657293e+03
C732_750	732	750	3.5841257420960266e-10
R732_847	732	847	4.6049314713428848e+03
C732_847	732	847	1.9227621240621751e-10
R733_740	733	740	2.3293493242421177e+03
C733_740	733	740	3.8011421150328401e-10
R733_741	733	741	1.2199653720703602e+04
C733_741	733	741	7.2577369978738579e-11
R733_742	733	742	5.7437453834955531e+03
C733_742	733	742	1.5415355705777266e-10
R733_750	733	750	5.4170758493484263e+03
C733_750	733	750	1.6344958171602848e-10
R733_840	733	840	7.5569244432241685e+03
C733_840	733	840	1.1716655212742014e-10
R733_835	733	835	9.2475828904414175e+03
C733_835	733	835	9.5745968669845152e-11
R733_849	733	849	8.9760897602818895e+03
C733_849	733	849	9.8641925977375016e-11
R734_736	734	736	5.3166371841224000e+03
C734_736	734	736	1.6653737146935920e-10
R734_829	734	829	2.5712777247158911e+03
C734_829	734	829	3.4434972667055346e-10
R734_831	734	831	7.1028985024034264e+03
C734_831	734	831	1.2465598113226573e-10
R734_832	734	832	5.6536523912925768e+03
C734_832	734	832	1.5661004964926211e-10
R734_853	734	853	9.6281897002211426e+03
C734_853	734	853	9.1961086067889109e-11
R735_736	735	736	1.9143279553177119e+03
C735_736	735	736	4.6252199328774427e-10
R735_737	735	737	5.0535801487128183e+03
C735_737	735	737	1.7520624104982732e-10
R735_740	735	740	1.9143279553177035e+03
C735_740	735	740	4.6252199328774633e-10
R735_741	735	741	4.8594367091309841e+03
C735_741	735	741	1.8220605282013025e-10
R735_768	735	768	1.5787632140263952e+03
C735_768	735	768	5.6083063871362586e-10
R735_852	735	852	4.6522346116310537e+03
C735_852	735	852	1.9032118016713174e-10
R735_854	735	854	5.5081459267185337e+03
C735_854	735	854	1.6074715402964759e-10
R736_737	736	737	1.0829004509183887e+04
C736_737	736	737	8.1763635886298870e-11
R736_768	736	768	4.2272305715068760e+03
C736_768	736	768	2.0945599411303839e-10
R736_829	736	829	7.1383620452922742e+03
C736_829	736	829	1.2403668741962043e-10
R736_853	736	853	8.0555014353283232e+03
C736_853	736	853	1.0991479410789929e-10
R736_854	736	854	7.8772427526545407e+03
C736_854	736	854	1.1240211956164788e-10
R737_741	737	741	1.8326241505089438e+04
C737_741	737	741	4.8314259170605590e-11
R737_738	737	738	5.5569761197379448e+04
C737_738	737	738	1.5933463859149252e-11
R737_854	737	854	2.1804774164175778e+04
C737_854	737	854	4.0606647655846937e-11
R738_739	738	739	1.1613482722592804e+04
C738_739	738	739	7.6240590600570766e-11
R738_745	738	745	8.6516002691181584e+03
C738_745	738	745	1.0234161937190947e-10
R738_748	738	748	8.4998096419683789e+03
C738_748	738	748	1.0416924837095002e-10
R738_741	738	741	1.0081408052373987e+04
C738_741	738	741	8.7826896510899601e-11
R738_851	738	851	5.5632252811588360e+03
C738_851	738	851	1.5915565826512148e-10
R738_854	738	854	7.9932484479711939e+03
C738_854	738	854	1.1077083209201791e-10
R738_855	738	855	7.4897659281486931e+03
C738_855	738	855	1.1821714993419773e-10
R739_747	739	747	3.7399055730539590e+03
C739_747	739	747	2.3674896716094853e-10
R739_745	739	745	9.5165213233873703e+02
C739_745	739	745	9.3040172097763807e-10
R739_744	739	744	6.6732807662734349e+03
C739_744	739	744	1.3268118227167669e-10
R739_748	739	748	8.3881376231285740e+03
C739_748	739	748	1.0555606279737694e-10
R739_749	739	749	5.2357801407317011e+03
C739_749	739	749	1.6910923642723136e-10
R739_855	739	855	5.5936066435457287e+03
C739_855	739	855	1.5829121318740824e-10
R740_741	740	741	2.0238888932994087e+03
C740_741	740	741	4.3748388789098095e-10
R740_742	740	742	5.0031632292211680e+03
C740_742	740	742	1.7697179586879704e-10
R740_750	740	750	3.2825492989650043e+03
C740_750	740	750	2.6973510557150648e-10
R740_768	740	768	2.3099864375931302e+03
C740_768	740	768	3.8330042431874805e-10
R740_840	740	840	7.3082670304647472e+03
C740_840	740	840	1.2115304189202491e-10
R740_847	740	847	4.4181490743969498e+03
C740_847	740	847	2.0040491318660501e-10
R740_849	740	849	4.0909010834218711e+03
C740_849	740	849	2.1643612584232503e-10
R740_850	740	850	1.3291239702363198e+03
C740_850	740	850	6.6616719096757517e-10
R740_852	740	852	2.9994808781102729e+03
C740_852	740	852	2.9519067388015146e-10
R740_860	740	860	4.4147394406547528e+03
C740_860	740	860	2.0055969182377908e-10
R741_742	741	742	7.1443180292764118e+03
C741_742	741	742	1.2393328209518086e-10
R741_748	741	748	1.1883559770590422e+04
C741_748	741	748	7.4507874643021125e-11
R741_851	741	851	1.0267226622623039e+04
C741_851	741	851	8.6237385639180128e-11
R741_852	741	852	7.3558873301947560e+03
C741_852	741	852	1.2036872534269196e-10
R741_854	741	854	1.0897068833243697e+04
C741_854	741	854	8.1252930971570277e-11
R741_860	741	860	8.8278366101867050e+03
C741_860	741	860	1.0029850129739475e-10
R742_846	742	846	3.3433462686053881e+03
C742_846	742	846	2.6483011646572139e-10
R742_834	742	834	3.1810409529367025e+03
C742_834	742	834	2.7834246550098355e-10
R742_835	742	835	4.1319003798739186e+03
C742_835	742	835	2.1428851141058192e-10
R742_849	742	849	2.3693960789577013e+03
C742_849	742	849	3.7368964588204114e-10
R742_860	742	860	2.9945016202477436e+03
C742_860	742	860	2.9568151698870906e-10
R742_748	742	748	4.5353962867487508e+03
C742_748	742	748	1.9522412722499321e-10
R742_861	742	861	1.3157419394539481e+03
C742_861	742	861	6.7294258482591321e-10
R743_746	743	746	1.3419107312737770e-06
C743_746	743	746	6.5981943587226353e-11
R743_744	743	744	3.1647869620570825e-06
C743_744	743	744	2.7977200118534551e-11
R743_862	743	862	1.1266641584923212e-05
C743_862	743	862	7.8587640782400429e-12
R743_863	743	863	8.1018546228661321e-06
C743_863	743	863	1.0928593796302558e-11
R743_867	743	867	6.7336252153768271e-06
C743_867	743	867	1.3149213883749694e-11
R743_868	743	868	6.4587489021573104e-06
C743_868	743	868	1.3708828058081930e-11
R744_747	744	747	5.5504975306715278e+03
C744_747	744	747	1.5952061536956986e-10
R744_745	744	745	6.2805291932675364e+03
C744_745	744	745	1.4097837211697572e-10
R744_749	744	749	6.9779394511999062e+03
C744_749	744	749	1.2688828670586214e-10
R744_746	744	746	1.7332568461653626e-06
C744_746	744	746	5.1084106989618436e-11
R744_862	744	862	1.0464626787333521e-05
C744_862	744	862	5.0766384654769124e-11
R744_868	744	868	1.2430081250735882e-05
C744_868	744	868	7.1231938379130219e-12
R744_865	744	865	8.3423364057186850e-06
C744_865	744	865	6.3681352910942406e-11
R744_871	744	871	8.6548361648836883e-06
C744_871	744	871	2.1483704629736680e-10
R745_747	745	747	8.1515382706468574e+02
C745_747	745	747	1.0861983987590830e-09
R745_748	745	748	2.8093449334836369e+03
C745_748	745	748	3.1516912400004414e-10
R745_749	745	749	1.5656927649287588e+03
C745_749	745	749	5.6551246932554349e-10
R745_851	745	851	2.6729708888260416e+03
C745_851	745	851	3.3124894303988193e-10
R745_855	745	855	1.3753546990282991e+03
C745_855	745	855	6.4377486209597918e-10
R745_870	745	870	8.3564935651405597e+02
C745_870	745	870	1.0595577855687694e-09
R745_871	745	871	3.8844578820910242e+03
C745_871	745	871	2.2793882919471238e-10
R746_862	746	862	2.9779599280847999e-06
C746_862	746	862	2.9732394091327987e-11
R746_863	746	863	2.9779599280847935e-06
C746_863	746	863	2.9732394091328051e-11
R746_867	746	867	8.8457157089043837e-07
C746_867	746	867	1.0009577640040012e-10
R746_868	746	868	2.6238807588917731e-06
C746_868	746	868	3.3744627254859219e-11
R746_865	746	865	2.6238807588917786e-06
C746_865	746	865	3.3744627254859148e-11
R746_871	746	871	8.7595176537129869e-07
C746_871	746	871	1.0108076913626499e-10
R747_855	747	855	3.3757467421253514e+03
C747_855	747	855	2.6228827259196148e-10
R747_866	747	866	4.7213970511644184e+03
C747_866	747	866	1.8753321783890912e-10
R747_870	747	870	2.4134975552825581e+03
C747_870	747	870	3.6686127141999127e-10
R747_865	747	865	2.9840478655399584e+03
C747_865	747	865	2.9671735226666179e-10
R747_871	747	871	3.9024139088342313e+03
C747_871	747	871	2.2689002304332736e-10
R748_749	748	749	3.5811717343516175e+03
C748_749	748	749	2.4724275945965151e-10
R748_851	748	851	2.3543731935520168e+03
C748_851	748	851	3.7607410079460633e-10
R748_860	748	860	3.9553050630743001e+03
C748_860	748	860	2.2385600290759864e-10
R748_861	748	861	2.6260019642830580e+03
C748_861	748	861	3.3717369360069547e-10
R748_834	748	834	1.0699783924957801e+04
C748_834	748	834	8.2751089920116500e-11
R748_833	748	833	5.1368792457625641e+03
C748_833	748	833	1.7236511495386741e-10
R748_870	748	870	4.9573006488833507e+03
C748_870	748	870	1.7860905448602233e-10
R748_872	748	872	3.9900068710840974e+03
C748_872	748	872	2.2190908695338394e-10
R748_873	748	873	6.4044997434662509e+03
C748_873	748	873	1.3824948351403832e-10
R749_870	749	870	4.1438313470484318e+03
C749_870	749	870	2.1367152944838503e-10
R749_862	749	862	2.8115314280395633e+03
C749_862	749	862	3.1492402072040458e-10
R749_871	749	871	3.0890364890208716e+03
C749_871	749	871	2.8663267165893861e-10
R749_873	749	873	1.3869695943426361e+03
C749_873	749	873	6.3838370019903016e-10
R749_833	749	833	5.9386801598854554e+03
C749_833	749	833	1.4909352884178189e-10
R750_751	750	751	9.5977521854996883e+02
C750_751	750	751	9.2252723823990113e-10
R750_752	750	752	3.5579396322453572e+03
C750_752	750	752	2.4885716825420866e-10
R750_840	750	840	1.3989408410362839e+03
C750_840	750	840	6.3292081818421619e-10
R750_847	750	847	1.3550755427557992e+03
C750_847	750	847	6.5340916706336225e-10
R750_850	750	850	4.9038804967906644e+03
C750_850	750	850	1.8055472238352067e-10
R750_874	750	874	3.1839360362009938e+03
C750_874	750	874	2.7808937479675736e-10
R751_752	751	752	1.5617408686993938e+03
C751_752	751	752	5.6694346638784584e-10
R751_774	751	774	3.5322515059757757e+03
C751_774	751	774	2.5066696983554829e-10
R751_838	751	838	1.1051236943419665e+03
C751_838	751	838	8.0119427918628820e-10
R751_839	751	839	1.9536575364198641e+03
C751_839	751	839	4.5321084437478047e-10
R751_840	751	840	2.3434517590762757e+03
C751_840	751	840	3.7782675844328364e-10
R751_847	751	847	2.7052955031799183e+03
C751_847	751	847	3.2729096716393511e-10
R751_874	751	874	9.9387720691649736e+02
C751_874	751	874	8.9087341528538575e-10
R752_791	752	791	3.2000185691520542e+03
C752_791	752	791	2.7669176367767756e-10
R752_828	752	828	1.8522932418908720e+03
C752_828	752	828	4.7801220761143637e-10
R752_838	752	838	2.2392045076916138e+03
C752_838	752	838	3.9541666634673513e-10
R752_847	752	847	1.5773911147405527e+03
C752_847	752	847	5.6131847924452947e-10
R752_875	752	875	3.4584280252315912e+03
C752_875	752	875	2.5601769799465715e-10
R753_754	753	754	1.2904124077217868e+03
C753_754	753	754	6.8615178868529326e-10
R753_757	753	757	3.4797531093278280e+03
C753_757	753	757	2.5444873641366856e-10
R753_759	753	759	4.0732898985690813e+03
C753_759	753	759	2.1737190422195128e-10
R753_766	753	766	3.2828611576786730e+03
C753_766	753	766	2.6970948181253093e-10
R753_767	753	767	1.9079269839807657e+03
C753_767	753	767	4.6407372458909904e-10
R753_771	753	771	3.2586319188552479e+03
C753_771	753	771	2.7171488027744058e-10
R753_824	753	824	9.4891700498878993e+02
C753_824	753	824	9.3308348047831661e-10
R753_826	753	826	1.9077916700062995e+03
C753_826	753	826	4.6410663995460080e-10
R753_876	753	876	2.0817621959348539e+03
C753_876	753	876	4.2532176990676223e-10
R753_877	753	877	3.6708949768569291e+03
C753_877	753	877	2.4119970396377501e-10
R754_757	754	757	2.5574214080197712e+03
C754_757	754	757	3.4621544142996204e-10
R754_770	754	770	2.4279605299833588e+03
C754_770	754	770	3.6467593717681596e-10
R754_771	754	771	3.5193419691774493e+03
C754_771	754	771	2.5158645833639824e-10
R754_810	754	810	3.7551028341385741e+03
C754_810	754	810	2.3579082139920051e-10
R754_811	754	811	1.3613498615654976e+03
C754_811	754	811	6.5039767270538685e-10
R754_824	754	824	1.4026380991140495e+03
C754_824	754	824	6.3125248220425389e-10
R754_877	754	877	1.6274131774226216e+03
C754_877	754	877	5.4406514214310454e-10
R755_760	755	760	1.2916640379069311e+03
C755_760	755	760	6.8548690349448087e-10
R755_761	755	761	2.2164597154244234e+03
C755_761	755	761	3.9947433988460899e-10
R755_762	755	762	1.5828141102478260e+03
C755_762	755	762	5.5939530483549159e-10
R755_808	755	808	9.5642700564101494e+02
C755_808	755	808	9.2575677650023692e-10
R755_816	755	816	1.1675433322547874e+03
C755_816	755	816	7.5836053124474463e-10
R755_879	755	879	1.7859630925140584e+03
C755_879	755	879	4.9576544185670531e-10
R756_758	756	758	1.0748721382984697e+03
C756_758	756	758	8.2374335528095877e-10
R756_760	756	760	4.0766793274227898e+03
C756_760	756	760	2.1719117707983849e-10
R756_782	756	782	1.0326339387112173e+03
C756_782	756	782	8.5743722776054638e-10
R756_792	756	792	2.7156396942985580e+03
C756_792	756	792	3.2604427736084524e-10
R756_880	756	880	4.2484648766793789e+03
C756_880	756	880	2.0840910950217099e-10
R757_758	757	758	1.4222622102698342e+03
C757_758	757	758	6.2254257710469334e-10
R757_759	757	759	1.4725733071897773e+03
C757_759	757	759	6.0127314367100084e-10
R757_761	757	761	1.0756348219219378e+03
C757_761	757	761	8.2315927641496301e-10
R757_810	757	810	3.3732257685324716e+03
C757_810	757	810	2.6248429321266656e-10
R757_826	757	826	4.1375907356646476e+03
C757_826	757	826	2.1399380418850671e-10
R757_877	757	877	2.1548522499477372e+03
C757_877	757	877	4.1089535568922393e-10
R757_881	757	881	2.7132638653307827e+03
C757_881	757	881	3.2632977316124603e-10
R758_759	758	759	9.9814922884905172e+02
C758_759	758	759	8.8706052773387494e-10
R758_760	758	760	3.0646564290425863e+03
C758_760	758	760	2.8891290172341088e-10
R758_761	758	761	1.5344228097397481e+03
C758_761	758	761	5.7703703052366314e-10
R758_792	758	792	5.2701596348973007e+03
C758_792	758	792	1.6800606490874432e-10
R758_880	758	880	2.8904978440549985e+03
C758_880	758	880	3.0632051275218068e-10
R758_881	758	881	2.7910930014794353e+03
C758_881	758	881	3.1723012498353827e-10
R759_766	759	766	2.4004508543745224e+03
C759_766	759	766	3.6885520071632991e-10
R759_792	759	792	5.9787407834972373e+03
C759_792	759	792	1.4809452588143125e-10
R759_825	759	825	1.5293904363158481e+03
C759_825	759	825	5.7893573849780776e-10
R759_826	759	826	1.1727740885872670e+03
C759_826	759	826	7.5497812436032121e-10
R759_880	759	880	4.2067593947451633e+03
C759_880	759	880	2.1047526103014428e-10
R759_881	759	881	3.2610987287036041e+03
C759_881	759	881	2.7150934557936051e-10
R760_761	760	761	2.1684551885107608e+03
C760_761	760	761	4.0831776759384315e-10
R760_782	760	782	5.6733497744332444e+03
C760_782	760	782	1.5606631300790042e-10
R760_808	760	808	1.3947948009732936e+03
C760_808	760	808	6.3480218099619472e-10
R760_878	760	878	2.4103332258426667e+03
C760_878	760	878	3.6734289359117655e-10
R760_879	760	879	1.7435376024459908e+03
C760_879	760	879	5.0782889939273761e-10
R760_880	760	880	1.2635453740734308e+03
C760_880	760	880	7.0074157989718849e-10
R760_881	760	881	4.1316385089196128e+03
C760_881	760	881	2.1430209341608866e-10
R761_762	761	762	1.7013409681438231e+03
C761_762	761	762	5.2042406447544679e-10
R761_810	761	810	4.6048586100244574e+03
C761_810	761	810	1.9227925473596625e-10
R761_877	761	877	5.2809844420580930e+03
C761_877	761	877	1.6766169099997133e-10
R761_879	761	879	3.6502364854178236e+03
C761_879	761	879	2.4256477223794194e-10
R761_881	761	881	1.7969875019216697e+03
C761_881	761	881	4.9272395091960703e-10
R761_882	761	882	2.1468347441833043e+03
C761_882	761	882	4.1242987337473413e-10
R762_803	762	803	1.9536975174960987e+03
C762_803	762	803	4.5320156972650096e-10
R762_810	762	810	4.7649602689952244e+03
C762_810	762	810	1.8581871237442784e-10
R762_816	762	816	3.9843133941911715e+03
C762_816	762	816	2.2222618908213243e-10
R762_817	762	817	4.5126720239125016e+03
C762_817	762	817	1.9620720872427576e-10
R762_818	762	818	2.7732645829030444e+03
C762_818	762	818	3.1926949457276328e-10
R762_879	762	879	3.1106734119971784e+03
C762_879	762	879	2.8463893968590080e-10
R762_882	762	882	5.3728088765101420e+03
C762_882	762	882	1.6479625500379154e-10
R763_764	763	764	2.1385452419171415e+03
C763_764	763	764	4.1402854816681300e-10
R763_765	763	765	1.1107217770168861e+03
C763_765	763	765	7.9715622761805197e-10
R763_774	763	774	2.8002777159174279e+03
C763_774	763	774	3.1618963243076719e-10
R763_776	763	776	1.4013838923753447e+03
C763_776	763	776	6.3181743883127968e-10
R763_777	763	777	1.0897061420842081e+03
C763_777	763	777	8.1252986241457607e-10
R763_884	763	884	4.0277577438913613e+03
C763_884	763	884	2.1982920473378948e-10
R764_765	764	765	2.6478126364380769e+03
C764_765	764	765	3.3439631245626734e-10
R764_777	764	777	2.0084282408939043e+03
C764_777	764	777	4.4085158915407458e-10
R764_780	764	780	1.7652084242920519e+03
C764_780	764	780	5.0159446868440075e-10
R764_793	764	793	3.6597556155225625e+03
C764_793	764	793	2.4193385425643362e-10
R764_797	764	797	5.6755001601184604e+03
C764_797	764	797	1.5600718116824428e-10
R764_819	764	819	6.2752927980047543e+03
C764_819	764	819	1.4109601100709138e-10
R764_884	764	884	1.6450664855154535e+03
C764_884	764	884	5.3822674615036555e-10
R765_774	765	774	1.5224333323747142e+03
C765_774	765	774	5.8158131648294287e-10
R765_791	765	791	5.1890347464732367e+03
C765_791	765	791	1.7063265616052793e-10
R765_793	765	793	2.1381969550340868e+03
C765_793	765	793	4.1409598849881657e-10
R765_884	765	884	3.4630493820519309e+03
C765_884	765	884	2.5567604848169114e-10
R765_885	765	885	8.0854045257571224e+03
C765_885	765	885	1.0950828482104784e-10
R766_767	766	767	2.4225369400967252e+03
C766_767	766	767	3.6549237580032421e-10
R766_825	766	825	2.6802427178929383e+03
C766_825	766	825	3.3035022380214442e-10
R766_826	766	826	3.8571980155208744e+03
C766_826	766	826	2.2954973484306156e-10
R766_828	766	828	4.0077541212516062e+03
C766_828	766	828	2.2092642285737012e-10
R766_831	766	831	3.0524538787412589e+03
C766_831	766	831	2.9006786568225564e-10
R766_876	766	876	3.2675391656092906e+03
C766_876	766	876	2.7097419091988078e-10
R766_883	766	883	3.0858524034043544e+03
C766_883	766	883	2.8692842882673001e-10
R766_889	766	889	6.9716302653296943e+03
C766_889	766	889	1.2700311806597616e-10
R767_769	767	769	1.2279287769552293e+03
C767_769	767	769	7.2106688784954069e-10
R767_771	767	771	3.6252707273112769e+03
C767_771	767	771	2.4423521670523098e-10
R767_824	767	824	3.8518633879110766e+03
C767_824	767	824	2.2986764911726943e-10
R767_831	767	831	1.7424917217445120e+03
C767_831	767	831	5.0813370913094199e-10
R767_832	767	832	5.2861479897459367e+03
C767_832	767	832	1.6749791784443686e-10
R767_876	767	876	1.1958290616867205e+03
C767_876	767	876	7.4042253200563145e-10
R767_889	767	889	1.2280036171196141e+03
C767_889	767	889	7.2102294273108437e-10
R767_890	767	890	3.3051430869181436e+03
C767_890	767	890	2.6789121027906919e-10
R768_829	768	829	1.2402813926318693e+03
C768_829	768	829	7.1388540290937277e-10
R768_847	768	847	3.1340845193513146e+03
C768_847	768	847	2.8251273258044172e-10
R768_848	768	848	2.5675011535422150e+03
C768_848	768	848	3.4485623520692297e-10
R768_850	768	850	1.3914658147756015e+03
C768_850	768	850	6.3632090152555391e-10
R768_852	768	852	7.9452647339777070e+02
C768_852	768	852	1.1143980865905335e-09
R768_853	768	853	2.1492296249460464e+03
C768_853	768	853	4.1197030388143260e-10
R768_854	768	854	3.6867380384217408e+03
C768_854	768	854	2.4016319371555890e-10
R768_891	768	891	2.2958324602722223e+03
C768_891	768	891	3.8566349985094905e-10
R769_771	769	771	3.3786674347753374e+03
C769_771	769	771	2.6206153721633619e-10
R769_832	769	832	4.2656528244859592e+03
C769_832	769	832	2.0756934943637830e-10
R769_889	769	889	3.9224185135830157e+03
C769_889	769	889	2.2573286828875271e-10
R769_890	769	890	3.5851490643534530e+03
C769_890	769	890	2.4696847071257736e-10
R769_894	769	894	3.4194119680502049e+03
C769_894	769	894	2.5893890235310778e-10
R769_895	769	895	6.7283006150115471e+03
C769_895	769	895	1.3159619826208978e-10
R770_771	770	771	3.5133811413275725e+03
C770_771	770	771	2.5201330174085072e-10
R770_811	770	811	8.9713682725616275e+02
C770_811	770	811	9.8693839646288783e-10
R770_824	770	824	4.6124087797456841e+03
C770_824	770	824	1.9196450791354613e-10
R770_827	770	827	4.3058580284129921e+03
C770_827	770	827	2.0563120656960875e-10
R770_892	770	892	4.5186334713963179e+03
C770_892	770	892	1.9594835193091988e-10
R770_893	770	893	4.4263657448012027e+03
C770_893	770	893	2.0003290119889674e-10
R770_896	770	896	4.7389134858278967e+03
C770_896	770	896	1.8684003925117358e-10
R771_824	771	824	1.0586375106321359e+03
C771_824	771	824	8.3637578756424098e-10
R771_890	771	890	2.5322556883389620e+03
C771_890	771	890	3.4965615272476388e-10
R771_892	771	892	2.7519276062399308e+03
C771_892	771	892	3.2174493968966841e-10
R771_895	771	895	3.8721194067977449e+03
C771_895	771	895	2.2866515431977448e-10
R771_896	771	896	5.7761724753676463e+03
C771_896	771	896	1.5328814807311381e-10
R772_773	772	773	3.3270560484765392e+03
C772_773	772	773	2.6612680063067580e-10
R772_775	772	775	1.5160206894846926e+03
C772_775	772	775	5.8404135764199949e-10
R772_776	772	776	3.3041715137691140e+03
C772_776	772	776	2.6796998219078239e-10
R772_778	772	778	1.1880762883703135e+03
C772_778	772	778	7.4525414770673581e-10
R772_794	772	794	3.5014668531438433e+03
C772_794	772	794	2.5287081638514262e-10
R772_795	772	795	4.1529512744646418e+03
C772_795	772	795	2.1320230438151228e-10
R772_836	772	836	8.3142289716294010e+02
C772_836	772	836	1.0649439469628627e-09
R772_900	772	900	1.0685723468328731e+03
C772_900	772	900	8.2859975211250827e-10
R772_901	772	901	1.8415412967068623e+03
C772_901	772	901	4.8080310948407777e-10
R773_778	773	778	6.0626132621463148e+03
C773_778	773	778	1.4604573035004046e-10
R773_779	773	779	5.2561024983164398e+03
C773_779	773	779	1.6845538723485791e-10
R773_794	773	794	8.7868871299151306e+03
C773_794	773	794	1.0076592183431768e-10
R773_901	773	901	5.6464550982188157e+03
C773_901	773	901	1.5680967373304837e-10
R774_776	774	776	1.4706303301162961e+03
C774_776	774	776	6.0206753768636194e-10
R774_791	774	791	4.2014884878314015e+03
C774_791	774	791	2.1073930923871434e-10
R774_838	774	838	1.9845377842520620e+03
C774_838	774	838	4.4615869182541116e-10
R774_839	774	839	1.3840264363695126e+03
C774_839	774	839	6.3974123501757141e-10
R774_884	774	884	2.7035122284088256e+03
C774_884	774	884	3.2750685289894939e-10
R774_885	774	885	3.3903137782938097e+03
C774_885	774	885	2.6116130824492333e-10
R774_897	774	897	4.1414557648660875e+03
C774_897	774	897	2.1379409366421902e-10
R774_902	774	902	6.2430062639018242e+03
C774_902	774	902	1.4182570772348086e-10
R775_776	775	776	2.0043664899292573e+03
C775_776	775	776	4.4174495340482884e-10
R775_836	775	836	1.3398701459229640e+03
C775_836	775	836	6.6082432271082732e-10
R775_837	775	837	9.6346002205144362e+02
C775_837	775	837	9.1899898432186664e-10
R775_839	775	839	1.5849667214806923e+03
C775_839	775	839	5.5863556609745892e-10
R775_898	775	898	1.8317443092896763e+03
C775_898	775	898	4.8337465944870473e-10
R775_900	775	900	2.8080851777327330e+03
C775_900	775	900	3.1531051433948784e-10
R775_902	775	902	2.7086662262586210e+03
C775_902	775	902	3.2688367917629910e-10
R776_777	776	777	1.4641847700584606e+03
C776_777	776	777	6.0471792891593042e-10
R776_778	776	778	2.1574437195171886e+03
C776_778	776	778	4.1040179805855923e-10
R776_839	776	839	4.7627903568892552e+03
C776_839	776	839	1.8590337078751835e-10
R776_884	776	884	3.2332193740424791e+03
C776_884	776	884	2.7385051221964104e-10
R776_900	776	900	3.0682510008897643e+03
C776_900	776	900	2.8857442935510715e-10
R776_902	776	902	3.4234705355332862e+03
C776_902	776	902	2.5863192701965970e-10
R776_903	776	903	3.2188159954928888e+03
C776_903	776	903	2.7507592324003541e-10
R777_778	777	778	1.4178900341031515e+03
C777_778	777	778	6.2446223642445450e-10
R777_780	777	780	2.9325287468840002e+03
C777_780	777	780	3.0193012861026995e-10
R777_781	777	781	3.9838516745586126e+03
C777_781	777	781	2.2225194460787732e-10
R777_884	777	884	1.9235076754538131e+03
C777_884	777	884	4.6031466003435789e-10
R777_903	777	903	1.5220018388207079e+03
C777_903	777	903	5.8174619709135742e-10
R778_779	778	779	3.0279413516392783e+03
C778_779	778	779	2.9241609360123467e-10
R778_781	778	781	7.9983830161458363e+03
C778_781	778	781	1.1069972267052734e-10
R778_900	778	900	2.2703519048786807e+03
C778_900	778	900	3.8999186857216029e-10
R778_901	778	901	4.7367249040102106e+03
C778_901	778	901	1.8692636782650940e-10
R778_903	778	903	2.7315397300947679e+03
C778_903	778	903	3.2414640429530982e-10
R778_904	778	904	4.3445088183031630e+03
C778_904	778	904	2.0380181482651901e-10
R779_781	779	781	4.4347531724456949e+03
C779_781	779	781	1.9965457992145841e-10
R779_901	779	901	6.5453623261615239e+03
C779_901	779	901	1.3527421975725017e-10
R779_904	779	904	6.2970228083842339e+03
C779_904	779	904	1.4060911142343337e-10
R780_781	780	781	1.3116802414361443e+03
C780_781	780	781	6.7502639265997074e-10
R780_786	780	786	1.5388684903375745e+03
C780_786	780	786	5.7537001196624005e-10
R780_797	780	797	8.2121164297395308e+02
C780_797	780	797	1.0781858602168935e-09
R780_884	780	884	3.3368549724852987e+03
C780_884	780	884	2.6534529939146191e-10
R780_903	780	903	3.2798437771715435e+03
C780_903	780	903	2.6995760830522342e-10
R780_905	780	905	3.2439434696449048e+03
C780_905	780	905	2.7294519463279108e-10
R781_786	781	786	5.2438713775042734e+03
C781_786	781	786	1.6884830270596748e-10
R781_903	781	903	3.2337730578337009e+03
C781_903	781	903	2.7380362377474336e-10
R781_904	781	904	4.2376960066787824e+03
C781_904	781	904	2.0893872054638742e-10
R781_905	781	905	3.4270123215373205e+03
C781_905	781	905	2.5836463327999092e-10
R782_783	782	783	8.3522607787728759e+02
C782_783	782	783	1.0600947517710132e-09
R782_784	782	784	1.6390693361509432e+03
C782_784	782	784	5.4019605038749931e-10
R782_792	782	792	2.4924148788309167e+03
C782_792	782	792	3.5524534427242365e-10
R782_793	782	793	4.6037218974204006e+03
C782_793	782	793	1.9232673072544325e-10
R782_808	782	808	2.3089027628710214e+03
C782_808	782	808	3.8348032491373510e-10
R782_820	782	820	9.1876657232961827e+02
C782_820	782	820	9.6370373973765512e-10
R782_878	782	878	3.5353341908811417e+03
C782_878	782	878	2.5044839720776706e-10
R782_880	782	880	3.7917779720156091e+03
C782_880	782	880	2.3351018657596523e-10
R782_906	782	906	2.7831668007567746e+03
C782_906	782	906	3.1813356693506287e-10
R783_784	783	784	1.1771432289746624e+03
C783_784	783	784	7.5217591190770758e-10
R783_798	783	798	9.0316572511847573e+02
C783_798	783	798	9.8035029128663238e-10
R783_799	783	799	2.8923929976726099e+03
C783_799	783	799	3.0611980543877003e-10
R783_820	783	820	1.8657931986402691e+03
C783_820	783	820	4.7455354770575065e-10
R783_906	783	906	1.9874779914943886e+03
C783_906	783	906	4.4549865985396497e-10
R784_785	784	785	1.1411453279607701e+03
C784_785	784	785	7.7590361192841736e-10
R784_799	784	799	9.0447626496834130e+02
C784_799	784	799	9.7892981385309397e-10
R784_807	784	807	3.4785584265287180e+03
C784_807	784	807	2.5453612477728797e-10
R784_808	784	808	2.7152181501818277e+03
C784_808	784	808	3.2609489651529732e-10
R784_906	784	906	1.0502741110576189e+03
C784_906	784	906	8.4303590117858788e-10
R784_907	784	907	3.3894227177813450e+03
C784_907	784	907	2.6122996611044705e-10
R785_788	785	788	1.3309932307005040e+03
C785_788	785	788	6.6523161897224873e-10
R785_789	785	789	2.2073911335711891e+03
C785_789	785	789	4.0111549250790938e-10
R785_799	785	799	1.1995830111484577e+03
C785_799	785	799	7.3810546954338506e-10
R785_807	785	807	1.2831058121439999e+03
C785_807	785	807	6.9005905305698337e-10
R785_907	785	907	1.6528944566775378e+03
C785_907	785	907	5.3567774888650132e-10
R786_787	786	787	3.4618415285685351e+03
C786_787	786	787	2.5576525510863548e-10
R786_797	786	797	2.3040437250827631e+03
C786_797	786	797	3.8428905322454124e-10
R786_798	786	798	3.4194423185875225e+03
C786_798	786	798	2.5893660404417704e-10
R786_905	786	905	3.9943650202004396e+03
C786_905	786	905	2.2166696764622910e-10
R786_910	786	910	3.2622144504047460e+03
C786_910	786	910	2.7141648569122897e-10
R787_798	787	798	1.6098341089304322e+03
C787_798	787	798	5.5000622535465408e-10
R787_799	787	799	1.8469185492217111e+03
C787_799	787	799	4.7940326446616409e-10
R787_789	787	789	5.7026538759161294e+03
C787_789	787	789	1.5526433849323495e-10
R787_910	787	910	5.5128329336251918e+03
C787_910	787	910	1.6061048690582327e-10
R787_911	787	911	3.6931751814025065e+03
C787_911	787	911	2.3974459325911443e-10
R788_789	788	789	2.8406212734935693e+03
C788_789	788	789	3.1169898992239047e-10
R788_790	788	790	1.3085164914616123e+03
C788_790	788	790	6.7665848117129009e-10
R788_801	788	801	2.8847713874296223e+03
C788_801	788	801	3.0692857865902590e-10
R788_802	788	802	1.8188705402092235e+03
C788_802	788	802	4.8679593303993536e-10
R788_807	788	807	1.3085164914615953e+03
C788_807	788	807	6.7665848117129899e-10
R788_907	788	907	1.7831503606826843e+03
C788_907	788	907	4.9654745961020071e-10
R788_909	788	909	1.2223072714210737e+03
C788_909	788	909	7.2438314194973115e-10
R788_912	788	912	2.1898340852948913e+03
C788_912	788	912	4.0433144576830641e-10
R789_790	789	790	5.1632940155285642e+03
C789_790	789	790	1.7148331647144447e-10
R789_799	789	799	1.6895123765378087e+03
C789_799	789	799	5.2406765052199399e-10
R789_907	789	907	2.9288964146309977e+03
C789_907	789	907	3.0230457358511634e-10
R789_911	789	911	5.1769748000976979e+03
C789_911	789	911	1.7103015098379286e-10
R789_912	789	912	5.1004056530765438e+03
C789_912	789	912	1.7359771789248158e-10
R790_801	790	801	4.5508972751413603e+03
C790_801	790	801	1.9455916672443397e-10
R790_912	790	912	7.1643819013963193e+03
C790_912	790	912	1.2358620658223626e-10
R791_792	791	792	2.1148318578821063e+03
C791_792	791	792	4.1867100611331851e-10
R791_793	791	793	2.6532310025186475e+03
C791_793	791	793	3.3371341615543224e-10
R791_825	791	825	2.7663815449918529e+03
C791_825	791	825	3.2006386946259353e-10
R791_828	791	828	2.9636261167799544e+03
C791_828	791	828	2.9876197158838219e-10
R791_838	791	838	2.1148318578821063e+03
C791_838	791	838	4.1867100611331851e-10
R791_875	791	875	1.2127311575255692e+03
C791_875	791	875	7.3010310340058380e-10
R791_883	791	883	5.1698870114296615e+03
C791_883	791	883	1.7126462913841313e-10
R791_885	791	885	1.6634279115006477e+03
C791_885	791	885	5.3228563472956697e-10
R791_886	791	886	5.5170898995743300e+03
C791_886	791	886	1.6048656045432837e-10
R791_887	791	887	2.3383955679527544e+03
C791_887	791	887	3.7864371359340920e-10
R791_888	791	888	5.0741651333240297e+03
C791_888	791	888	1.7449546052120147e-10
R791_913	791	913	4.0295932053999527e+03
C791_913	791	913	2.1972907352371788e-10
R792_793	792	793	1.5727640826348795e+03
C792_793	792	793	5.6296986399679358e-10
R792_820	792	820	5.9182351017811843e+03
C792_820	792	820	1.4960858540978198e-10
R792_821	792	821	3.0437118331180445e+03
C792_821	792	821	2.9090098874207740e-10
R792_825	792	825	1.4571337925302369e+03
C792_825	792	825	6.0764412042254292e-10
R792_880	792	880	2.3634050732902751e+03
C792_880	792	880	3.7463691336980229e-10
R792_888	792	888	4.2685796602839937e+03
C792_888	792	888	2.0742702541976036e-10
R792_913	792	913	5.9852681199754506e+03
C792_913	792	913	1.4793301886426296e-10
R793_819	793	819	2.5045924993119788e+03
C793_819	793	819	3.5351810002754072e-10
R793_820	793	820	7.3928817595493447e+03
C793_820	793	820	1.1976639293010597e-10
R793_821	793	821	9.1759501127729145e+03
C793_821	793	821	9.6493417119552345e-11
R793_884	793	884	6.3577969100317432e+03
C793_884	793	884	1.3926503067484415e-10
R793_885	793	885	5.7275987489795880e+03
C793_885	793	885	1.5458813029766508e-10
R793_913	793	913	6.8719792729697465e+03
C793_913	793	913	1.2884479806024848e-10
R794_795	794	795	5.0113306885627617e+03
C794_795	794	795	1.7668336749773268e-10
R794_836	794	836	1.0916589088246774e+04
C794_836	794	836	8.1107640357488280e-11
R794_901	794	901	7.1676207574430591e+03
C794_901	794	901	1.2353036128209719e-10
R794_796	794	796	2.1494942346179570e+04
C794_796	794	796	4.1191958900851445e-11
R794_916	794	916	7.3443944372129481e+03
C794_916	794	916	1.2055708462684351e-10
R795_836	795	836	2.9757709103318630e+03
C795_836	795	836	2.9754265646788538e-10
R795_843	795	843	5.1757884470572762e+03
C795_843	795	843	1.7106935315399336e-10
R795_844	795	844	4.9081365142654622e+03
C795_844	795	844	1.8039815704525271e-10
R795_796	795	796	5.6856351517372796e+03
C795_796	795	796	1.5572908884761188e-10
R795_916	795	916	6.1505577038161427e+03
C795_916	795	916	1.4395747903489106e-10
R795_845	795	845	8.5701068347095224e+03
C795_845	795	845	1.0331478927590414e-10
R795_920	795	920	3.0763353147281355e+03
C795_920	795	920	2.8781608346171034e-10
R796_916	796	916	3.7950718771261490e+03
C796_916	796	916	2.3330751310314859e-10
R796_842	796	842	1.1878507923366078e+04
C796_842	796	842	7.4539562326536230e-11
R796_917	796	917	3.9097552474954432e+03
C796_917	796	917	2.2646399215582402e-10
R796_845	796	845	3.0534594469285566e+03
C796_845	796	845	2.8997234025512723e-10
R796_920	796	920	4.8927493536698157e+03
C796_920	796	920	1.8096548948208228e-10
R797_798	797	798	2.5130929902422226e+03
C797_798	797	798	3.5232233154040977e-10
R797_819	797	819	2.1623281563264977e+03
C797_819	797	819	4.0947475021747229e-10
R797_884	797	884	4.7936931605835216e+03
C797_884	797	884	1.8470493459623536e-10
R797_903	797	903	9.9300559059172901e+03
C797_903	797	903	8.9165538451035490e-11
R797_905	797	905	3.4835057962128299e+03
C797_905	797	905	2.5417462564942548e-10
R797_910	797	910	5.4743828307533922e+03
C797_910	797	910	1.6173855739974756e-10
R797_915	797	915	4.2699402500635506e+03
C797_915	797	915	2.0736093009423779e-10
R797_924	797	924	2.5779758990336550e+03
C797_924	797	924	3.4345502688054455e-10
R798_799	798	799	2.5217131937028116e+03
C798_799	798	799	3.5111795580522637e-10
R798_819	798	819	5.4567445852748833e+03
C798_819	798	819	1.6226135708996121e-10
R798_820	798	820	4.0580590105191873e+03
C798_820	798	820	2.1818775414670964e-10
R798_906	798	906	3.0655481378883337e+03
C798_906	798	906	2.8882886253089806e-10
R798_910	798	910	2.6883551804692756e+03
C798_910	798	910	3.2935334889247871e-10
R798_911	798	911	6.5588607036889125e+03
C798_911	798	911	1.3499582041771555e-10
R798_924	798	924	2.6932899235360305e+03
C798_924	798	924	3.2874989579195779e-10
R798_925	798	925	3.7539853236341810e+03
C798_925	798	925	2.3586101312799977e-10
R799_906	799	906	3.3079800252450964e+03
C799_906	799	906	2.6766146559013680e-10
R799_907	799	907	2.3932120759462123e+03
C799_907	799	907	3.6997088164446484e-10
R799_911	799	911	5.0463725096153121e+03
C799_911	799	911	1.7545648483399337e-10
R799_925	799	925	8.8007878393877199e+03
C799_925	799	925	1.0060676360556370e-10
R800_801	800	801	5.6118333233526864e+03
C800_801	800	801	1.5777709897681403e-10
R800_823	800	823	5.6531621924171386e+03
C800_823	800	823	1.5662362967184195e-10
R800_928	800	928	1.6058087482610872e+04
C800_928	800	928	5.5138495331950973e-11
R801_802	801	802	2.4170665915343129e+03
C801_802	801	802	3.6631956471581994e-10
R801_823	801	823	5.4060713951845082e+03
C801_823	801	823	1.6378229530758552e-10
R801_909	801	909	3.9311633815125824e+03
C801_909	801	909	2.2523072581107528e-10
R801_912	801	912	5.3970111969974287e+03
C801_912	801	912	1.6405724379311899e-10
R801_927	801	927	5.6858117169665384e+03
C801_927	801	927	1.5572425289038301e-10
R801_928	801	928	6.0077154719971522e+03
C801_928	801	928	1.4738027888089367e-10
R801_929	801	929	6.5770026822689479e+03
C801_929	801	929	1.3462344847251092e-10
R802_807	802	807	5.2118599358571419e+03
C802_807	802	807	1.6988537539322498e-10
R802_822	802	822	1.5692358069086174e+03
C802_822	802	822	5.6423564756928931e-10
R802_823	802	823	3.8877635377830738e+03
C802_823	802	823	2.2774501923666218e-10
R802_909	802	909	3.2876443209162458e+03
C802_909	802	909	2.6931708398834312e-10
R802_929	802	929	8.1152091174340267e+03
C802_929	802	929	1.0910609559004972e-10
R803_804	803	804	2.0317173648050766e+03
C803_804	803	804	4.3579820551710808e-10
R803_809	803	809	2.1075426487896584e+03
C803_809	803	809	4.2011903398893852e-10
R803_813	803	813	2.4276373004806383e+03
C803_813	803	813	3.6472449221500243e-10
R803_816	803	816	2.7846667008546210e+03
C803_816	803	816	3.1796221121481531e-10
R803_817	803	817	1.2518108621443080e+03
C803_817	803	817	7.0731035212724448e-10
R803_818	803	818	3.3924338256233345e+03
C803_818	803	818	2.6099809965705406e-10
R803_930	803	930	4.5203135612157212e+03
C803_930	803	930	1.9587552272853171e-10
R804_805	804	805	1.1993179047209717e+03
C804_805	804	805	7.3826862603706224e-10
R804_806	804	806	2.9740679523241647e+03
C804_806	804	806	2.9771303006310463e-10
R804_809	804	809	3.0819877291652815e+03
C804_809	804	809	2.8728822419413226e-10
R804_816	804	816	3.4988904027415460e+03
C804_816	804	816	2.5305702087902862e-10
R804_930	804	930	3.6227263488337958e+03
C804_930	804	930	2.4440675238554193e-10
R805_806	805	806	8.3483846211589607e+03
C805_806	805	806	1.0605869540987708e-10
R805_807	805	807	1.4053510487768488e+04
C805_807	805	807	6.3003388546272952e-11
R805_816	805	816	8.3872839455906342e+03
C805_816	805	816	1.0556680654235901e-10
R805_822	805	822	1.8546260458241347e+03
C805_822	805	822	4.7741094960550340e-10
R805_930	805	930	6.2247812674214001e+03
C805_930	805	930	1.4224094689624051e-10
R806_809	806	809	4.6433071622152629e+03
C806_809	806	809	1.9068710097515453e-10
R806_822	806	822	3.2009216003475576e+03
C806_822	806	822	2.7661370450430928e-10
R806_823	806	823	4.6629510514059530e+03
C806_823	806	823	1.8988378216688174e-10
R806_930	806	930	3.9451944933171344e+03
C806_930	806	930	2.2442969115967122e-10
R806_931	806	931	4.3054089595525193e+03
C806_931	806	931	2.0565265460682875e-10
R807_808	807	808	3.6418757916416639e+03
C807_808	807	808	2.4312163081785819e-10
R807_816	807	816	4.7804265350215182e+03
C807_816	807	816	1.8521752718369395e-10
R807_822	807	822	2.7027566192173699e+03
C807_822	807	822	3.2759841393206470e-10
R807_906	807	906	7.2813146358349295e+03
C807_906	807	906	1.2160150000144463e-10
R807_907	807	907	2.5865638363691983e+03
C807_907	807	907	3.4231468377091219e-10
R807_908	807	908	2.2598613947260656e+03
C807_908	807	908	3.9180225113201153e-10
R807_909	807	909	1.7899190211703428e+03
C807_909	807	909	4.9466974272448736e-10
R807_932	807	932	6.2915347357046749e+03
C807_932	807	932	1.4073176401223982e-10
R808_816	808	816	2.7720748887033483e+03
C808_816	808	816	3.1940651578650491e-10
R808_878	808	878	1.1239695545854663e+03
C808_878	808	878	7.8776046743237038e-10
R808_879	808	879	3.3414012440886690e+03
C808_879	808	879	2.6498427366854244e-10
R808_906	808	906	2.5862157665358795e+03
C808_906	808	906	3.4236075472000500e-10
R808_908	808	908	1.9598050106965720e+03
C808_908	808	908	4.5178922232946849e-10
R808_933	808	933	4.4049766778804478e+03
C808_933	808	933	2.0100419285898216e-10
R809_813	809	813	6.8172416481529935e+03
C809_813	809	813	1.2987933058525045e-10
R809_817	809	817	6.5071502570273988e+03
C809_817	809	817	1.3606859327457393e-10
R809_930	809	930	3.8197417458430937e+03
C809_930	809	930	2.3180069245874380e-10
R809_931	809	931	1.0642036418058027e+04
C809_931	809	931	8.3200127016815118e-11
R809_934	809	934	6.6510953412682311e+03
C809_934	809	934	1.3312375424935174e-10
R810_811	810	811	1.6349829372078527e+03
C810_811	810	811	5.4154619081962829e-10
R810_812	810	812	3.4076701164434248e+03
C810_812	810	812	2.5983113137257226e-10
R810_818	810	818	3.6584281342173895e+03
C810_818	810	818	2.4202164132148754e-10
R810_877	810	877	3.0183205377476079e+03
C810_877	810	877	2.9334816187572158e-10
R810_882	810	882	4.5337629082474168e+03
C810_882	810	882	1.9529446061004319e-10
R810_937	810	937	6.3237224263051239e+03
C810_937	810	937	1.4001544059190147e-10
R811_812	811	812	1.7104502525005764e+03
C811_812	811	812	5.1765246045920990e-10
R811_824	811	824	5.5084285273758715e+03
C811_824	811	824	1.6073890716737677e-10
R811_827	811	827	7.7362767217208993e+03
C811_827	811	827	1.1445024700500149e-10
R811_877	811	877	2.2740529694941310e+03
C811_877	811	877	3.8935714936181269e-10
R811_892	811	892	6.8733927870005064e+03
C811_892	811	892	1.2881830111245393e-10
R811_893	811	893	2.9348445981961954e+03
C811_893	811	893	3.0169187910126260e-10
R811_937	811	937	7.6050081953429335e+03
C811_937	811	937	1.1642574984234767e-10
R812_814	812	814	4.4283147846386964e+03
C812_814	812	814	1.9994486046281396e-10
R812_815	812	815	8.2921966130093115e+03
C812_815	812	815	1.0677735020306929e-10
R812_818	812	818	6.0407528048872964e+03
C812_818	812	818	1.4657424501523194e-10
R812_827	812	827	3.5677168271698702e+03
C812_827	812	827	2.4817518446450480e-10
R812_893	812	893	4.2715485650892861e+03
C812_893	812	893	2.0728285496655534e-10
R812_937	812	937	3.1862272893562131e+03
C812_937	812	937	2.7788939748830714e-10
R812_938	812	938	1.6401399693604315e+03
C812_938	812	938	5.3984342692731710e-10
R812_939	812	939	1.0276690404664439e+04
C812_939	812	939	8.6157969816636839e-11
R813_814	813	814	8.7613831594186959e+03
C813_814	813	814	1.0105924664967471e-10
R813_817	813	817	1.0253964325972562e+04
C813_817	813	817	8.6348923553137145e-11
R813_818	813	818	5.6577716511553599e+03
C813_818	813	818	1.5649602640276067e-10
R813_934	813	934	8.7315341445819231e+03
C813_934	813	934	1.0140472075567828e-10
R813_939	813	939	1.2966771455921182e+04
C813_939	813	939	6.8283672979805629e-11
R814_815	814	815	5.1576468331027854e+03
C814_815	814	815	1.7167107604522459e-10
R814_818	814	818	1.0063024444400875e+04
C814_818	814	818	8.7987342830380614e-11
R814_938	814	938	9.3232599449707322e+03
C814_938	814	938	9.4968797065196443e-11
R814_939	814	939	5.2489772028738789e+03
C814_939	814	939	1.6868405928972650e-10
R814_941	814	941	1.0065249752448502e+04
C814_941	814	941	8.7967889866280817e-11
R815_827	815	827	8.3689016742393560e+03
C815_827	815	827	1.0579868376580912e-10
R815_936	815	936	1.2111160674896397e+04
C815_936	815	936	7.3107673613418919e-11
R815_938	815	938	7.8128904201622090e+03
C815_938	815	938	1.1332794063194058e-10
R815_941	815	941	1.2327672535251026e+04
C815_941	815	941	7.1823677922019907e-11
R816_817	816	817	1.6793625523996714e+03
C816_817	816	817	5.2723503953021307e-10
R816_822	816	822	3.9947470724698087e+03
C816_822	816	822	2.2164576771379356e-10
R816_879	816	879	2.7023870048329441e+03
C816_879	816	879	3.2764322064771581e-10
R816_908	816	908	5.9420524088723905e+03
C816_908	816	908	1.4900891489579169e-10
R816_930	816	930	1.3854149991727566e+03
C816_930	816	930	6.3910004022526927e-10
R816_932	816	932	2.4447856372720557e+03
C816_932	816	932	3.6216622357450097e-10
R816_933	816	933	2.3555758587316946e+03
C816_933	816	933	3.7588209202344834e-10
R816_942	816	942	3.6606046384837609e+03
C816_942	816	942	2.4187774128668116e-10
R817_818	817	818	3.4948423353688013e+03
C817_818	817	818	2.5335013621052645e-10
R817_879	817	879	5.1021804893233239e+03
C817_879	817	879	1.7353733047131557e-10
R817_930	817	930	2.9612780381647535e+03
C817_930	817	930	2.9899886815381139e-10
R817_934	817	934	3.8407815211956190e+03
C817_934	817	934	2.3053088982379110e-10
R817_935	817	935	4.0264801314998517e+03
C817_935	817	935	2.1989895709982912e-10
R817_942	817	942	3.3300848909399865e+03
C817_942	817	942	2.6588474789604298e-10
R818_879	818	879	3.5920407963971538e+03
C818_879	818	879	2.4649463407767595e-10
R818_882	818	882	2.6653668677297678e+03
C818_882	818	882	3.3219396264731000e-10
R818_934	818	934	6.3028288535488255e+03
C818_934	818	934	1.4047958500435286e-10
R818_935	818	935	2.1788837538896760e+03
C818_935	818	935	4.0636347860200337e-10
R818_937	818	937	3.4657129353776618e+03
C818_937	818	937	2.5547955015596676e-10
R818_939	818	939	2.6637457878664327e+03
C818_939	818	939	3.3239612643712133e-10
R818_940	818	940	2.1268249474643476e+03
C818_940	818	940	4.1631013532901141e-10
R818_943	818	943	3.8496530337863128e+03
C818_943	818	943	2.2999963215623865e-10
R819_820	819	820	1.5797288711318386e+03
C819_820	819	820	5.6048781400419602e-10
R819_821	819	821	3.7252658573097874e+03
C819_821	819	821	2.3767935380037767e-10
R819_884	819	884	1.9893538559445321e+03
C819_884	819	884	4.4507857616894873e-10
R819_885	819	885	4.7357429833401566e+03
C819_885	819	885	1.8696512560221491e-10
R819_913	819	913	2.7022986934674027e+03
C819_913	819	913	3.2765392805777964e-10
R819_914	819	914	1.8893353365971304e+03
C819_914	819	914	4.6864035438765585e-10
R819_915	819	915	5.2468946142427249e+03
C819_915	819	915	1.6875101308429676e-10
R819_924	819	924	1.6265683375199997e+03
C819_924	819	924	5.4434772968099377e-10
R819_945	819	945	2.4612048071716836e+03
C819_945	819	945	3.5975014314939829e-10
R820_821	820	821	1.2088820250321187e+03
C820_821	820	821	7.3242778316310512e-10
R820_878	820	878	2.4387757381935580e+03
C820_878	820	878	3.6305871336732440e-10
R820_880	820	880	5.3288769421367388e+03
C820_880	820	880	1.6615485613840629e-10
R820_906	820	906	1.8317316788891574e+03
C820_906	820	906	4.8337799247811067e-10
R820_924	820	924	4.4285622576426958e+03
C820_924	820	924	1.9993368732074791e-10
R820_945	820	945	2.0315345705352763e+03
C820_945	820	945	4.3583741795085804e-10
R821_878	821	878	2.0217560940708506e+03
C821_878	821	878	4.3794540018780888e-10
R821_880	821	880	1.4732374512174338e+03
C821_880	821	880	6.0100208623417764e-10
R821_888	821	888	1.4522916401247423e+03
C821_888	821	888	6.0967009465395554e-10
R821_913	821	913	9.2245711645599658e+02
C821_913	821	913	9.5984817711820047e-10
R821_945	821	945	1.4855018981752698e+03
C821_945	821	945	5.9604015503959477e-10
R821_947	821	947	1.1176295409796483e+03
C821_947	821	947	7.9222922196910976e-10
R822_823	822	823	2.2183346018633215e+03
C822_823	822	823	3.9913671317044779e-10
R822_909	822	909	3.9166061400158637e+03
C822_909	822	909	2.2606786336101025e-10
R822_929	822	929	3.0766128456956703e+03
C822_929	822	929	2.8779012053425684e-10
R822_930	822	930	1.1049092029933738e+03
C822_930	822	930	8.0134981164177144e-10
R822_931	822	931	2.1340692014018650e+03
C822_931	822	931	4.1489694013594807e-10
R822_932	822	932	6.8516067100432736e+02
C822_932	822	932	1.2922790509883306e-09
R822_948	822	948	5.2052116576993913e+03
C822_948	822	948	1.7010235892911585e-10
R823_928	823	928	7.1074950923559090e+03
C823_928	823	928	1.2457536307724860e-10
R823_929	823	929	6.5014652550404617e+03
C823_929	823	929	1.3618757418007454e-10
R823_931	823	931	1.0983598825917152e+04
C823_931	823	931	8.0612811495877439e-11
R823_948	823	948	6.7672634664210746e+03
C823_948	823	948	1.3083852669449285e-10
R824_876	824	876	2.7361040658966726e+03
C824_876	824	876	3.2360566717327386e-10
R824_826	824	826	6.1554295321567070e+03
C824_826	824	826	1.4384354123046416e-10
R824_877	824	877	2.5353993477347544e+03
C824_877	824	877	3.4922261161385683e-10
R824_890	824	890	2.3925323911897503e+03
C824_890	824	890	3.7007598516135531e-10
R824_892	824	892	1.8306051383784509e+03
C824_892	824	892	4.8367545962659296e-10
R824_949	824	949	4.2382179364259400e+03
C824_949	824	949	2.0891299007777489e-10
R825_826	825	826	4.7616474634925862e+03
C825_826	825	826	1.8594799142281750e-10
R825_828	825	828	2.8811701521276391e+03
C825_828	825	828	3.0731221515888272e-10
R825_875	825	875	1.0162644863990006e+04
C825_875	825	875	8.7124837436498943e-11
R825_880	825	880	7.4306885200081933e+03
C825_880	825	880	1.1915703091522180e-10
R825_883	825	883	2.0408097544891834e+03
C825_883	825	883	4.3385660018153972e-10
R825_888	825	888	7.2657213018216125e+03
C825_888	825	888	1.2186247516513109e-10
R825_950	825	950	9.1284753049961819e+03
C825_950	825	950	9.6995254094119545e-11
R826_876	826	876	1.6100083505043524e+03
C826_876	826	876	5.4994670147060608e-10
R826_877	826	877	2.5794946005626070e+03
C826_877	826	877	3.4325281452687803e-10
R826_880	826	880	5.5052546264676530e+03
C826_880	826	880	1.6083157669822673e-10
R826_881	826	881	1.2711143782033346e+03
C826_881	826	881	6.9656892950223806e-10
R826_883	826	883	2.2718288928133447e+03
C826_883	826	883	3.8973832250347500e-10
R826_949	826	949	1.1878628495526370e+03
C826_949	826	949	7.4538805724369512e-10
R826_950	826	950	1.7178265464120725e+03
C826_950	826	950	5.1542967684911154e-10
R827_893	827	893	3.0818434507938687e+03
C827_893	827	893	2.8730167376669319e-10
R827_896	827	896	1.0159472694336800e+04
C827_896	827	896	8.7152041089057664e-11
R827_936	827	936	9.5453273686160119e+03
C827_936	827	936	9.2759393942963128e-11
R827_938	827	938	2.7646167428102854e+03
C827_938	827	938	3.2026818328530955e-10
R827_952	827	952	6.8106459271008944e+03
C827_952	827	952	1.3000511128859972e-10
R828_830	828	830	3.3880516807643257e+03
C828_830	828	830	2.6133567758926698e-10
R828_831	828	831	3.5642506176828465e+03
C828_831	828	831	2.4841653314368204e-10
R828_847	828	847	5.5145820801787586e+03
C828_847	828	847	1.6055954355679813e-10
R828_875	828	875	2.0016701935834319e+03
C828_875	828	875	4.4233999414004595e-10
R828_883	828	883	4.6223514102604368e+03
C828_883	828	883	1.9155159422422902e-10
R828_960	828	960	5.3243778221829261e+03
C828_960	828	960	1.6629525763763130e-10
R829_830	829	830	2.1359401495040270e+03
C829_830	829	830	4.1453351673060578e-10
R829_831	829	831	3.2593877908891131e+03
C829_831	829	831	2.7165186792899875e-10
R829_832	829	832	6.6961398614445598e+03
C829_832	829	832	1.3222823895870486e-10
R829_847	829	847	2.9136864339891945e+03
C829_847	829	847	3.0388265922210214e-10
R829_848	829	848	1.8327327669661563e+03
C829_848	829	848	4.8311395837904535e-10
R829_853	829	853	3.8353153200774955e+03
C829_853	829	853	2.3085944904319098e-10
R829_960	829	960	8.3132730365613916e+03
C829_960	829	960	1.0650664038170876e-10
R830_831	830	831	2.5340193695461867e+03
C830_831	830	831	3.4941279152833313e-10
R830_847	830	847	1.5187344563022109e+03
C830_847	830	847	5.8299775712984272e-10
R830_960	830	960	7.8677646037303393e+03
C830_960	830	960	1.1253752829363968e-10
R831_832	831	832	3.7379198642112437e+03
C831_832	831	832	2.3687473618079730e-10
R831_848	831	848	6.7330308125084275e+03
C831_848	831	848	1.3150374717654566e-10
R831_883	831	883	7.5770859969144622e+03
C831_883	831	883	1.1685478851111889e-10
R831_889	831	889	2.3882554921589972e+03
C831_889	831	889	3.7073871895488717e-10
R831_960	831	960	2.8642911596434483e+03
C831_960	831	960	3.0912317650354319e-10
R831_961	831	961	7.4590621920996673e+03
C831_961	831	961	1.1870376716228474e-10
R832_848	832	848	3.6001261961717023e+03
C832_848	832	848	2.4594104024507124e-10
R832_853	832	853	4.9379225017376084e+03
C832_853	832	853	1.7930997932600795e-10
R832_889	832	889	5.3778212122142877e+03
C832_889	832	889	1.6464265857128294e-10
R832_894	832	894	3.4200592194891428e+03
C832_894	832	894	2.5888989776973980e-10
R832_961	832	961	3.3557644940680834e+03
C832_961	832	961	2.6385009534046173e-10
R832_962	832	962	5.5481489418645897e+03
C832_962	832	962	1.5958814209526858e-10
R833_861	833	861	6.1834707533825276e+03
C833_861	833	861	1.4319122981468807e-10
R833_834	833	834	5.1190016391054314e+03
C833_834	833	834	1.7296708306089368e-10
R833_872	833	872	4.0911913271880380e+03
C833_872	833	872	2.1642077108834873e-10
R833_873	833	873	1.3903131928724370e+03
C833_873	833	873	6.3684843547423524e-10
R833_862	833	862	9.2885433736031719e+03
C833_862	833	862	9.5323749492976975e-11
R833_869	833	869	5.1436708209034414e+03
C833_869	833	869	1.7213752833904792e-10
R833_963	833	963	2.5332125969952081e+03
C833_963	833	963	3.4952407182494162e-10
R833_859	833	859	1.0411301154547529e+04
C833_859	833	859	8.5044008290285579e-11
R834_846	834	846	1.7141971661939103e+03
C834_846	834	846	5.1652096921028350e-10
R834_835	834	835	9.8760941173598458e+03
C834_835	834	835	8.9652728212020834e-11
R834_858	834	858	4.0761447047743263e+03
C834_858	834	858	2.1721966363532741e-10
R834_861	834	861	1.1760323165832995e+03
C834_861	834	861	7.5288643791047129e-10
R834_963	834	963	2.1324780383251891e+03
C834_963	834	963	4.1520651832615931e-10
R834_859	834	859	7.9237282762342174e+03
C834_859	834	859	1.1174269874393002e-10
R834_964	834	964	3.8026260103522759e+03
C834_964	834	964	2.3284403443555436e-10
R835_837	835	837	5.1478538059710654e+03
C835_837	835	837	1.7199765476498010e-10
R835_840	835	840	4.3042775415500482e+03
C835_840	835	840	2.0570671225376996e-10
R835_843	835	843	5.7548272242528683e+03
C835_843	835	843	1.5385670971467811e-10
R835_844	835	844	7.0980783408598154e+03
C835_844	835	844	1.2474063248965861e-10
R835_846	835	846	1.1594089751607798e+03
C835_846	835	846	7.6368115192244027e-10
R835_849	835	849	3.9818539838242373e+03
C835_849	835	849	2.2236344810656006e-10
R835_858	835	858	8.4054438997102025e+03
C835_858	835	858	1.0533872955008682e-10
R835_965	835	965	5.1147655496969801e+03
C835_965	835	965	1.7311033577139346e-10
R836_837	836	837	3.0824517820378351e+03
C836_837	836	837	2.8724497390666148e-10
R836_843	836	843	3.1113131850050900e+03
C836_843	836	843	2.8458040995913162e-10
R836_898	836	898	3.3296080140405211e+03
C836_898	836	898	2.6592282874329494e-10
R836_900	836	900	2.1003216912536777e+03
C836_900	836	900	4.2156341354142540e-10
R836_901	836	901	5.4879966425678831e+03
C836_901	836	901	1.6133734026588338e-10
R836_899	836	899	1.2881887924851969e+03
C836_899	836	899	6.8733619393771773e-10
R836_902	836	902	4.8506353263124556e+03
C836_902	836	902	1.8253666213516656e-10
R836_916	836	916	4.3270314466333120e+03
C836_916	836	916	2.0462499351348797e-10
R836_920	836	920	3.9209900943346361e+03
C836_920	836	920	2.2581510291987854e-10
R836_921	836	921	5.9081230855504791e+03
C836_921	836	921	1.4986464717796293e-10
R836_966	836	966	2.7569175641033721e+03
C836_966	836	966	3.2116258869276829e-10
R837_839	837	839	3.3293346607278022e+03
C837_839	837	839	2.6594466220059862e-10
R837_840	837	840	1.9696194355410253e+03
C837_840	837	840	4.4953799994199821e-10
R837_843	837	843	2.3290238037147260e+03
C837_843	837	843	3.8016733890301270e-10
R837_898	837	898	8.9118952233395021e+02
C837_898	837	898	9.9352467630135832e-10
R837_965	837	965	1.8154549493792726e+03
C837_965	837	965	4.8771178926953611e-10
R837_966	837	966	3.8155511768740271e+03
C837_966	837	966	2.3205527606771576e-10
R838_839	838	839	1.7550304298886915e+03
C838_839	838	839	5.0450337875688891e-10
R838_847	838	847	5.5558921039624156e+03
C838_847	838	847	1.5936572653535276e-10
R838_874	838	874	1.5031440714795406e+03
C838_874	838	874	5.8904452241127154e-10
R838_875	838	875	1.6887562968850989e+03
C838_875	838	875	5.2430228288898160e-10
R838_885	838	885	3.7472626934885752e+03
C838_885	838	885	2.3628415035821921e-10
R838_886	838	886	1.6477327257790721e+03
C838_886	838	886	5.3735582709954436e-10
R838_897	838	897	2.7828771026874715e+03
C838_897	838	897	3.1816668470373199e-10
R838_967	838	967	3.6409613797484685e+03
C838_967	838	967	2.4318268977661281e-10
R839_840	839	840	2.7775792681199414e+03
C839_840	839	840	3.1877354207763557e-10
R839_874	839	874	4.4284353004520744e+03
C839_874	839	874	1.9993941914644493e-10
R839_897	839	897	2.4023211879079895e+03
C839_897	839	897	3.6856802752135253e-10
R839_898	839	898	1.1646871487112178e+03
C839_898	839	898	7.6022027261119738e-10
R839_902	839	902	2.9922723395065627e+03
C839_902	839	902	2.9590180345884191e-10
R839_967	839	967	2.4500366950334169e+03
C839_967	839	967	3.6139000835982319e-10
R840_849	840	849	1.1962537854666655e+03
C840_849	840	849	7.4015964877769904e-10
R840_850	840	850	5.7366839495196182e+03
C840_850	840	850	1.5434330869389165e-10
R840_874	840	874	1.4246381265489015e+03
C840_874	840	874	6.2150434219030258e-10
R840_898	840	898	4.6204521839554955e+03
C840_898	840	898	1.9163033106902693e-10
R840_965	840	965	1.5352466485928760e+03
C840_965	840	965	5.7672738286810593e-10
R840_967	840	967	3.0797203690879323e+03
C840_967	840	967	2.8749973230920938e-10
R840_970	840	970	4.4687468644369910e+03
C840_970	840	970	1.9813581045422504e-10
R841_842	841	842	3.1024949001466071e+03
C841_842	841	842	2.8538927869249994e-10
R841_918	841	918	3.9381194004801168e+03
C841_918	841	918	2.2483289399301959e-10
R841_919	841	919	5.5627597733445737e+03
C841_919	841	919	1.5916897687056642e-10
R841_956	841	956	1.0856962623657403e+03
C841_956	841	956	8.1553083711522198e-10
R841_955	841	955	5.7967316731687715e+03
C841_955	841	955	1.5274448286063027e-10
R841_857	841	857	5.3139878718523250e+03
C841_857	841	857	1.6662039941603493e-10
R841_971	841	971	2.9372948646643467e+03
C841_971	841	971	3.0144021029403169e-10
R841_845	841	845	6.0118608085248043e+03
C841_845	841	845	1.4727865629298642e-10
R842_917	842	917	4.4416107887451863e+03
C842_917	842	917	1.9934632362286356e-10
R842_845	842	845	4.5792413198261493e+03
C842_845	842	845	1.9335490747485110e-10
R842_918	842	918	3.0986221283320519e+03
C842_918	842	918	2.8574596870145301e-10
R842_919	842	919	1.6263467121380427e+04
C842_919	842	919	5.4442190898889132e-11
R842_971	842	971	5.9986859801823366e+03
C842_971	842	971	1.4760212230230578e-10
R843_844	843	844	1.9950115826436131e+03
C843_844	843	844	4.4381636147030355e-10
R843_846	843	846	8.0508774705765527e+03
C843_846	843	846	1.0997792289547688e-10
R843_920	843	920	2.4743016485266548e+03
C843_920	843	920	3.5784593290281750e-10
R843_965	843	965	3.7753263906696934e+03
C843_965	843	965	2.3452774411457936e-10
R843_966	843	966	3.1866194006318369e+03
C843_966	843	966	2.7785520339342722e-10
R843_972	843	972	1.9215756266142928e+03
C843_972	843	972	4.6077748355918610e-10
R844_846	844	846	6.4988024284842004e+03
C844_846	844	846	1.3624337582863214e-10
R844_858	844	858	4.5901001783866077e+03
C844_858	844	858	1.9289748530308103e-10
R844_845	844	845	6.2098536158965844e+03
C844_845	844	845	1.4258287497042111e-10
R844_920	844	920	5.0667243973215272e+03
C844_920	844	920	1.7475171575704172e-10
R844_972	844	972	3.2343219873844123e+03
C844_972	844	972	2.7375715378790592e-10
R844_857	844	857	1.0966873343763356e+04
C844_857	844	857	8.0735753386221079e-11
R845_917	845	917	5.1479864268731444e+03
C845_917	845	917	1.7199322381232421e-10
R845_920	845	920	2.5603259171740879e+03
C845_920	845	920	3.4582268443279462e-10
R845_971	845	971	2.8282561708965168e+03
C845_971	845	971	3.1306173422732597e-10
R845_857	845	857	6.2439572860659728e+03
C845_857	845	857	1.4180410613568776e-10
R845_972	845	972	7.7102402574914704e+03
C845_972	845	972	1.1483673039108010e-10
R846_849	846	849	1.9749449759793160e+03
C846_849	846	849	4.4832579766479184e-10
R846_858	846	858	1.6457874799827603e+03
C846_858	846	858	5.3799095719775130e-10
R846_861	846	861	3.2213818083205319e+03
C846_861	846	861	2.7485682678564988e-10
R846_963	846	963	4.9370061192336461e+03
C846_963	846	963	1.7934326195192975e-10
R846_964	846	964	9.6485527999653380e+02
C846_964	846	964	9.1767003824986157e-10
R846_965	846	965	2.3391019552309604e+03
C846_965	846	965	3.7852936667421790e-10
R846_972	846	972	5.5663561381987120e+03
C846_972	846	972	1.5906613944872814e-10
R846_973	846	973	2.9483821439251028e+03
C846_973	846	973	3.0030665581269105e-10
R847_848	847	848	4.3803912985987254e+03
C847_848	847	848	2.0213234876602073e-10
R847_850	847	850	2.1058210374709283e+03
C847_850	847	850	4.2046250177241064e-10
R847_874	847	874	1.2331236182239006e+03
C847_874	847	874	7.1802921346627921e-10
R847_875	847	875	3.7410240909353347e+03
C847_875	847	875	2.3667818227779088e-10
R847_960	847	960	2.0649659383089552e+03
C847_960	847	960	4.2878130107322170e-10
R847_974	847	974	5.6289428926804931e+03
C847_974	847	974	1.5729752434535094e-10
R848_850	848	850	5.2628052230509411e+03
C848_850	848	850	1.6824084194145936e-10
R848_853	848	853	2.0350512670486296e+03
C848_853	848	853	4.3508426349577669e-10
R848_891	848	891	1.7277697235549806e+03
C848_891	848	891	5.1246342011260765e-10
R848_960	848	960	3.2565296141949989e+03
C848_960	848	960	2.7189029015443853e-10
R848_961	848	961	1.6866236682868591e+03
C848_961	848	961	5.2496522985435122e-10
R848_962	848	962	3.2133562622342347e+03
C848_962	848	962	2.7554329786152365e-10
R848_968	848	968	1.2181929325763265e+03
C848_968	848	968	7.2682968191865089e-10
R848_969	848	969	2.8307607467951416e+03
C848_969	848	969	3.1278474618613773e-10
R848_974	848	974	3.1529865140529760e+03
C848_974	848	974	2.8081908303560965e-10
R849_850	849	850	1.6399159932800158e+03
C849_850	849	850	5.3991715754235882e-10
R849_860	849	860	2.3574898757588276e+03
C849_860	849	860	3.7557691797722007e-10
R849_861	849	861	3.4027628128221490e+03
C849_861	849	861	2.6020584754353197e-10
R849_874	849	874	4.3787941203472819e+03
C849_874	849	874	2.0220607714476829e-10
R849_964	849	964	1.4157509563428157e+03
C849_964	849	964	6.2540574508049355e-10
R849_965	849	965	1.8021282483902512e+03
C849_965	849	965	4.9131840782746695e-10
R849_970	849	970	3.1078266628972774e+03
C849_970	849	970	2.8489966711160358e-10
R849_974	849	974	3.6137258348230566e+03
C849_974	849	974	2.4501548323556042e-10
R849_975	849	975	2.3566062046477882e+03
C849_975	849	975	3.7571775036225551e-10
R849_976	849	976	3.5837462181314972e+03
C849_976	849	976	2.4706514574618566e-10
R850_852	850	852	1.9837524695358495e+03
C850_852	850	852	4.4633531415699604e-10
R850_860	850	860	1.8987243601538901e+03
C850_860	850	860	4.6632296940048616e-10
R850_874	850	874	2.9833406738000376e+03
C850_874	850	874	2.9678768820330391e-10
R850_891	850	891	1.5160759090032486e+03
C850_891	850	891	5.8402008530174658e-10
R850_974	850	974	1.2277120663273056e+03
C850_974	850	974	7.2119416757768454e-10
R850_976	850	976	3.2916556792168299e+03
C850_976	850	976	2.6898888218790378e-10
R851_854	851	854	2.5845965370941717e+03
C851_854	851	854	3.4257524104534501e-10
R851_852	851	852	1.6826178330439297e+03
C851_852	851	852	5.2621502299083468e-10
R851_855	851	855	1.3780060699363264e+03
C851_855	851	855	6.4253619850957012e-10
R851_856	851	856	7.3869032575286099e+02
C851_856	851	856	1.1986332443132998e-09
R851_860	851	860	1.3450548585655704e+03
C851_860	851	860	6.5827707774257773e-10
R851_870	851	870	1.5725610953204859e+03
C851_870	851	870	5.6304253255073224e-10
R851_872	851	872	4.4222066366228109e+03
C851_872	851	872	2.0022103317546106e-10
R851_977	851	977	1.2864473121625915e+03
C851_977	851	977	6.8826664981060160e-10
R852_853	852	853	5.7385142494847523e+03
C852_853	852	853	1.5429408087284956e-10
R852_854	852	854	1.7242411997824113e+03
C852_854	852	854	5.1351213612790038e-10
R852_856	852	856	2.4866941092511602e+03
C852_856	852	856	3.5606260472729952e-10
R852_860	852	860	1.3170909960566853e+03
C852_860	852	860	6.7225331002254707e-10
R852_891	852	891	1.1363385270840515e+03
C852_891	852	891	7.7918574491359141e-10
R852_977	852	977	3.9928584351904078e+03
C852_977	852	977	2.2175060700787831e-10
R853_854	853	854	4.1587429335511524e+03
C853_854	853	854	2.1290538892336405e-10
R853_856	853	856	7.9002153867808020e+03
C853_856	853	856	1.1207527116052371e-10
R853_891	853	891	3.2479824524571109e+03
C853_891	853	891	2.7260577748201111e-10
R853_962	853	962	5.3934585021168814e+03
C853_962	853	962	1.6416530902249116e-10
R853_969	853	969	6.8119825472097764e+03
C853_969	853	969	1.2997960220298453e-10
R853_978	853	978	5.2467534336885401e+03
C853_978	853	978	1.6875555386591485e-10
R854_855	854	855	5.8466060728922885e+03
C854_855	854	855	1.5144149796669778e-10
R854_856	854	856	2.8866388812532914e+03
C854_856	854	856	3.0673001304395168e-10
R854_978	854	978	1.1850976526049933e+04
C854_978	854	978	7.4712727660352601e-11
R855_856	855	856	1.5672875605263453e+03
C855_856	855	856	5.6493703134008690e-10
R855_866	855	866	4.5961306950007265e+03
C855_866	855	866	1.9264438730236331e-10
R855_870	855	870	2.8712308278897744e+03
C855_870	855	870	3.0837603619307170e-10
R855_978	855	978	1.1232284576582990e+04
C855_978	855	978	7.8828022533004254e-11
R856_870	856	870	3.1163242417510169e+03
C856_870	856	870	2.8412280398733358e-10
R856_866	856	866	4.9317191376275778e+03
C856_866	856	866	1.7953552442687036e-10
R856_891	856	891	3.5502028193204565e+03
C856_891	856	891	2.4939949258151901e-10
R856_977	856	977	1.0466087063854382e+03
C856_977	856	977	8.4598835868457213e-10
R856_978	856	978	1.4408955935658048e+03
C856_978	856	978	6.1449197683285411e-10
R856_979	856	979	4.7774489966337333e+03
C856_979	856	979	1.8533296374778260e-10
R857_956	857	956	6.1666974006239243e+03
C857_956	857	956	1.4358070846972592e-10
R857_955	857	955	2.3421343367666912e+04
C857_955	857	955	3.7803928143691270e-11
R857_957	857	957	1.5587597650619720e+04
C857_957	857	957	5.6802773688785727e-11
R857_971	857	971	1.0230249705254208e+04
C857_971	857	971	8.6549087970477722e-11
R857_972	857	972	1.2067547529793977e+04
C857_972	857	972	7.3371890975689938e-11
R857_858	857	858	1.3728643377111990e+04
C857_858	857	858	6.4494266285345099e-11
R857_983	857	983	4.4813892815495301e+03
C857_983	857	983	1.9757685085412815e-10
R857_859	857	859	2.2547882193757454e+04
C857_859	857	859	3.9268378914323700e-11
R858_963	858	963	9.7770610510604711e+03
C858_963	858	963	9.0560831836471237e-11
R858_859	858	859	5.6423425273644671e+03
C858_859	858	859	1.5692396861868263e-10
R858_972	858	972	1.0421059976486633e+04
C858_972	858	972	8.4964368662861388e-11
R858_973	858	973	8.0045128406513641e+03
C858_973	858	973	1.1061494925754275e-10
R858_983	858	983	1.2160563842257068e+04
C858_983	858	983	7.2810668418452322e-11
R858_985	858	985	1.2990098132104215e+04
C858_985	858	985	6.8161054111804059e-11
R859_869	859	869	1.2446928709058784e+04
C859_869	859	869	7.1135522858389852e-11
R859_963	859	963	5.6321153560355333e+03
C859_963	859	963	1.5720892164453992e-10
R859_983	859	983	1.6534766049581835e+04
C859_983	859	983	5.3548914997947157e-11
R859_957	859	957	8.6595659618691952e+03
C859_957	859	957	1.0224747817601698e-10
R859_984	859	984	1.1146936960450616e+04
C859_984	859	984	7.9431577019002616e-11
R859_985	859	985	6.0610192124004470e+03
C859_985	859	985	1.4608414041791707e-10
R860_861	860	861	1.4002809696550814e+03
C860_861	860	861	6.3231508596313867e-10
R860_872	860	872	4.3079463015646788e+03
C860_872	860	872	2.0553152702446854e-10
R860_891	860	891	3.8561222581739748e+03
C860_891	860	891	2.2961377322079009e-10
R860_964	860	964	4.0396921307740545e+03
C860_964	860	964	2.1917976742706452e-10
R860_976	860	976	1.2080535355150396e+03
C860_976	860	976	7.3293008601850753e-10
R860_977	860	977	1.6846507925243461e+03
C860_977	860	977	5.2558001078268223e-10
R860_989	860	989	3.6286542649457347e+03
C860_989	860	989	2.4400747964706996e-10
R861_872	861	872	4.7480598308641920e+03
C861_872	861	872	1.8648012309037089e-10
R861_963	861	963	5.0419150033943997e+03
C861_963	861	963	1.7561160414324798e-10
R861_964	861	964	1.5853450180674479e+03
C861_964	861	964	5.5850226392948513e-10
R861_989	861	989	8.2334116660931631e+03
C861_989	861	989	1.0753971957291188e-10
R862_863	862	863	1.9478436548230754e-06
C862_863	862	863	4.5456357829726514e-11
R862_871	862	871	3.5822718771783957e-06
C862_871	862	871	2.7188351199719302e-10
R862_873	862	873	1.6101058422838521e+03
C862_873	862	873	5.4991340224197892e-10
R862_869	862	869	1.9945918985496455e-05
C862_869	862	869	9.3221046330493821e-11
R862_990	862	990	9.8160674551825078e-06
C862_990	862	990	9.9221064172885803e-11
R863_867	863	867	3.4151777949495189e-06
C863_867	863	867	2.5925993750878427e-11
R863_871	863	871	3.4016732616701016e-06
C863_871	863	871	2.6028919110981604e-11
R863_987	863	987	5.9288822505600521e-06
C863_987	863	987	1.4933991674676316e-11
R863_869	863	869	1.2724166816026261e-05
C863_869	863	869	6.9585599945514940e-12
R863_864	863	864	9.1499626542211331e-06
C863_864	863	864	9.6767474924231699e-12
R863_990	863	990	5.0320887777451568e-06
C863_990	863	990	1.7595452322221352e-11
R864_869	864	869	2.1523851361208625e-06
C864_869	864	869	4.1136633348794943e-11
R864_984	864	984	3.6951204370157848e-06
C864_984	864	984	2.3961838234833631e-11
R864_957	864	957	1.1493736626885405e-05
C864_957	864	957	7.7034893911601013e-12
R864_958	864	958	8.2651589227041130e-06
C864_958	864	958	1.0712664934582016e-11
R864_986	864	986	3.8726658768601565e-06
C864_986	864	986	2.2863288748728083e-11
R864_990	864	990	4.3280787170062451e-06
C864_990	864	990	2.0457548015957732e-11
R864_987	864	987	7.7522621067136725e-06
C864_987	864	987	1.1421424733990909e-11
R865_868	865	868	1.8497484821588201e-06
C865_868	865	868	4.7866982470321482e-11
R865_867	865	867	4.0341670595090502e-06
C865_867	865	867	2.1947994930278215e-11
R865_866	865	866	4.3749030982224513e+03
C865_866	865	866	2.0238591845834274e-10
R865_870	865	870	5.8197194683244807e+03
C865_870	865	870	1.5214114469248045e-10
R865_871	865	871	3.0169641033383431e-06
C865_871	865	871	3.2282805679336007e-10
R865_980	865	980	1.5099987594359772e-05
C865_980	865	980	6.4500758878758175e-11
R865_991	865	991	4.7609571588747433e-06
C865_991	865	991	2.0457244759712053e-10
R866_870	866	870	1.7189097945189285e+03
C866_870	866	870	5.1510485571920452e-10
R866_978	866	978	5.9653598192309155e+03
C866_978	866	978	1.4842671834239043e-10
R866_979	866	979	1.5235633712618749e+03
C866_979	866	979	5.8114995306474283e-10
R866_981	866	981	7.1377584885799479e+03
C866_981	866	981	1.2404717575085028e-10
R866_980	866	980	3.5710819281220388e+03
C866_980	866	980	2.4794132409211472e-10
R866_991	866	991	3.8981274918436789e+03
C866_991	866	991	2.2713951340807169e-10
R867_868	867	868	2.6931350697105473e-06
C867_868	867	868	3.2876879873506057e-11
R867_871	867	871	1.8253797418134350e-06
C867_871	867	871	4.8506004609231345e-11
R867_987	867	987	6.3159988734964594e-06
C867_987	867	987	1.4018665921798099e-11
R867_988	867	988	6.5116706382877297e-06
C867_988	867	988	1.3597413488542545e-11
R867_991	867	991	4.2118816684613308e-06
C867_991	867	991	2.1021929185001485e-11
R868_982	868	982	1.5963041366289218e-05
C868_982	868	982	5.5466797421813941e-12
R868_988	868	988	4.9708645949154091e-06
C868_988	868	988	1.7812168583422608e-11
R868_980	868	980	7.9283105452569775e-06
C868_980	868	980	1.1167811561439050e-11
R868_991	868	991	5.7302781224410171e-06
C868_991	868	991	1.5451584770946928e-11
R869_873	869	873	4.8691451044077075e+03
C869_873	869	873	1.8184275939907609e-10
R869_963	869	963	4.0757299668248993e+03
C869_963	869	963	2.1724176746423781e-10
R869_984	869	984	6.9644333846200617e-06
C869_984	869	984	2.6698215564203849e-10
R869_957	869	957	1.9157932753689848e-05
C869_957	869	957	5.0838504937775867e-11
R869_990	869	990	5.8655749715003146e-06
C869_990	869	990	2.1636416860140357e-10
R869_992	869	992	8.9079809414179635e+03
C869_992	869	992	9.9396124388099559e-11
R870_871	870	871	2.6381458221783623e+03
C870_871	870	871	3.3562162267773905e-10
R870_872	870	872	1.8212572172284008e+03
C870_872	870	872	4.8615800850328826e-10
R870_873	870	873	3.0305871731268958e+03
C870_873	870	873	2.9216080288046747e-10
R870_977	870	977	2.6278180059776937e+03
C870_977	870	977	3.3694067842060296e-10
R870_979	870	979	2.4011492252556282e+03
C870_979	870	979	3.6874791969905063e-10
R870_989	870	989	4.9489776866519778e+03
C870_989	870	989	1.7890943094936294e-10
R870_991	870	991	4.2469086689700516e+03
C870_991	870	991	2.0848547748843616e-10
R870_993	870	993	1.2070462552828899e+03
C870_993	870	993	7.3354171625551202e-10
R871_873	871	873	2.3722762378113571e+03
C871_873	871	873	3.7323595270544060e-10
R871_987	871	987	6.2873113234273091e-06
C871_987	871	987	1.4082629858025622e-11
R871_990	871	990	5.8243999110359513e-06
C871_990	871	990	1.6722077360289066e-10
R871_991	871	991	3.7015625603259755e-06
C871_991	871	991	2.6312149072803142e-10
R871_993	871	993	3.0141085357828465e+03
C871_993	871	993	2.9375809503489986e-10
R872_873	872	873	1.6872564807450128e+03
C872_873	872	873	5.2476833949337740e-10
R872_963	872	963	1.7770991609326911e+03
C872_963	872	963	4.9823825319646079e-10
R872_977	872	977	5.2089526072992076e+03
C872_977	872	977	1.6998019533894000e-10
R872_989	872	989	1.1032996016332006e+03
C872_989	872	989	8.0251889911799623e-10
R872_990	872	990	5.2386317406781754e+03
C872_990	872	990	1.6901718340395824e-10
R872_992	872	992	3.8076118516445445e+03
C872_992	872	992	2.3253913901900983e-10
R872_993	872	993	1.9465457131823568e+03
C872_993	872	993	4.5486667777889070e-10
R873_963	873	963	8.2865891443071341e+03
C873_963	873	963	1.0684960558329124e-10
R873_990	873	990	2.8939430312939890e+03
C873_990	873	990	3.0595584367951316e-10
R873_993	873	993	4.1331537351121124e+03
C873_993	873	993	2.1422352964472610e-10
R874_875	874	875	3.6484887674083038e+03
C874_875	874	875	2.4268096687302000e-10
R874_886	874	886	4.2128232040082139e+03
C874_886	874	886	2.1017230935719891e-10
R874_960	874	960	2.6479214637116324e+03
C874_960	874	960	3.3438256905810754e-10
R874_967	874	967	1.6386485994268057e+03
C874_967	874	967	5.4033475023853004e-10
R874_970	874	970	1.1148919639292405e+03
C874_970	874	970	7.9417451228143856e-10
R874_974	874	974	3.5990364252456839e+03
C874_974	874	974	2.4601551000961546e-10
R874_994	874	994	2.9408991669816428e+03
C874_994	874	994	3.0107077170168308e-10
R874_995	874	995	6.2751637645353667e+03
C874_995	874	995	1.4109891230313719e-10
R875_883	875	883	1.6177646403156589e+03
C875_883	875	883	5.4731001014290743e-10
R875_886	875	886	2.3657562750434859e+03
C875_886	875	886	3.7426458128436110e-10
R875_887	875	887	2.4595263968705490e+03
C875_887	875	887	3.5999564096022260e-10
R875_960	875	960	1.3417662710363486e+03
C875_960	875	960	6.5989047482623296e-10
R875_995	875	995	1.1344668453118886e+03
C875_995	875	995	7.8047127190974007e-10
R876_883	876	883	4.1998790053752755e+03
C876_883	876	883	2.1082006899884116e-10
R876_889	876	889	1.5335065414603532e+03
C876_889	876	889	5.7738180944231165e-10
R876_890	876	890	2.4507640062253599e+03
C876_890	876	890	3.6128275894818309e-10
R876_949	876	949	1.7043034795407746e+03
C876_949	876	949	5.1951943555180479e-10
R876_996	876	996	7.4750263303285456e+03
C876_996	876	996	1.1845025590178539e-10
R876_997	876	997	5.6404684229360564e+03
C876_997	876	997	1.5697610824299401e-10
R877_881	877	881	2.5180623677578837e+03
C877_881	877	881	3.5162702601698810e-10
R877_882	877	882	2.8946583753942591e+03
C877_882	877	882	3.0588023416732344e-10
R877_892	877	892	5.7749910627833997e+03
C877_892	877	892	1.5331950683110678e-10
R877_893	877	893	8.6479460456577090e+03
C877_893	877	893	1.0238486422386791e-10
R877_937	877	937	6.1695081182001768e+03
C877_937	877	937	1.4351529566643997e-10
R877_949	877	949	3.9090620796294493e+03
C877_949	877	949	2.2650414950277059e-10
R877_951	877	951	6.3144781958663179e+03
C877_951	877	951	1.4022041952407514e-10
R877_999	877	999	6.3859602277545482e+03
C877_999	877	999	1.3865084499771993e-10
R878_879	878	879	4.0360371067463821e+03
C878_879	878	879	2.1937825601751542e-10
R878_880	878	880	1.3583392407528345e+03
C878_880	878	880	6.5183921301520588e-10
R878_906	878	906	3.1506001139004643e+03
C878_906	878	906	2.8103178749773018e-10
R878_908	878	908	4.6693272753564424e+03
C878_908	878	908	1.8962448538851028e-10
R878_933	878	933	5.1685148527565007e+03
C878_933	878	933	1.7131009717961508e-10
R878_945	878	945	3.2400308741329063e+03
C878_945	878	945	2.7327479770912827e-10
R878_946	878	946	1.8878324812494923e+03
C878_946	878	946	4.6901342703562932e-10
R878_947	878	947	1.6661954668722810e+03
C878_947	878	947	5.3140150678844093e-10
R878_1000	878	1000	2.5260797373370829e+03
C878_1000	878	1000	3.5051101856087164e-10
R879_880	879	880	1.5304294676419153e+04
C879_880	879	880	5.7854269041503291e-11
R879_881	879	881	1.3785810311197229e+04
C879_881	879	881	6.4226821761854477e-11
R879_882	879	882	4.5822553942284430e+03
C879_882	879	882	1.9322772423711369e-10
R879_933	879	933	1.0337865856579338e+04
C879_933	879	933	8.5648120606681335e-11
R879_935	879	935	1.9024605737883583e+04
C879_935	879	935	4.6540716475236647e-11
R879_942	879	942	8.7648277775258030e+03
C879_942	879	942	1.0101952989542282e-10
R879_943	879	943	5.7025550965128459e+03
C879_943	879	943	1.5526702797513352e-10
R879_999	879	999	1.9021115556140936e+04
C879_999	879	999	4.6549256224572176e-11
R879_1000	879	1000	6.4575957695783654e+03
C879_1000	879	1000	1.3711276042876428e-10
R879_1001	879	1001	1.9352709754544721e+04
C879_1001	879	1001	4.5751669555839417e-11
R880_881	880	881	2.3641085642653798e+03
C880_881	880	881	3.7452543215803373e-10
R880_888	880	888	3.3230513732192162e+03
C880_888	880	888	2.6644751532753099e-10
R880_947	880	947	4.7473586147490523e+03
C880_947	880	947	1.8650766743198814e-10
R880_950	880	950	3.8467516693555754e+03
C880_950	880	950	2.3017310650789403e-10
R880_1000	880	1000	1.1380970903655616e+04
C880_1000	880	1000	7.7798176376639333e-11
R880_1001	880	1001	5.9260778515139782e+03
C880_1001	880	1001	1.4941058890642075e-10
R881_882	881	882	1.9288216493364009e+03
C881_882	881	882	4.5904647638345554e-10
R881_949	881	949	6.9937116001091299e+03
C881_949	881	949	1.2660212950247822e-10
R881_950	881	950	2.7915316993642750e+03
C881_950	881	950	3.1718027128319536e-10
R881_999	881	999	6.8810683583043165e+03
C881_999	881	999	1.2867460917336266e-10
R881_1001	881	1001	7.3155910147113100e+03
C881_1001	881	1001	1.2103174985034900e-10
R882_937	882	937	6.1704525591512138e+03
C882_937	882	937	1.4349332941339317e-10
R882_940	882	940	8.3882512088614349e+03
C882_940	882	940	1.0555463345740463e-10
R882_943	882	943	5.8392539494975163e+03
C882_943	882	943	1.5163217584948377e-10
R882_999	882	999	2.3676433182148317e+03
C882_999	882	999	3.7396628744214426e-10
R882_1001	882	1001	1.1540650261652043e+04
C882_1001	882	1001	7.6721741117320084e-11
R883_887	883	887	3.5865999587092278e+03
C883_887	883	887	2.4686856406998095e-10
R883_888	883	888	3.4176784905124896e+03
C883_888	883	888	2.5907023851363776e-10
R883_889	883	889	5.6071560097616193e+03
C883_889	883	889	1.5790871168174299e-10
R883_949	883	949	4.1116934716295473e+03
C883_949	883	949	2.1534163181407845e-10
R883_950	883	950	2.8558403147822505e+03
C883_950	883	950	3.1003791672697586e-10
R883_960	883	960	4.3300377469968380e+03
C883_960	883	960	2.0448292449969873e-10
R883_995	883	995	3.1776305753495294e+03
C883_995	883	995	2.7864119528828700e-10
R883_996	883	996	3.4613068538697903e+03
C883_996	883	996	2.5580476365742870e-10
R883_1002	883	1002	2.3438119739539161e+03
C883_1002	883	1002	3.7776869114903202e-10
R884_885	884	885	1.7502629358980892e+03
C884_885	884	885	5.0587758189924586e-10
R884_897	884	897	5.6561570202068442e+03
C884_897	884	897	1.5654070043260933e-10
R884_902	884	902	4.0614199738849843e+03
C884_902	884	902	2.1800719634838584e-10
R884_903	884	903	1.3618304682844005e+03
C884_903	884	903	6.5016813936864553e-10
R884_914	884	914	4.8372140625127622e+03
C884_914	884	914	1.8304312570365267e-10
R884_915	884	915	2.4038324452153242e+03
C884_915	884	915	3.6833631373200317e-10
R884_1003	884	1003	2.6453084459101760e+03
C884_1003	884	1003	3.3471286989950711e-10
R885_886	885	886	2.4033076382557765e+03
C885_886	885	886	3.6841674682255882e-10
R885_887	885	887	2.8811173267503823e+03
C885_887	885	887	3.0731784973806170e-10
R885_897	885	897	2.0113905615752130e+03
C885_897	885	897	4.4020231506236545e-10
R885_913	885	913	1.5484236639674991e+03
C885_913	885	913	5.7181945891430432e-10
R885_914	885	914	3.3897368132025063e+03
C885_914	885	914	2.6120576035621096e-10
R885_1003	885	1003	3.3952628253717521e+03
C885_1003	885	1003	2.6078063090831692e-10
R885_1005	885	1005	3.8839692411827928e+03
C885_1005	885	1005	2.2796750610475016e-10
R886_887	886	887	1.4204515277054725e+03
C886_887	886	887	6.2333614659154330e-10
R886_897	886	897	1.3056143979456192e+03
C886_897	886	897	6.7816254408131845e-10
R886_967	886	967	2.6871307960665104e+03
C886_967	886	967	3.2950341791925367e-10
R886_994	886	994	1.3526177951799589e+03
C886_994	886	994	6.5459643134607702e-10
R886_995	886	995	1.7246862057790893e+03
C886_995	886	995	5.1337963899353594e-10
R886_1004	886	1004	1.6749976118246134e+03
C886_1004	886	1004	5.2860898155878144e-10
R886_1005	886	1005	1.7997290154505552e+03
C886_1005	886	1005	4.9197338827053306e-10
R887_888	887	888	5.4964846443687429e+03
C887_888	887	888	1.6108819345236036e-10
R887_913	887	913	6.5238463848101101e+03
C887_913	887	913	1.3572036027113967e-10
R887_995	887	995	5.2190771078480875e+03
C887_995	887	995	1.6965045033892458e-10
R887_1002	887	1002	7.4429617737258641e+03
C887_1002	887	1002	1.1896054401697796e-10
R887_1005	887	1005	6.6332022014350596e+03
C887_1005	887	1005	1.3348285711966447e-10
R888_913	888	913	1.4271169228624337e+03
C888_913	888	913	6.2042483521537627e-10
R888_947	888	947	2.2898815990361331e+03
C888_947	888	947	3.8666574816474984e-10
R888_950	888	950	1.9979636920074061e+03
C888_950	888	950	4.4316059658241188e-10
R888_1001	888	1001	3.6796264106852645e+03
C888_1001	888	1001	2.4062735801896442e-10
R888_1002	888	1002	1.3818087798754361e+03
C888_1002	888	1002	6.4076795182891858e-10
R888_1005	888	1005	7.8318900623237241e+03
C888_1005	888	1005	1.1305301461768682e-10
R888_1007	888	1007	4.4324294491281025e+03
C888_1007	888	1007	1.9975924983400911e-10
R889_890	889	890	5.1243726333610348e+03
C889_890	889	890	1.7278579155928032e-10
R889_894	889	894	1.0836132291862781e+04
C889_894	889	894	8.1709853465418762e-11
R889_960	889	960	1.0384829359099613e+04
C889_960	889	960	8.5260792554492953e-11
R889_961	889	961	5.1498114511458270e+03
C889_961	889	961	1.7193227171511211e-10
R889_996	889	996	8.2933932932024782e+03
C889_996	889	996	1.0676194295834455e-10
R889_997	889	997	8.8463116114774584e+03
C889_997	889	997	1.0008903377891782e-10
R889_998	889	998	3.4747104951998203e+03
C889_998	889	998	2.5481800078687772e-10
R889_1009	889	1009	7.2222092734846565e+03
C889_1009	889	1009	1.2259666650074691e-10
R890_892	890	892	4.1516635350124243e+03
C890_892	890	892	2.1326843426326702e-10
R890_894	890	894	2.2944791139088327e+04
C890_894	890	894	3.8589097470214789e-11
R890_895	890	895	7.2929644820338144e+03
C890_895	890	895	1.2140725268595854e-10
R890_949	890	949	8.7515573784406170e+03
C890_949	890	949	1.0117271057163167e-10
R890_953	890	953	6.9262494882578421e+03
C890_953	890	953	1.2783524231996866e-10
R890_997	890	997	6.6025143759808170e+03
C890_997	890	997	1.3410327206875172e-10
R890_1008	890	1008	1.3940751153530437e+04
C890_1008	890	1008	6.3512989504569946e-11
R890_1009	890	1009	7.1517208279244633e+03
C890_1009	890	1009	1.2380499784650597e-10
R891_969	891	969	2.4198196197855582e+03
C891_969	891	969	3.6590280302730373e-10
R891_968	891	968	9.0628796958987241e+03
C891_968	891	968	9.7697289538189893e-11
R891_974	891	974	3.0557820727229832e+03
C891_974	891	974	2.8975193931647436e-10
R891_976	891	976	4.4096483820743806e+03
C891_976	891	976	2.0079124342414861e-10
R891_977	891	977	3.8522731751497267e+03
C891_977	891	977	2.2984319684586917e-10
R891_978	891	978	7.8650708050103849e+03
C891_978	891	978	1.1257607256834239e-10
R891_1010	891	1010	4.6325043792193183e+03
C891_1010	891	1010	1.9113177435338186e-10
R892_893	892	893	1.1589321678581414e+03
C892_893	892	893	7.6399534524645205e-10
R892_895	892	895	5.3126051775794294e+03
C892_895	892	895	1.6666376515926625e-10
R892_896	892	896	1.9111804501391018e+03
C892_896	892	896	4.6328371642539368e-10
R892_949	892	949	3.4173276968406622e+03
C892_949	892	949	2.5909683245144281e-10
R892_951	892	951	1.7736519264967617e+03
C892_951	892	951	4.9920661910752673e-10
R892_953	892	953	1.2315335388334640e+03
C892_953	892	953	7.1895628805910422e-10
R892_1008	892	1008	2.4220929782891317e+03
C892_1008	892	1008	3.6555936937046242e-10
R892_1014	892	1014	4.3813935628401496e+03
C892_1014	892	1014	2.0208611004715251e-10
R893_896	893	896	4.3613782400498067e+03
C893_896	893	896	2.0301352759761755e-10
R893_937	893	937	3.6344818667081927e+03
C893_937	893	937	2.4361623311713966e-10
R893_938	893	938	2.9712764340116082e+03
C893_938	893	938	2.9799273186593747e-10
R893_951	893	951	2.6681365445577389e+03
C893_951	893	951	3.3184912650216860e-10
R893_952	893	952	9.8963427543164635e+03
C893_952	893	952	8.9469292210378352e-11
R893_1014	893	1014	3.1762310736673317e+03
C893_1014	893	1014	2.7876396935997487e-10
R894_895	894	895	6.9220846999467794e+03
C894_895	894	895	1.2791215653671615e-10
R894_961	894	961	4.4312827047716828e+03
C894_961	894	961	1.9981094429984473e-10
R894_962	894	962	1.2863823073709604e+04
C894_962	894	962	6.8830143000767153e-11
R894_1009	894	1009	4.3157340406296380e+03
C894_1009	894	1009	2.0516064552736504e-10
R894_1018	894	1018	9.9715187586901575e+03
C894_1018	894	1018	8.8794776716270984e-11
R895_896	895	896	1.2706948660623733e+04
C895_896	895	896	6.9679889747546868e-11
R895_1008	895	1008	5.6263304610440400e+03
C895_1008	895	1008	1.5737056111981360e-10
R895_1009	895	1009	7.0289311687908221e+03
C895_1009	895	1009	1.2596776955667893e-10
R895_1018	895	1018	1.3638961577386797e+04
C895_1018	895	1018	6.4918342696119305e-11
R895_1019	895	1019	1.8658708076913477e+04
C895_1019	895	1019	4.7453380912022177e-11
R896_952	896	952	9.7649918389349605e+03
C896_952	896	952	9.0672762077450950e-11
R896_1008	896	1008	7.3961997853079711e+03
C896_1008	896	1008	1.1971266426020861e-10
R896_1014	896	1014	1.7173434546097884e+04
C896_1014	896	1014	5.1557466814416762e-11
R896_1019	896	1019	2.3025635208587406e+04
C896_1019	896	1019	3.8453609365346997e-11
R897_902	897	902	2.7308875583745248e+03
C897_902	897	902	3.2422381470257892e-10
R897_898	897	898	5.6600706561570178e+03
C897_898	897	898	1.5643246091580903e-10
R897_967	897	967	5.4822779017868488e+03
C897_967	897	967	1.6150563644564865e-10
R897_1003	897	1003	3.9371953196693171e+03
C897_1003	897	1003	2.2488566347639722e-10
R897_1004	897	1004	2.1470743116696317e+03
C897_1004	897	1004	4.1238385503828738e-10
R897_1005	897	1005	1.1957531086329718e+04
C897_1005	897	1005	7.4046956291189825e-11
R897_1020	897	1020	6.5507239315760353e+03
C897_1020	897	1020	1.3516350115627262e-10
R898_899	898	899	6.0929459123502238e+03
C898_899	898	899	1.4531866759317231e-10
R898_902	898	902	2.3404817306612044e+03
C898_902	898	902	3.7830621367416617e-10
R898_965	898	965	3.9912593538434485e+03
C898_965	898	965	2.2183945046000872e-10
R898_966	898	966	1.4664604577717516e+03
C898_966	898	966	6.0377951345880181e-10
R898_967	898	967	1.5789662108025866e+03
C898_967	898	967	5.6075853659334665e-10
R898_1004	898	1004	6.9083670139011165e+03
C898_1004	898	1004	1.2816614692276014e-10
R898_1020	898	1020	4.8710897372507306e+03
C898_1020	898	1020	1.8177016426713077e-10
R899_900	899	900	1.7637783363015506e+03
C899_900	899	900	5.0200116617637226e-10
R899_901	899	901	9.6570009249787054e+03
C899_901	899	901	9.1686724333823397e-11
R899_902	899	902	2.0125707872692365e+03
C899_902	899	902	4.3994416857326223e-10
R899_916	899	916	9.3662670640346187e+03
C899_916	899	916	9.4532728529587388e-11
R899_921	899	921	2.9745023949386964e+03
C899_921	899	921	2.9766954741962758e-10
R899_966	899	966	4.6872037858831127e+03
C899_966	899	966	1.8890127721066834e-10
R899_1020	899	1020	2.4187769936321861e+03
C899_1020	899	1020	3.6606052729582158e-10
R899_1022	899	1022	2.3894988522055419e+03
C899_1022	899	1022	3.7054580749546955e-10
R899_1023	899	1023	5.1580976908946905e+03
C899_1023	899	1023	1.7165607066011598e-10
R899_1024	899	1024	3.1693085230272350e+03
C899_1024	899	1024	2.7937285854842335e-10
R900_901	900	901	4.0101252943668901e+03
C900_901	900	901	2.2079578983324216e-10
R900_902	900	902	1.5771736902252542e+03
C900_902	900	902	5.6139586095526592e-10
R900_903	900	903	2.5673712985866719e+03
C900_903	900	903	3.4487367767467833e-10
R900_904	900	904	4.8508448182404727e+03
C900_904	900	904	1.8252877898105274e-10
R900_1022	900	1022	5.0960817756564657e+03
C900_1022	900	1022	1.7374501051564123e-10
R900_1024	900	1024	6.9627441877908032e+03
C900_1024	900	1024	1.2716520352027080e-10
R901_904	901	904	8.8510774399048241e+03
C901_904	901	904	1.0003514122564508e-10
R901_916	901	916	1.1990747870962317e+04
C901_916	901	916	7.3841831320980048e-11
R901_1024	901	1024	1.1405939167123142e+04
C901_1024	901	1024	7.7627871648847697e-11
R902_903	902	903	2.6141091247826785e+03
C902_903	902	903	3.3870765887541469e-10
R902_1003	902	1003	2.8428055641304240e+03
C902_1003	902	1003	3.1145949370295319e-10
R902_1020	902	1020	1.3156007674099367e+03
C902_1020	902	1020	6.7301479569911712e-10
R902_1022	902	1022	2.5379831460979894e+03
C902_1022	902	1022	3.4886708489821268e-10
R902_1025	902	1025	5.6167499838714130e+03
C902_1025	902	1025	1.5763898771397947e-10
R903_904	903	904	2.4232790887175902e+03
C903_904	903	904	3.6538044083422827e-10
R903_905	903	905	4.7318513443078391e+03
C903_905	903	905	1.8711889222071844e-10
R903_915	903	915	2.5294340630763763e+03
C903_915	903	915	3.5004619990889440e-10
R903_1003	903	1003	9.1383535254137460e+03
C903_1003	903	1003	9.6890405830508963e-11
R903_1022	903	1022	7.4411506174763517e+03
C903_1022	903	1022	1.1898949869667974e-10
R903_1025	903	1025	7.4063610156947661e+03
C903_1025	903	1025	1.1954842328421682e-10
R903_1026	903	1026	6.2426804927155272e+03
C903_1026	903	1026	1.4183310882771903e-10
R904_905	904	905	1.1663056526428816e+04
C904_905	904	905	7.5916530087427441e-11
R904_1022	904	1022	1.0589858627811465e+04
C904_1022	904	1022	8.3610066273659376e-11
R904_1024	904	1024	7.8579121323660884e+03
C904_1024	904	1024	1.1267863101357846e-10
R904_1026	904	1026	6.6665068080999990e+03
C904_1026	904	1026	1.3281600202135707e-10
R905_910	905	910	5.2681610381502633e+03
C905_910	905	910	1.6806980183181433e-10
R905_915	905	915	2.4995539440439788e+03
C905_915	905	915	3.5423071536815824e-10
R905_924	905	924	6.7892237627765053e+03
C905_924	905	924	1.3041531884020586e-10
R905_1026	905	1026	6.1253694585865278e+03
C905_1026	905	1026	1.4454944925139525e-10
R905_1027	905	1027	4.8365202527285956e+03
C905_1027	905	1027	1.8306938365459706e-10
R906_907	906	907	2.4171324323099275e+03
C906_907	906	907	3.6630958646061915e-10
R906_908	906	908	3.2036685021164917e+03
C906_908	906	908	2.7637652931789025e-10
R906_924	906	924	7.6680039670912083e+03
C906_924	906	924	1.1546926494821260e-10
R906_925	906	925	2.0702018531785125e+03
C906_925	906	925	4.2769683562043012e-10
R906_945	906	945	5.6018199666041010e+03
C906_945	906	945	1.5805912845798807e-10
R906_946	906	946	3.9699359708783300e+03
C906_946	906	946	2.2303099802995187e-10
R906_1028	906	1028	7.2322750725580590e+03
C906_1028	906	1028	1.2242603783968452e-10
R907_908	907	908	5.7029686343667718e+03
C907_908	907	908	1.5525576913826259e-10
R907_909	907	909	2.4008381469302371e+03
C907_909	907	909	3.6879569863221119e-10
R907_911	907	911	4.4379749386872945e+03
C907_911	907	911	1.9950963985431999e-10
R907_912	907	912	3.5454925065997045e+03
C907_912	907	912	2.4973082866536890e-10
R907_925	907	925	7.0473166063900308e+03
C907_925	907	925	1.2563913772472804e-10
R907_1028	907	1028	5.0309635571030813e+03
C907_1028	907	1028	1.7599387704764851e-10
R908_909	908	909	6.7257833801275810e+03
C908_909	908	909	1.3164545030042355e-10
R908_926	908	926	7.4206869874323338e+03
C908_926	908	926	1.1931762964797522e-10
R908_932	908	932	6.8795413809066886e+03
C908_932	908	932	1.2870316968473651e-10
R908_933	908	933	3.4702797829161118e+03
C908_933	908	933	2.5514334206101779e-10
R908_944	908	944	5.2814415659799470e+03
C908_944	908	944	1.6764717939953479e-10
R908_946	908	946	4.9377384696065610e+03
C908_946	908	946	1.7931666230401835e-10
R908_1028	908	1028	6.8390193116051660e+03
C908_1028	908	1028	1.2946575252354217e-10
R909_912	909	912	2.7225046517800065e+03
C909_912	909	912	3.2522213731429356e-10
R909_927	909	927	8.5738924131264248e+03
C909_927	909	927	1.0326917332720958e-10
R909_926	909	926	2.4314305904125940e+03
C909_926	909	926	3.6415548327445850e-10
R909_929	909	929	5.4224918916098550e+03
C909_929	909	929	1.6328632654481168e-10
R909_932	909	932	7.0586372327533281e+03
C909_932	909	932	1.2543763796097920e-10
R909_1028	909	1028	9.5996278724716994e+03
C909_1028	909	1028	9.2234698413577523e-11
R910_911	910	911	6.5987642995365777e+03
C910_911	910	911	1.3417948293170312e-10
R910_924	910	924	3.2332952606558556e+03
C910_924	910	924	2.7384408484871803e-10
R910_925	910	925	5.3364048359338149e+03
C910_925	910	925	1.6592046685398466e-10
R910_1027	910	1027	1.0529886936352481e+04
C910_1027	910	1027	8.4086257245864246e-11
R910_1029	910	1029	7.5105256685300592e+03
C910_1029	910	1029	1.1789038754104839e-10
R911_912	911	912	1.0246208716212519e+04
C911_912	911	912	8.6414283197160217e-11
R911_925	911	925	2.9209924133466247e+03
C911_925	911	925	3.0312258862924002e-10
R911_1028	911	1028	7.7688847705454946e+03
C911_1028	911	1028	1.1396986927350580e-10
R911_1029	911	1029	1.0635832832776365e+04
C911_1029	911	1029	8.3248655335331320e-11
R911_1030	911	1030	1.6095709354666365e+04
C911_1030	911	1030	5.5009615431661925e-11
R912_927	912	927	5.3628173114195024e+03
C912_927	912	927	1.6510328998427799e-10
R912_926	912	926	5.1018066115650390e+03
C912_926	912	926	1.7355004787772374e-10
R912_1028	912	1028	5.3674487146336805e+03
C912_1028	912	1028	1.6496082753171279e-10
R912_1030	912	1030	5.6795551079301176e+03
C912_1030	912	1030	1.5589579903252072e-10
R913_914	913	914	1.8133841544840161e+03
C913_914	913	914	4.8826873197860211e-10
R913_945	913	945	3.0266141920329865e+03
C913_945	913	945	2.9254431702286491e-10
R913_947	913	947	3.4212692729113628e+03
C913_947	913	947	2.5879833216008284e-10
R913_1005	913	1005	3.4222439505995358e+03
C913_1005	913	1005	2.5872462468518218e-10
R913_1007	913	1007	7.5823081243261113e+03
C913_1007	913	1007	1.1677430766224539e-10
R913_1031	913	1031	5.0181270129343920e+03
C913_1031	913	1031	1.7644407553212650e-10
R914_915	914	915	4.0345678057067144e+03
C914_915	914	915	2.1945814876319962e-10
R914_924	914	924	3.6547279555854116e+03
C914_924	914	924	2.4226667277569619e-10
R914_945	914	945	3.1227794622887614e+03
C914_945	914	945	2.8353548253806398e-10
R914_1003	914	1003	2.0818529748591732e+03
C914_1003	914	1003	4.2530322380709612e-10
R914_1005	914	1005	5.6004419418281068e+03
C914_1005	914	1005	1.5809801992358125e-10
R914_1006	914	1006	2.3045234962135764e+03
C914_1006	914	1006	3.8420904935652779e-10
R914_1025	914	1025	7.9549645140068351e+03
C914_1025	914	1025	1.1130392601261567e-10
R914_1031	914	1031	2.5190449734549970e+03
C914_1031	914	1031	3.5148986660829782e-10
R914_1032	914	1032	4.9670890924624409e+03
C914_1032	914	1032	1.7825707677432709e-10
R915_924	915	924	4.7211881427782973e+03
C915_924	915	924	1.8754151601739683e-10
R915_1003	915	1003	5.1261910623819049e+03
C915_1003	915	1003	1.7272449874090074e-10
R915_1025	915	1025	2.5831965009329947e+03
C915_1025	915	1025	3.4276090935405252e-10
R915_1026	915	1026	5.6190011468102457e+03
C915_1026	915	1026	1.5757583217483916e-10
R915_1027	915	1027	5.1458068029616288e+03
C915_1027	915	1027	1.7206607546758348e-10
R915_1032	915	1032	9.0086228292632859e+03
C915_1032	915	1032	9.8285697878685448e-11
R916_920	916	920	4.3089957036772503e+03
C916_920	916	920	2.0548147238680079e-10
R916_917	916	917	7.7800704351630193e+03
C916_917	916	917	1.1380601102250146e-10
R916_921	916	921	4.8865391055730461e+03
C916_921	916	921	1.8119547650610002e-10
R916_922	916	922	8.7455493937037336e+03
C916_922	916	922	1.0124221382106057e-10
R916_1024	916	1024	7.2138969649864011e+03
C916_1024	916	1024	1.2273793013644315e-10
R916_1033	916	1033	9.6580774442553648e+03
C916_1033	916	1033	9.1676504647066013e-11
R917_920	917	920	3.7554379911398355e+03
C917_920	917	920	2.3576977806289418e-10
R917_922	917	922	1.2798406028234510e+03
C917_922	917	922	6.9181957483352356e-10
R917_971	917	971	2.9336327783054780e+03
C917_971	917	971	3.0181650145436236e-10
R917_918	917	918	3.1778954441116252e+03
C917_918	917	918	2.7861797131828464e-10
R917_1033	917	1033	9.6787245341497055e+03
C917_1033	917	1033	9.1480936209719884e-11
R917_1034	917	1034	6.3599551085346829e+03
C917_1034	917	1034	1.3921777223109965e-10
R918_919	918	919	3.8989554163526204e+03
C918_919	918	919	2.2709128142026513e-10
R918_956	918	956	4.6019245549347552e+03
C918_956	918	956	1.9240184647324220e-10
R918_954	918	954	3.0896811047597271e+03
C918_954	918	954	2.8657287004020939e-10
R918_971	918	971	2.3756215399855078e+03
C918_971	918	971	3.7271036939048865e-10
R918_922	918	922	6.7642802488740044e+03
C918_922	918	922	1.3089622977217548e-10
R918_1034	918	1034	2.4465071743587828e+03
C918_1034	918	1034	3.6191137756710795e-10
R918_1035	918	1035	4.4945021722177762e+03
C918_1035	918	1035	1.9700041245348802e-10
R919_954	919	954	1.2032518439833003e-05
C919_954	919	954	1.1773678600027617e-10
R919_923	919	923	5.8410794057378237e-06
C919_923	919	923	1.5158478770725723e-11
R919_955	919	955	2.9906326497564998e-05
C919_955	919	955	6.2173448083054727e-11
R919_956	919	956	9.0357698868930274e+03
C919_956	919	956	9.7990408430426901e-11
R919_1035	919	1035	2.3841140407741810e-05
C919_1035	919	1035	4.0852100287105825e-11
R920_921	920	921	2.1763858008234565e+03
C920_921	920	921	4.0682988345402423e-10
R920_922	920	922	2.4771589344223107e+03
C920_922	920	922	3.5743317451146326e-10
R920_966	920	966	5.2517947742924116e+03
C920_966	920	966	1.6859356082117564e-10
R920_971	920	971	3.1792654372286856e+03
C920_971	920	971	2.7849791065945260e-10
R920_972	920	972	1.6126797167775294e+03
C920_972	920	972	5.4903572760823931e-10
R920_1036	920	1036	5.1348490510345955e+03
C920_1036	920	1036	1.7243326393822645e-10
R921_922	921	922	3.6715695837016956e+03
C921_922	921	922	2.4115538641305448e-10
R921_966	921	966	2.2185008835814679e+03
C921_966	921	966	3.9910679696039238e-10
R921_972	921	972	1.0738807854805060e+04
C921_972	921	972	8.2450379378360997e-11
R921_1020	921	1020	5.9995555118059638e+03
C921_1020	921	1020	1.4758072993202035e-10
R921_1021	921	1021	3.2807853278451862e+03
C921_1021	921	1021	2.6988013332818132e-10
R921_1023	921	1023	1.4103090777827813e+03
C921_1023	921	1023	6.2781896227457590e-10
R921_1024	921	1024	8.1722480774971018e+03
C921_1024	921	1024	1.0834457952127849e-10
R921_1033	921	1033	3.6206276618259549e+03
C921_1033	921	1033	2.4454842209692047e-10
R921_1036	921	1036	2.2833680574435161e+03
C921_1036	921	1036	3.8776875187232167e-10
R921_1037	921	1037	2.4074828790007164e+03
C921_1037	921	1037	3.6777781035249326e-10
R922_971	922	971	1.4924536859725038e+03
C922_971	922	971	5.9326382454745906e-10
R922_1033	922	1033	3.2048516891727390e+03
C922_1033	922	1033	2.7627449491385088e-10
R922_1034	922	1034	3.1486065858837524e+03
C922_1034	922	1034	2.8120972168121166e-10
R922_1036	922	1036	3.3827329114794852e+03
C922_1036	922	1036	2.6174658327155657e-10
R922_1037	922	1037	5.4904863884233782e+03
C922_1037	922	1037	1.6126417935702282e-10
R922_1038	922	1038	4.0676831612553256e+03
C922_1038	922	1038	2.1767152125652562e-10
R923_954	923	954	7.3829932870272196e-06
C923_954	923	954	1.1992680302930576e-11
R923_955	923	955	2.5768245764400324e-05
C923_955	923	955	3.4360848223639466e-12
R923_959	923	959	1.8529974482265404e-05
C923_959	923	959	4.7783054560998627e-12
R923_1013	923	1013	1.6567784252380535e-05
C923_1013	923	1013	5.3442196506921497e-12
R923_1035	923	1035	2.2010253490573534e-05
C923_1035	923	1035	4.0227559490816573e-12
R923_1039	923	1039	1.4771982208438617e-05
C923_1039	923	1039	5.9939063641316681e-12
R924_925	924	925	2.7925011238491684e+03
C924_925	924	925	3.1707016127518811e-10
R924_945	924	945	1.8093628560200586e+03
C924_945	924	945	4.8935390640636885e-10
R924_1027	924	1027	5.2726588681635558e+03
C924_1027	924	1027	1.6792643025821004e-10
R924_1029	924	1029	6.3209835319335607e+03
C924_1029	924	1029	1.4007610955270977e-10
R924_1031	924	1031	8.2308242518930820e+03
C924_1031	924	1031	1.0757352539708943e-10
R924_1032	924	1032	5.6981509382204385e+03
C924_1032	924	1032	1.5538703542600801e-10
R924_1040	924	1040	6.8294821277076726e+03
C924_1040	924	1040	1.2964654788505789e-10
R925_945	925	945	3.0578275535577272e+03
C925_945	925	945	2.8955811477002069e-10
R925_946	925	946	2.4829966750260905e+03
C925_946	925	946	3.5659281810786003e-10
R925_1028	925	1028	1.0109166988465721e+03
C925_1028	925	1028	8.7585731120104983e-10
R925_1029	925	1029	1.4567166546362353e+03
C925_1029	925	1029	6.0781812226970303e-10
R925_1040	925	1040	1.8293032991786642e+03
C925_1040	925	1040	4.8401967136753245e-10
R926_927	926	927	2.8788836238876397e+03
C926_927	926	927	3.0755629520874203e-10
R926_929	926	929	1.5582716323498537e+03
C926_929	926	929	5.6820567307947450e-10
R926_932	926	932	4.0735572772490505e+03
C926_932	926	932	2.1735763644348215e-10
R926_944	926	944	1.4635746481021633e+03
C926_944	926	944	6.0497001833704511e-10
R926_1028	926	1028	1.6750380912006769e+03
C926_1028	926	1028	5.2859620706614907e-10
R926_1030	926	1030	4.0735572772489891e+03
C926_1030	926	1030	2.1735763644348541e-10
R926_1041	926	1041	1.9566602860088135e+03
C926_1041	926	1041	4.5251533341338125e-10
R927_929	927	929	9.5818695969022531e+02
C927_929	927	929	9.2405638873049289e-10
R927_928	927	928	4.5685822822040655e+03
C927_928	927	928	1.9380602712332864e-10
R927_1030	927	1030	2.8711105475758300e+03
C927_1030	927	1030	3.0838895508484940e-10
R927_1041	927	1041	2.8186929804185424e+03
C927_1041	927	1041	3.1412388218617757e-10
R927_1042	927	1042	2.8955277961683546e+03
C927_1042	927	1042	3.0578838955428872e-10
R927_1043	927	1043	4.6078410847433033e+03
C927_1043	927	1043	1.9215479991956484e-10
R928_929	928	929	6.8344106420968374e+03
C928_929	928	929	1.2955305556944821e-10
R928_948	928	948	1.2239492366606772e+04
C928_948	928	948	7.2341135986628330e-11
R928_1043	928	1043	1.1569393044654445e+04
C928_1043	928	1043	7.6531135063226283e-11
R929_932	929	932	1.4968932204297844e+03
C929_932	929	932	5.9150430345711679e-10
R929_944	929	944	3.3936549803307666e+03
C929_944	929	944	2.6090418349295533e-10
R929_948	929	948	1.0099133942567315e+03
C929_948	929	948	8.7672743696170492e-10
R929_1041	929	1041	3.3105594725122996e+03
C929_1041	929	1041	2.6745291514973996e-10
R929_1042	929	1042	5.4679323708964148e+03
C929_1042	929	1042	1.6192935860229815e-10
R929_1043	929	1043	3.6063696786835330e+03
C929_1043	929	1043	2.4551525788759757e-10
R929_1044	929	1044	7.6856318668661117e+02
C929_1044	929	1044	1.1520442262101708e-09
R930_931	930	931	1.3805778320816883e+03
C930_931	930	931	6.4133927195175347e-10
R930_932	930	932	1.1863635810699154e+03
C930_932	930	932	7.4633004234797059e-10
R930_934	930	934	3.7935788890606268e+03
C930_934	930	934	2.3339933281821092e-10
R930_942	930	942	2.7780713854759974e+03
C930_942	930	942	3.1871707340892958e-10
R930_1045	930	1045	6.1656607169441622e+03
C930_1045	930	1045	1.4360484988522582e-10
R931_932	931	932	3.7836227836558114e+03
C931_932	931	932	2.3401349244558966e-10
R931_934	931	934	8.6476434378462491e+03
C931_934	931	934	1.0238844698718515e-10
R931_948	931	948	5.7943022267193073e+03
C931_948	931	948	1.5280852586823347e-10
R931_1045	931	1045	5.3997749779071728e+03
C931_1045	931	1045	1.6397327394616134e-10
R932_933	932	933	9.4168195297991861e+02
C932_933	932	933	9.4025246942253071e-10
R932_942	932	942	1.9149340956917595e+03
C932_942	932	942	4.6237558968322995e-10
R932_944	932	944	2.0148419316394632e+03
C932_944	932	944	4.3944826033054641e-10
R932_948	932	948	3.1281796642336426e+03
C932_948	932	948	2.8304601293318440e-10
R932_1044	932	1044	2.7386816289057660e+03
C932_1044	932	1044	3.2330109946141014e-10
R932_1045	932	1045	2.6958471466078931e+03
C932_1045	932	1045	3.2843805065658004e-10
R932_1046	932	1046	2.4585503602952572e+03
C932_1046	932	1046	3.6013855807032014e-10
R933_942	933	942	1.0520155271152501e+03
C933_942	933	942	8.4164041202692334e-10
R933_944	933	944	1.1485069895662250e+03
C933_944	933	944	7.7093025096382767e-10
R933_946	933	946	3.1511594542391708e+03
C933_946	933	946	2.8098190350503198e-10
R933_1000	933	1000	1.4371685991743004e+03
C933_1000	933	1000	6.1608553248985648e-10
R933_1046	933	1046	1.6945167841757857e+03
C933_1046	933	1046	5.2251992424534674e-10
R934_935	934	935	9.4888228356926663e+02
C934_935	934	935	9.3311762378938565e-10
R934_939	934	939	3.9712311501978784e+03
C934_939	934	939	2.2295825858836782e-10
R934_942	934	942	3.0349760544587393e+03
C934_942	934	942	2.9173830890666005e-10
R934_1045	934	1045	3.0103168402973174e+03
C934_1045	934	1045	2.9412810301142605e-10
R934_1047	934	1047	5.7425800143791539e+03
C934_1047	934	1047	1.5418484017339808e-10
R935_939	935	939	4.1349684125116873e+03
C935_939	935	939	2.1412951523907138e-10
R935_940	935	940	1.4153491188826126e+03
C935_940	935	940	6.2558330654066418e-10
R935_942	935	942	9.1977046311173535e+02
C935_942	935	942	9.6265189763159203e-10
R935_943	935	943	1.5959437995754949e+03
C935_943	935	943	5.5479320884326436e-10
R935_1045	935	1045	4.9167034768053272e+03
C935_1045	935	1045	1.8008382768596592e-10
R935_1047	935	1047	2.0846770498266292e+03
C935_1047	935	1047	4.2472707308483854e-10
R935_1048	935	1048	2.6573280902448482e+03
C935_1048	935	1048	3.3319889438959606e-10
R936_938	936	938	3.5828404826436563e+03
C936_938	936	938	2.4712760336086178e-10
R936_941	936	941	7.0093302081391521e+03
C936_941	936	941	1.2632002707931525e-10
R936_952	936	952	5.1332732391449690e+03
C936_952	936	952	1.7248619749052771e-10
R936_1050	936	1050	4.5154828330331902e+03
C936_1050	936	1050	1.9608507316707853e-10
R936_1015	936	1015	1.3854308185469352e+04
C936_1015	936	1015	6.3909274273878451e-11
R937_938	937	938	1.2377356171493391e+03
C937_938	937	938	7.1535372290508296e-10
R937_939	937	939	3.3895702833086975e+03
C937_939	937	939	2.6121859341878191e-10
R937_940	937	940	8.9528172364380328e+02
C937_940	937	940	9.8898342087933948e-10
R937_951	937	951	1.1317516755953714e+03
C937_951	937	951	7.8234368969165882e-10
R937_999	937	999	1.2680825432304980e+03
C937_999	937	999	6.9823434320320778e-10
R937_1014	937	1014	3.2915990120428155e+03
C937_1014	937	1014	2.6899351301922282e-10
R937_1048	937	1048	3.4540728427305894e+03
C937_1048	937	1048	2.5634050641504117e-10
R937_1049	937	1049	1.0796507517867733e+03
C937_1049	937	1049	8.2009740671663677e-10
R937_1051	937	1051	3.0957280049026772e+03
C937_1051	937	1051	2.8601310589876441e-10
R938_939	938	939	5.8318045277321662e+03
C938_939	938	939	1.5182586753200313e-10
R938_941	938	941	1.4346475425952212e+03
C938_941	938	941	6.1716815831874075e-10
R938_952	938	952	4.9394194269974832e+03
C938_952	938	952	1.7925563819515893e-10
R938_1014	938	1014	2.6903434852382798e+03
C938_1014	938	1014	3.2910993951450020e-10
R938_1049	938	1049	4.3214712627559184e+03
C938_1049	938	1049	2.0488827250359744e-10
R938_1050	938	1050	3.1501231158836067e+03
C938_1050	938	1050	2.8107434189969451e-10
R938_1051	938	1051	4.8772198299233560e+03
C938_1051	938	1051	1.8154170051299782e-10
R939_940	939	940	3.4839591712042479e+03
C939_940	939	940	2.5414154936665070e-10
R939_941	939	941	9.9866222545964138e+03
C939_941	939	941	8.8660485910787269e-11
R939_1047	939	1047	6.8142694456795762e+03
C939_1047	939	1047	1.2993598048304044e-10
R939_1051	939	1051	4.7948834317578212e+03
C939_1051	939	1051	1.8465908385501718e-10
R940_943	940	943	9.1954973910846320e+02
C940_943	940	943	9.6288296765593753e-10
R940_999	940	999	3.4686774942166144e+03
C940_999	940	999	2.5526120060924486e-10
R940_1047	940	1047	3.6410938867932928e+03
C940_1047	940	1047	2.4317383984838342e-10
R940_1048	940	1048	1.1007871982588363e+03
C940_1048	940	1048	8.0435054395663953e-10
R940_1051	940	1051	4.7517466979642877e+03
C940_1051	940	1051	1.8633543367943529e-10
R941_1050	941	1050	8.2054430421888374e+03
C941_1050	941	1050	1.0790627357323183e-10
R941_1051	941	1051	9.0661302567602706e+03
C941_1051	941	1051	9.7662261254163762e-11
R942_943	942	943	1.4622175014243994e+03
C942_943	942	943	6.0553151691693017e-10
R942_1000	942	1000	2.8794442333164930e+03
C942_1000	942	1000	3.0749641595947510e-10
R942_1045	942	1045	1.9492591295041773e+03
C942_1045	942	1045	4.5423349225262801e-10
R942_1046	942	1046	1.0607515353405411e+03
C942_1046	942	1046	8.3470893248883901e-10
R942_1048	942	1048	3.1710356704159772e+03
C942_1048	942	1048	2.7922069434931666e-10
R942_1053	942	1053	4.0819411911117750e+03
C942_1053	942	1053	2.1691120480323324e-10
R943_999	943	999	2.0343890577840409e+03
C943_999	943	999	4.3522588676545621e-10
R943_1000	943	1000	4.5649447768244181e+03
C943_1000	943	1000	1.9396045844741575e-10
R943_1048	943	1048	2.0927946039970620e+03
C943_1048	943	1048	4.2307963715546887e-10
R943_1053	943	1053	3.7193115013605998e+03
C943_1053	943	1053	2.3805986171798087e-10
R944_946	944	946	1.2086161309681020e+03
C944_946	944	946	7.3258891637560650e-10
R944_1000	944	1000	2.8932554797382722e+03
C944_1000	944	1000	3.0602855084891993e-10
R944_1028	944	1028	1.7007464499601440e+03
C944_1028	944	1028	5.2060598551932852e-10
R944_1040	944	1040	4.6909574323201523e+03
C944_1040	944	1040	1.8875012073219155e-10
R944_1041	944	1041	1.0837536686569445e+03
C944_1041	944	1041	8.1699264999699289e-10
R944_1044	944	1044	2.3868467886871954e+03
C944_1044	944	1044	3.7095752684946937e-10
R944_1046	944	1046	1.0416766674494004e+03
C944_1046	944	1046	8.4999386985214328e-10
R944_1052	944	1052	1.9816681917342860e+03
C944_1052	944	1052	4.4680476045039246e-10
R944_1055	944	1055	2.3301748517127612e+03
C944_1055	944	1055	3.7997954576206413e-10
R945_946	945	946	2.3480527087004625e+03
C945_946	945	946	3.7708641650980577e-10
R945_947	945	947	1.4204713542504517e+03
C945_947	945	947	6.2332744623858618e-10
R945_1031	945	1031	1.6683140040726228e+03
C945_1031	945	1031	5.3072669745536545e-10
R945_1040	945	1040	3.8250718854454049e+03
C945_1040	945	1040	2.3147768413688225e-10
R945_1055	945	1055	6.2765530368600894e+03
C945_1055	945	1055	1.4106768101858342e-10
R946_947	946	947	4.8600760094163297e+03
C946_947	946	947	1.8218208521523397e-10
R946_1000	946	1000	3.0210413959582474e+03
C946_1000	946	1000	2.9308396200216684e-10
R946_1028	946	1028	2.0691431119776439e+03
C946_1028	946	1028	4.2791567996170908e-10
R946_1040	946	1040	3.2021191468194179e+03
C946_1040	946	1040	2.7651025496020776e-10
R946_1055	946	1055	3.3518754966701695e+03
C946_1055	946	1055	2.6415622614252697e-10
R947_1000	947	1000	1.8683356797110412e+03
C947_1000	947	1000	4.7390776256916520e-10
R947_1001	947	1001	2.5084318198809892e+03
C947_1001	947	1001	3.5297701722744374e-10
R947_1007	947	1007	1.2458613001008450e+03
C947_1007	947	1007	7.1068808512499010e-10
R947_1031	947	1031	3.1746251676163611e+03
C947_1031	947	1031	2.7890498403778765e-10
R947_1055	947	1055	3.0721579908138888e+03
C947_1055	947	1055	2.8820743736080814e-10
R948_1043	948	1043	4.9874906796078703e+03
C948_1043	948	1043	1.7752790703352534e-10
R948_1044	948	1044	1.8066752600833845e+03
C948_1044	948	1044	4.9008186543669983e-10
R948_1045	948	1045	5.0346001768208707e+03
C948_1045	948	1045	1.7586675219542521e-10
R948_1057	948	1057	7.0538481181272828e+03
C948_1057	948	1057	1.2552280214605311e-10
R949_950	949	950	1.1677122617483310e+03
C949_950	949	950	7.5825082146035405e-10
R949_951	949	951	3.4798584630770879e+03
C949_951	949	951	2.5444103290254584e-10
R949_953	949	953	2.7317566923271656e+03
C949_953	949	953	3.2412065986217740e-10
R949_996	949	996	2.3921595088330314e+03
C949_996	949	996	3.7013367145066940e-10
R949_997	949	997	1.2048359069173280e+03
C949_997	949	997	7.3488744534964679e-10
R949_999	949	999	3.4681033543644421e+03
C949_999	949	999	2.5530345875815462e-10
R949_1002	949	1002	3.4963438241050394e+03
C949_1002	949	1002	2.5324133616253860e-10
R949_1058	949	1058	1.5790643822310083e+03
C949_1058	949	1058	5.6072367388150502e-10
R950_999	950	999	5.1410239727812150e+03
C950_999	950	999	1.7222615307529916e-10
R950_1001	950	1001	1.4582183831204636e+03
C950_1001	950	1001	6.0719216816158840e-10
R950_1002	950	1002	1.5854373067150982e+03
C950_1002	950	1002	5.5846975339221595e-10
R950_1058	950	1058	5.0932483710594424e+03
C950_1058	950	1058	1.7384166590639382e-10
R951_953	951	953	1.5853255894406993e+03
C951_953	951	953	5.5850910853736635e-10
R951_999	951	999	1.8895721389178277e+03
C951_999	951	999	4.6858162409564638e-10
R951_1014	951	1014	1.5787371707358752e+03
C951_1014	951	1014	5.6083989033291199e-10
R951_1049	951	1049	2.6115146728513300e+03
C951_1049	951	1049	3.3904415353457432e-10
R951_1058	951	1058	5.0545953876100675e+03
C951_1058	951	1058	1.7517105006473066e-10
R951_1059	951	1059	1.2694832784360185e+03
C951_1059	951	1059	6.9746391838325014e-10
R952_1014	952	1014	3.1413703376283579e+03
C952_1014	952	1014	2.8185749737755051e-10
R952_1008	952	1008	6.8843510503663119e+03
C952_1008	952	1008	1.2861325275573904e-10
R952_1019	952	1019	7.7732843369312895e+03
C952_1019	952	1019	1.1390536397765975e-10
R952_1050	952	1050	5.9665382246106647e+03
C952_1050	952	1050	1.4839740371524664e-10
R952_1015	952	1015	6.3699177577706587e+03
C952_1015	952	1015	1.3900003349648874e-10
R952_1060	952	1060	3.6682351159042096e+03
C952_1060	952	1060	2.4137459942551876e-10
R952_1062	952	1062	1.0427569316619634e+04
C952_1062	952	1062	8.4911330226192292e-11
R953_997	953	997	1.4674946590787038e+03
C953_997	953	997	6.0335400624617452e-10
R953_1008	953	1008	1.1000723490505809e+03
C953_1008	953	1008	8.0487322716925110e-10
R953_1009	953	1009	5.4437035383869088e+03
C953_1009	953	1009	1.6265007369640290e-10
R953_1014	953	1014	3.3701625434309676e+03
C953_1014	953	1014	2.6272287175757591e-10
R953_1058	953	1058	2.4435883666198483e+03
C953_1058	953	1058	3.6234367203375441e-10
R953_1059	953	1059	3.7165567811520791e+03
C953_1059	953	1059	2.3823631222056377e-10
R953_1061	953	1061	1.9169516104618208e+03
C953_1061	953	1061	4.6188895789951107e-10
R953_1063	953	1063	2.5538331455806970e+03
C953_1063	953	1063	3.4670189132449028e-10
R954_955	954	955	2.5342097806964505e-06
C954_955	954	955	2.0963192266126298e-10
R954_956	954	956	1.3394151784811036e+03
C954_956	954	956	6.6104878899764641e-10
R954_959	954	959	4.2969611814587016e-06
C954_959	954	959	2.0605696544817852e-11
R954_971	954	971	3.4500139373399657e+03
C954_971	954	971	2.5664208834549713e-10
R954_1012	954	1012	1.4688679413551710e-06
C954_1012	954	1012	6.0278991512546508e-11
R954_1013	954	1013	1.4210517098834205e-06
C954_1013	954	1013	6.2307288013652759e-11
R954_1034	954	1034	5.9462963585176121e+03
C954_1034	954	1034	1.4890256528026991e-10
R954_1035	954	1035	2.6887342524070226e-06
C954_1035	954	1035	3.6223760604980766e-10
R954_1039	954	1039	3.7793020908169651e-06
C954_1039	954	1039	2.3428102872522705e-11
R954_1064	954	1064	2.2359970689717465e-06
C954_1064	954	1064	3.3658629267642175e-10
R954_1065	954	1065	6.8233429099672321e-06
C954_1065	954	1065	2.0762111288963463e-10
R955_956	955	956	1.3778949059795057e+03
C955_956	955	956	6.4258803618305096e-10
R955_957	955	957	1.0664857973042662e-05
C955_957	955	957	9.1324297178443389e-11
R955_959	955	959	2.7773067665905004e-06
C955_959	955	959	3.1880481924111146e-11
R955_1012	955	1012	1.9521059914045609e-06
C955_1012	955	1012	4.5357105894794771e-11
R955_958	955	958	1.4830818133593267e-05
C955_958	955	958	5.9701277011444100e-12
R955_1065	955	1065	1.0185631490498461e-05
C955_1065	955	1065	9.5621038303279135e-11
R956_957	956	957	8.2844985221688075e+03
C956_957	956	957	1.0687656945446656e-10
R956_971	956	971	1.3664194517377684e+03
C956_971	956	971	6.4798461451493018e-10
R956_983	956	983	3.1511574444225375e+03
C956_983	956	983	2.8098208271604041e-10
R956_1065	956	1065	3.1616962337764512e+03
C956_1065	956	1065	2.8004549337822434e-10
R957_983	957	983	4.9068827516092624e+03
C957_983	957	983	1.8044425076381088e-10
R957_984	957	984	3.0228142653274456e-06
C957_984	957	984	2.4897525875577398e-10
R957_958	957	958	1.8290449944613237e-06
C957_958	957	958	4.8408802647349134e-11
R957_985	957	985	5.3053413374497586e+03
C957_985	957	985	1.6689195385977084e-10
R957_1012	957	1012	5.2058111445361430e-06
C957_1012	957	1012	1.7008277041116022e-11
R957_1065	957	1065	6.4051673360448870e-06
C957_1065	957	1065	1.9813693936394802e-10
R957_1066	957	1066	6.0535668170597041e-06
C957_1066	957	1066	1.4626398096487178e-11
R958_984	958	984	9.4623342254857818e-06
C958_984	958	984	9.3572976878709210e-12
R958_986	958	986	1.3567748169444225e-05
C958_986	958	986	6.5259081362819048e-12
R958_1012	958	1012	1.0152628570575451e-05
C958_1012	958	1012	8.7210792313050649e-12
R958_959	958	959	1.8263518102089786e-05
C958_959	958	959	4.8480187483630918e-12
R958_1066	958	1066	8.2388699402105307e-06
C958_1066	958	1066	1.0746847421132789e-11
R959_1012	959	1012	3.0810603022595248e-06
C959_1012	959	1012	2.8737470053756163e-11
R959_1013	959	1013	6.1327280451750789e-06
C959_1013	959	1013	1.4437600610654880e-11
R959_1066	959	1066	1.6779942384683947e-05
C959_1066	959	1066	5.2766497131013663e-12
R960_961	960	961	5.3561281585054239e+03
C960_961	960	961	1.6530948392151013e-10
R960_968	960	968	4.5289723511153134e+03
C960_968	960	968	1.9550103490518221e-10
R960_974	960	974	4.4947523198147537e+03
C960_974	960	974	1.9698944873930043e-10
R960_970	960	970	6.2131422674563073e+03
C960_970	960	970	1.4250740504329303e-10
R960_994	960	994	4.2559266710926013e+03
C960_994	960	994	2.0804371177586369e-10
R960_995	960	995	1.2119011248385957e+03
C960_995	960	995	7.3060315198397275e-10
R960_996	960	996	3.9785550177877435e+03
C960_996	960	996	2.2254782898348175e-10
R960_998	960	998	3.0894254667802866e+03
C960_998	960	998	2.8659658283414064e-10
R960_1067	960	1067	2.1199849622816942e+03
C960_1067	960	1067	4.1765333125148347e-10
R961_962	961	962	2.0354397417028795e+03
C961_962	961	962	4.3500122531716186e-10
R961_968	961	968	2.0707213827581668e+03
C961_968	961	968	4.2758952946177466e-10
R961_998	961	998	1.5511288465713740e+03
C961_998	961	998	5.7082220065543618e-10
R961_1009	961	1009	1.6521857421878506e+03
C961_1009	961	1009	5.3590753090963875e-10
R961_1011	961	1011	1.9867133784097434e+03
C961_1011	961	1011	4.4567011594230561e-10
R961_1016	961	1016	5.7047766422340719e+03
C961_1016	961	1016	1.5520656411768953e-10
R961_1018	961	1018	6.9623347476200242e+03
C961_1018	961	1018	1.2717268183674567e-10
R961_1068	961	1068	5.4366192824675845e+03
C961_1068	961	1068	1.6286201694412639e-10
R962_968	962	968	1.0464614149335101e+04
C962_968	962	968	8.4610743316919881e-11
R962_969	962	969	6.1735084738671676e+03
C962_969	962	969	1.4342229956402121e-10
R962_978	962	978	1.0806539398807714e+04
C962_978	962	978	8.1933609736127767e-11
R962_1016	962	1016	5.2716965249941486e+03
C962_1016	962	1016	1.6795708506778717e-10
R962_1017	962	1017	6.6382504479876670e+03
C962_1017	962	1017	1.3338134628054109e-10
R962_1018	962	1018	1.1233806523420826e+04
C962_1018	962	1018	7.8817342977559110e-11
R962_1068	962	1068	1.2071119123222319e+04
C962_1068	962	1068	7.3350181757103104e-11
R963_964	963	964	2.7096338538091545e+03
C963_964	963	964	3.2676694692727369e-10
R963_973	963	973	5.2999622366346894e+03
C963_973	963	973	1.6706133782987356e-10
R963_984	963	984	9.5356282539591757e+03
C963_984	963	984	9.2853743677809129e-11
R963_985	963	985	2.8530107417764425e+03
C963_985	963	985	3.1034540765475322e-10
R963_989	963	989	4.8959433300958308e+03
C963_989	963	989	1.8084743266067773e-10
R963_990	963	990	9.5321007104073033e+03
C963_990	963	990	9.2888106053399673e-11
R963_992	963	992	2.0487624031867122e+03
C963_992	963	992	4.3217250586148525e-10
R963_1070	963	1070	5.4393174031950766e+03
C963_1070	963	1070	1.6278123081765767e-10
R964_965	964	965	4.2133857279007107e+03
C964_965	964	965	2.1014424951336077e-10
R964_973	964	973	2.2230909566375149e+03
C964_973	964	973	3.9828275089527597e-10
R964_975	964	975	1.4650696366808354e+03
C964_975	964	975	6.0435269391422660e-10
R964_976	964	976	3.1357378318069846e+03
C964_976	964	976	2.8236377822114451e-10
R964_989	964	989	1.9527094427354639e+03
C964_989	964	989	4.5343089059868333e-10
R964_1070	964	1070	4.2395457461916130e+03
C964_1070	964	1070	2.0884755931584708e-10
R965_966	965	966	2.4116590505056297e+03
C965_966	965	966	3.6714094453540714e-10
R965_967	965	967	1.9421023638845718e+03
C965_967	965	967	4.5590737036589316e-10
R965_970	965	970	2.9121497204038983e+03
C965_970	965	970	3.0404301519813267e-10
R965_972	965	972	4.1642880973707861e+03
C965_972	965	972	2.1262188422050537e-10
R965_973	965	973	3.7359407072273038e+03
C965_973	965	973	2.3700022326026947e-10
R965_975	965	975	2.9060405955182100e+03
C965_975	965	975	3.0468217927358681e-10
R965_1071	965	1071	4.0301723420364592e+03
C965_1071	965	1071	2.1969749840836714e-10
R966_967	966	967	3.3030464592951334e+03
C966_967	966	967	2.6806125575628370e-10
R966_972	966	972	2.3236513065464601e+03
C966_972	966	972	3.8104632102307930e-10
R966_1004	966	1004	4.7444136121772253e+03
C966_1004	966	1004	1.8662343844293935e-10
R966_1020	966	1020	1.6673696232825687e+03
C966_1020	966	1020	5.3102729552962971e-10
R966_1021	966	1021	3.6036840888532156e+03
C966_1021	966	1021	2.4569822433624111e-10
R966_1036	966	1036	3.7562653437903773e+03
C966_1036	966	1036	2.3571784755933683e-10
R966_1071	966	1071	2.1183551838902263e+03
C966_1071	966	1071	4.1797465714601464e-10
R967_970	967	970	1.2685435451143064e+03
C967_970	967	970	6.9798059759960095e-10
R967_994	967	994	1.8409661900056465e+03
C967_994	967	994	4.8095330946696217e-10
R967_1004	967	1004	1.6881611589337933e+03
C967_1004	967	1004	5.2448711843317827e-10
R967_1071	967	1071	2.6347453563460140e+03
C967_1071	967	1071	3.3605478402965646e-10
R968_969	968	969	7.4911653641714702e+02
C968_969	968	969	1.1819506560818370e-09
R968_974	968	974	1.2790607753828083e+03
C968_974	968	974	6.9224136862066183e-10
R968_998	968	998	3.8547695287674028e+03
C968_998	968	998	2.2969435010116435e-10
R968_1011	968	1011	1.6538795224521511e+03
C968_1011	968	1011	5.3535869431844689e-10
R968_1016	968	1016	1.9508817352403946e+03
C968_1016	968	1016	4.5385569289308849e-10
R968_1067	968	1067	1.9126255641308317e+03
C968_1067	968	1067	4.6293367520807320e-10
R968_1072	968	1072	1.3870587362681738e+03
C968_1072	968	1072	6.3834267327581534e-10
R969_974	969	974	3.4063762072193545e+03
C969_974	969	974	2.5992982801590573e-10
R969_978	969	978	3.2050350932051483e+03
C969_978	969	978	2.7625868545936883e-10
R969_1010	969	1010	8.6271720642946138e+02
C969_1010	969	1010	1.0263140402223968e-09
R969_1016	969	1016	1.4153782782296587e+03
C969_1016	969	1016	6.2557041839547884e-10
R969_1072	969	1072	3.5688438123471374e+03
C969_1072	969	1072	2.4809681461450192e-10
R970_974	970	974	1.5452558696251383e+03
C970_974	970	974	5.7299169613560039e-10
R970_975	970	975	1.9307481870404372e+03
C970_975	970	975	4.5858843097360161e-10
R970_994	970	994	1.2351940816271988e+03
C970_994	970	994	7.1682563482945323e-10
R970_1067	970	1067	4.7995795602712633e+03
C970_1067	970	1067	1.8447840494802798e-10
R970_1071	970	1071	3.6034063073276998e+03
C970_1071	970	1071	2.4571716486688119e-10
R970_1073	970	1073	1.7417848273184475e+03
C970_1073	970	1073	5.0833993258693170e-10
R971_972	971	972	2.0675789316494997e+03
C971_972	971	972	4.2823940994292265e-10
R971_983	971	983	1.5558420448526731e+03
C971_983	971	983	5.6909297741972432e-10
R971_1034	971	1034	2.7702757083128222e+03
C971_1034	971	1034	3.1961395721122845e-10
R971_1036	971	1036	2.8215262025289535e+03
C971_1036	971	1036	3.1380845618459726e-10
R971_1038	971	1038	3.0210274182800335e+03
C971_1038	971	1038	2.9308531804193187e-10
R971_1064	971	1064	3.3619248089624671e+03
C971_1064	971	1064	2.6336662240023498e-10
R971_1065	971	1065	3.6001858535805736e+03
C971_1065	971	1065	2.4593696484291350e-10
R971_1074	971	1074	2.7209024447175348e+03
C971_1074	971	1074	3.2541364480706997e-10
R972_973	972	973	1.6571689705992255e+03
C972_973	972	973	5.3429601773187692e-10
R972_983	972	983	2.8303418071635774e+03
C972_983	972	983	3.1283104374850086e-10
R972_1036	972	1036	2.1824404534085884e+03
C972_1036	972	1036	4.0570123245155742e-10
R972_1071	972	1071	8.3923494582510903e+03
C972_1071	972	1071	1.0550308779497791e-10
R972_1074	972	1074	5.0510797749066123e+03
C972_1074	972	1074	1.7529297123729755e-10
R972_1075	972	1075	5.5619145897585558e+03
C972_1075	972	1075	1.5919316404648999e-10
R973_975	973	975	4.5009770582222436e+03
C973_975	973	975	1.9671701727129332e-10
R973_983	973	983	4.3981452267236373e+03
C973_983	973	983	2.0131640408781717e-10
R973_985	973	985	2.0378306102924062e+03
C973_985	973	985	4.3449086358210716e-10
R973_1070	973	1070	1.2057761606636761e+03
C973_1070	973	1070	7.3431438652150269e-10
R973_1071	973	1071	7.6194048026601449e+03
C973_1071	973	1071	1.1620576733117997e-10
R973_1074	973	1074	4.6735473603798919e+03
C973_1074	973	1074	1.8945325968153417e-10
R973_1075	973	1075	4.7773692432218295e+03
C973_1075	973	1075	1.8533605769665794e-10
R974_975	974	975	4.2393783977515150e+03
C974_975	974	975	2.0885580352289605e-10
R974_976	974	976	2.3532357631224686e+03
C974_976	974	976	3.7625587524012167e-10
R974_1010	974	1010	5.0681099366300868e+03
C974_1010	974	1010	1.7470394146357789e-10
R974_1067	974	1067	6.3249782079610850e+03
C974_1067	974	1067	1.3998764147290603e-10
R974_1072	974	1072	4.2825348424977356e+03
C974_1072	974	1072	2.0675109818454863e-10
R974_1073	974	1073	4.5678968496849684e+03
C974_1073	974	1073	1.9383510854914863e-10
R974_1076	974	1076	6.3269163324488936e+03
C974_1076	974	1076	1.3994475905409836e-10
R975_976	975	976	2.1479381457083223e+03
C975_976	975	976	4.1221800705439637e-10
R975_989	975	989	3.7495073631076666e+03
C975_989	975	989	2.3614269714785876e-10
R975_1070	975	1070	2.9048175975763625e+03
C975_1070	975	1070	3.0481045778528407e-10
R975_1071	975	1071	3.7749939982770134e+03
C975_1071	975	1071	2.3454839454158712e-10
R975_1073	975	1073	3.4806093952534607e+03
C975_1073	975	1073	2.5438613792959759e-10
R975_1076	975	1076	1.6478861537560140e+03
C975_1076	975	1076	5.3730579608419686e-10
R976_977	976	977	2.6057674105037709e+03
C976_977	976	977	3.3979194694465178e-10
R976_989	976	989	2.1585142408723536e+03
C976_989	976	989	4.1019825810468685e-10
R976_1010	976	1010	4.0854086209113084e+03
C976_1010	976	1010	2.1672710464455197e-10
R976_1076	976	1076	7.6241959608423531e+03
C976_1076	976	1076	1.1613274189796340e-10
R977_978	977	978	7.5173508843096761e+03
C977_978	977	978	1.1778335151922454e-10
R977_979	977	979	2.7581085825382347e+03
C977_979	977	979	3.2102390286794504e-10
R977_989	977	989	1.9720449756561638e+03
C977_989	977	989	4.4898508534542539e-10
R977_1010	977	1010	2.0001800623757069e+03
C977_1010	977	1010	4.4266953678577663e-10
R977_1079	977	1079	8.8332544388737369e+03
C977_1079	977	1079	1.0023698375577341e-10
R978_979	978	979	9.5853608118185584e+03
C978_979	978	979	9.2371982555763196e-11
R978_981	978	981	1.6811560742057260e+04
C978_981	978	981	5.2667256495999186e-11
R978_1010	978	1010	7.5304094655565532e+03
C978_1010	978	1010	1.1757910187352089e-10
R978_1016	978	1016	1.3274153436720095e+04
C978_1016	978	1016	6.6702467010112990e-11
R978_1017	978	1017	1.5863378133609005e+04
C978_1017	978	1017	5.5815273029652137e-11
R978_1081	978	1081	1.4842680369381671e+04
C978_1081	978	1081	5.9653563889073049e-11
R979_981	979	981	2.6661418182173961e+03
C979_981	979	981	3.3209740594069310e-10
R979_980	979	980	4.8261718713615655e+03
C979_980	979	980	1.8346192495838418e-10
R979_989	979	989	4.0386515825253914e+03
C979_989	979	989	2.1923623853344213e-10
R979_991	979	991	2.2981735737095200e+03
C979_991	979	991	3.8527063048194010e-10
R979_993	979	993	2.8972610753753420e+03
C979_993	979	993	3.0560545241346378e-10
R979_1010	979	1010	2.7306887781920759e+03
C979_1010	979	1010	3.2424741653870013e-10
R979_1079	979	1079	8.6364745748167581e+02
C979_1079	979	1079	1.0252085779095648e-09
R979_1080	979	1080	2.6774280548635647e+03
C979_1080	979	1080	3.3069750654611664e-10
R979_1081	979	1081	2.1143626033592623e+03
C979_1081	979	1081	4.1876392454788130e-10
R979_1082	979	1082	6.0839901256510902e+03
C979_1082	979	1082	1.4553258033193228e-10
R980_981	980	981	6.4794842135000390e+03
C980_981	980	981	1.3664957773262652e-10
R980_982	980	982	2.7631481824904354e-06
C980_982	980	982	3.2043839968870900e-11
R980_988	980	988	5.4715896765402847e-06
C980_988	980	988	1.6182112220444406e-11
R980_991	980	991	5.0450413955604414e-06
C980_991	980	991	1.9305305596761001e-10
R980_1080	980	1080	5.4109110491433873e-06
C980_1080	980	1080	1.7999938458611863e-10
R980_1084	980	1084	1.6917233753432379e-05
C980_1084	980	1084	5.7572099144071357e-11
R981_1080	981	1080	7.2787247274077772e+03
C981_1080	981	1080	1.2164476812345815e-10
R981_1081	981	1081	2.1426115390833179e+03
C981_1081	981	1081	4.1324279532201733e-10
R981_1017	981	1017	1.0650759477079779e+04
C981_1017	981	1017	8.3131985433095513e-11
R981_1083	981	1083	8.1890656453776464e+03
C981_1083	981	1083	1.0812207644223471e-10
R981_1084	981	1084	6.2240339010050438e+03
C981_1084	981	1084	1.4225802683321256e-10
R982_988	982	988	8.2771437215491294e-06
C982_988	982	988	1.0697153649692666e-11
R982_1080	982	1080	1.1195936826815158e-05
C982_1080	982	1080	7.9083938699917617e-12
R982_1084	982	1084	1.5344606632389305e-05
C982_1084	982	1084	5.7702279563886848e-12
R982_1085	982	1085	3.0895181139038876e-05
C982_1085	982	1085	2.8658798850063799e-12
R982_1086	982	1086	1.0437541513580206e-05
C982_1086	982	1086	8.4830204559952013e-12
R983_985	983	985	3.0379915164881199e+03
C983_985	983	985	2.9144873410427859e-10
R983_1065	983	1065	2.9824810612590168e+03
C983_1065	983	1065	2.9687322853484667e-10
R983_1074	983	1074	3.0244866085679332e+03
C983_1074	983	1074	2.9275010813132281e-10
R983_1088	983	1088	1.4357052799030198e+04
C983_1088	983	1088	6.1671346765529000e-11
R984_985	984	985	1.1667584194646720e+03
C984_985	984	985	7.5887070273402869e-10
R984_986	984	986	1.3078491255417805e-06
C984_986	984	986	6.7700376473716921e-11
R984_990	984	990	6.9334418412202870e-06
C984_990	984	990	9.7905352213638812e-11
R984_992	984	992	2.9072475147630230e+03
C984_992	984	992	3.0455569304087027e-10
R984_1065	984	1065	1.0224732333356211e-05
C984_1065	984	1065	9.5255369738988772e-11
R984_1066	984	1066	4.1480668581967225e-06
C984_1066	984	1066	2.1345335356646483e-11
R984_1078	984	1078	4.9967193457053982e-06
C984_1078	984	1078	1.7720002274312316e-11
R984_1088	984	1088	4.2595991465456128e-06
C984_1088	984	1088	1.5936266351916070e-10
R984_1089	984	1089	4.3914867037001786e-06
C984_1089	984	1089	2.2178381140842337e-10
R985_992	985	992	3.6856584358902892e+03
C985_992	985	992	2.4023354228323191e-10
R985_1065	985	1065	7.3027702829259397e+03
C985_1065	985	1065	1.2124423299609074e-10
R985_1070	985	1070	2.3353226886756356e+03
C985_1070	985	1070	3.7914194299294972e-10
R985_1074	985	1074	6.6788206744847885e+03
C985_1074	985	1074	1.3257112667848389e-10
R985_1088	985	1088	3.2902043196709565e+03
C985_1088	985	1088	2.6910753730593485e-10
R985_1089	985	1089	5.8751131901864437e+03
C985_1089	985	1089	1.5070667628650433e-10
R986_987	986	987	1.2187568625653804e-05
C986_987	986	987	7.2649337115219853e-12
R986_990	986	990	6.7190846713942732e-06
C986_990	986	990	1.3177669652974729e-11
R986_1066	986	1066	1.2412390169450897e-05
C986_1066	986	1066	7.1333463548315886e-12
R986_1077	986	1077	5.0897369096464849e-06
C986_1077	986	1077	1.7396160104501319e-11
R986_1078	986	1078	5.1917360026996608e-06
C986_1078	986	1078	1.7054387612151107e-11
R986_1089	986	1089	6.2608458644672824e-06
C986_1089	986	1089	1.4142159076700695e-11
R987_990	987	990	1.6545887779906718e-06
C987_990	987	990	5.3512920761813114e-11
R987_991	987	991	7.5987540088723830e-06
C987_991	987	991	1.1652157454579737e-11
R987_988	987	988	9.6685558025854976e-06
C987_988	987	988	9.1577149656955758e-12
R987_1077	987	1077	7.5856253755024575e-06
C987_1077	987	1077	1.1672324137696447e-11
R987_1087	987	1087	1.5180786728763873e-05
C987_1087	987	1087	5.8324960196058112e-12
R987_1090	987	1090	5.8740694532507940e-06
C987_1090	987	1090	1.5073345467680785e-11
R988_991	988	991	2.6285330254068995e-06
C988_991	988	991	3.3684902306408578e-11
R988_1080	988	1080	8.4835494762939819e-06
C988_1080	988	1080	1.0436890645527218e-11
R988_1086	988	1086	9.6765416995161575e-06
C988_1086	988	1086	9.1501572482684855e-12
R988_1090	988	1090	7.7813056674649625e-06
C988_1090	988	1090	1.1378794504913168e-11
R988_1087	988	1087	1.8621785733204717e-05
C988_1087	988	1087	4.7547469098046800e-12
R989_992	989	992	4.7300929465372565e+03
C989_992	989	992	1.8718845310390485e-10
R989_993	989	993	5.7283095178594604e+03
C989_993	989	993	1.5456894899611868e-10
R989_1010	989	1010	9.6962228723255030e+03
C989_1010	989	1010	9.1315844670518065e-11
R989_1070	989	1070	6.2467524941130259e+03
C989_1070	989	1070	1.4174065364914389e-10
R989_1076	989	1076	5.0194885222899611e+03
C989_1076	989	1076	1.7639621602243647e-10
R989_1079	989	1079	3.0966383456155181e+03
C989_1079	989	1079	2.8592902459974091e-10
R989_1091	989	1091	1.3318061900718902e+04
C989_1091	989	1091	6.6482554916808566e-11
R990_991	990	991	1.0515369566739993e-05
C990_991	990	991	6.4555131534754309e-11
R990_992	990	992	2.1854221625605155e+03
C990_992	990	992	4.0514770869835658e-10
R990_993	990	993	2.7985632220463267e+03
C990_993	990	993	3.1638334082464519e-10
R990_1077	990	1077	9.7812346381902708e-06
C990_1077	990	1077	9.0522190137728951e-12
R990_1089	990	1089	6.6912196366110200e-06
C990_1089	990	1089	7.9395281817926311e-11
R990_1090	990	1090	6.8291425307042896e-06
C990_1090	990	1090	1.2965299489930061e-11
R990_1092	990	1092	1.6488678890462170e-05
C990_1092	990	1092	8.5917741379175283e-11
R991_993	991	993	1.8204659871334843e+03
C991_993	991	993	4.8636930761567554e-10
R991_1079	991	1079	8.3236934138155466e+03
C991_1079	991	1079	1.0637330541636657e-10
R991_1080	991	1080	6.7714865988857535e-06
C991_1080	991	1080	1.4383262001231821e-10
R991_1090	991	1090	5.3290947501140515e-06
C991_1090	991	1090	1.6614806514390662e-11
R991_1092	991	1092	1.3968445309320642e-05
C991_1092	991	1092	1.0141930739061574e-10
R992_993	992	993	5.0566128144131908e+03
C992_993	992	993	1.7510116241770256e-10
R992_1070	992	1070	3.7757407320846501e+03
C992_1070	992	1070	2.3450200756002267e-10
R992_1079	992	1079	9.4972155984772162e+03
C992_1079	992	1079	9.3229302053748072e-11
R992_1089	992	1089	1.9176768369536005e+03
C992_1089	992	1089	4.6171428086213229e-10
R992_1091	992	1091	4.7093550419138728e+03
C992_1091	992	1091	1.8801274777961268e-10
R992_1092	992	1092	5.2748002450012946e+03
C992_1092	992	1092	1.6785825824192569e-10
R993_1079	993	1079	1.0870084949037770e+04
C993_1079	993	1079	8.1454633137745456e-11
R993_1092	993	1092	1.7585026611654746e+04
C993_1092	993	1092	5.0350721739208244e-11
R994_995	994	995	5.6601773843321125e+03
C994_995	994	995	1.5642951122890955e-10
R994_1004	994	1004	7.6164901663086484e+03
C994_1004	994	1004	1.1625023631181559e-10
R994_1005	994	1005	1.9576626778399946e+04
C994_1005	994	1005	4.5228362971956703e-11
R994_1067	994	1067	7.5296334167767536e+03
C994_1067	994	1067	1.1759122027470832e-10
R994_1071	994	1071	1.1621282986550081e+04
C994_1071	994	1071	7.6189417530296925e-11
R994_1073	994	1073	8.4175219151332767e+03
C994_1073	994	1073	1.0518758259579546e-10
R994_1093	994	1093	4.5806099506513510e+03
C994_1093	994	1093	1.9329713536820477e-10
R995_996	995	996	2.6716638209306025e+03
C995_996	995	996	3.3141100117588450e-10
R995_1002	995	1002	3.6519571661018740e+03
C995_1002	995	1002	2.4245048378951905e-10
R995_1005	995	1005	5.5523330074606247e+03
C995_1005	995	1005	1.5946788143115154e-10
R995_1067	995	1067	5.5961088147541122e+03
C995_1067	995	1067	1.5822043691602241e-10
R995_1093	995	1093	4.3399544650335683e+03
C995_1093	995	1093	2.0401568468833039e-10
R995_1094	995	1094	8.7476770883417903e+03
C995_1094	995	1094	1.0121758871049504e-10
R996_997	996	997	2.8192737507162128e+03
C996_997	996	997	3.1405917267702961e-10
R996_998	996	998	3.3851559283959709e+03
C996_998	996	998	2.6155923107493269e-10
R996_1002	996	1002	4.8283945693105152e+03
C996_1002	996	1002	1.8337747029369972e-10
R996_1058	996	1058	6.1525326072966282e+03
C996_1058	996	1058	1.4391127007599000e-10
R996_1067	996	1067	7.2427150046303614e+03
C996_1067	996	1067	1.2224956817076753e-10
R996_1093	996	1093	1.1208811022449432e+04
C996_1093	996	1093	7.8993104614454612e-11
R996_1094	996	1094	7.4628859900790667e+03
C996_1094	996	1094	1.1864294629142783e-10
R996_1095	996	1095	3.3071352401319205e+03
C996_1095	996	1095	2.6772983788370294e-10
R997_998	997	998	4.4746188437789106e+03
C997_998	997	998	1.9787579961833018e-10
R997_1009	997	1009	5.4098362739055765e+03
C997_1009	997	1009	1.6366831395079923e-10
R997_1058	997	1058	2.4636901776778495e+03
C997_1058	997	1058	3.5938722722617302e-10
R997_1063	997	1063	2.4526529040460487e+03
C997_1063	997	1063	3.6100451891882372e-10
R997_1095	997	1095	4.2415711955881434e+03
C997_1095	997	1095	2.0874782972426951e-10
R998_1009	998	1009	3.2473146706140051e+03
C998_1009	998	1009	2.7266183647443820e-10
R998_1011	998	1011	2.0585720802820465e+03
C998_1011	998	1011	4.3011308186919941e-10
R998_1063	998	1063	4.8392736706448995e+03
C998_1063	998	1063	1.8296522204787929e-10
R998_1067	998	1067	3.4267603085869191e+03
C998_1067	998	1067	2.5838363409348496e-10
R998_1095	998	1095	6.4701365265005770e+03
C998_1095	998	1095	1.3684700130723294e-10
R998_1096	998	1096	8.9852188545767331e+03
C998_1096	998	1096	9.8541704551692793e-11
R999_1000	999	1000	8.0305981344014117e+03
C999_1000	999	1000	1.1025564557975454e-10
R999_1001	999	1001	1.7767400094700636e+03
C999_1001	999	1001	4.9833896742387639e-10
R999_1048	999	1048	4.1764290781041682e+03
C999_1048	999	1048	2.1200378724063562e-10
R999_1049	999	1049	5.0830357304917334e+03
C999_1049	999	1049	1.7419094191855004e-10
R999_1053	999	1053	5.3201506169527429e+03
C999_1053	999	1053	1.6642739002136506e-10
R999_1058	999	1058	3.8637352387261094e+03
C999_1058	999	1058	2.2916134957319864e-10
R999_1059	999	1059	5.5427577082263406e+03
C999_1059	999	1059	1.5974336752730447e-10
R999_1097	999	1097	2.4290628152633758e+03
C999_1097	999	1097	3.6451045075340991e-10
R1000_1001	1000	1001	2.0286979153659424e+03
C1000_1001	1000	1001	4.3644683370233833e-10
R1000_1007	1000	1007	4.9343072012773127e+03
C1000_1007	1000	1007	1.7944135733397327e-10
R1000_1046	1000	1046	2.9564939486627172e+03
C1000_1046	1000	1046	2.9948269709819397e-10
R1000_1053	1000	1053	1.7654021530810912e+03
C1000_1053	1000	1053	5.0153942553809126e-10
R1000_1055	1000	1055	1.7844373748200044e+03
C1000_1055	1000	1055	4.9618932790471939e-10
R1000_1098	1000	1098	4.9093517587460146e+03
C1000_1098	1000	1098	1.8035350189006637e-10
R1001_1002	1001	1002	1.6273125939634367e+03
C1001_1002	1001	1002	5.4409877056472521e-10
R1001_1007	1001	1007	9.5529166258836858e+02
C1001_1007	1001	1007	9.2685701799275857e-10
R1001_1053	1001	1053	3.5650970379800560e+03
C1001_1053	1001	1053	2.4835755444167891e-10
R1001_1058	1001	1058	1.9649692470522430e+03
C1001_1058	1001	1058	4.5060185192631623e-10
R1001_1097	1001	1097	2.8510611587240624e+03
C1001_1097	1001	1097	3.1055762483055679e-10
R1001_1098	1001	1098	1.8996650463466096e+03
C1001_1098	1001	1098	4.6609205312421570e-10
R1001_1099	1001	1099	6.2510118746983028e+02
C1001_1099	1001	1099	1.4164407290343430e-09
R1002_1005	1002	1005	9.2979516953708317e+03
C1002_1005	1002	1005	9.5227294215867275e-11
R1002_1007	1002	1007	7.8853939110987594e+03
C1002_1007	1002	1007	1.1228592910923137e-10
R1002_1058	1002	1058	6.0997975064451157e+03
C1002_1058	1002	1058	1.4515543848209002e-10
R1002_1094	1002	1094	5.2782321735579708e+03
C1002_1094	1002	1094	1.6774911610285486e-10
R1002_1099	1002	1099	5.2296252257437727e+03
C1002_1099	1002	1099	1.6930826655443042e-10
R1003_1005	1003	1005	3.9595062153091840e+03
C1003_1005	1003	1005	2.2361848512235779e-10
R1003_1004	1003	1004	4.1244212491796907e+03
C1003_1004	1003	1004	2.1467709727179340e-10
R1003_1006	1003	1006	1.3529786821997254e+03
C1003_1006	1003	1006	6.5442182744553794e-10
R1003_1020	1003	1020	4.0068580221350671e+03
C1003_1020	1003	1020	2.2097583113968229e-10
R1003_1025	1003	1025	1.5860074475800250e+03
C1003_1025	1003	1025	5.5826899366140871e-10
R1003_1100	1003	1100	4.7129214005120166e+03
C1003_1100	1003	1100	1.8787047490412363e-10
R1004_1005	1004	1005	1.3344236560483498e+03
C1004_1005	1004	1005	6.6352149685505793e-10
R1004_1006	1004	1006	5.4710504283604414e+03
C1004_1006	1004	1006	1.6183707192867922e-10
R1004_1020	1004	1020	1.3206486041070466e+03
C1004_1020	1004	1020	6.7044237123066797e-10
R1004_1071	1004	1071	1.6078262918224409e+03
C1004_1071	1004	1071	5.5069306068903398e-10
R1004_1093	1004	1093	4.2654444193146783e+03
C1004_1093	1004	1093	2.0757949105857971e-10
R1004_1100	1004	1100	1.7692118951122995e+03
C1004_1100	1004	1100	5.0045943289557095e-10
R1004_1101	1004	1101	3.7249237706369490e+03
C1004_1101	1004	1101	2.3770118161333446e-10
R1005_1006	1005	1006	2.3388044413219372e+03
C1005_1006	1005	1006	3.7857751852033608e-10
R1005_1007	1005	1007	5.9535622251013438e+03
C1005_1007	1005	1007	1.4872084110701106e-10
R1005_1031	1005	1031	7.0883034224149023e+03
C1005_1031	1005	1031	1.2491265242682689e-10
R1005_1093	1005	1093	6.7109348021343503e+03
C1005_1093	1005	1093	1.3193672831069685e-10
R1005_1094	1005	1094	4.7317485605160900e+03
C1005_1094	1005	1094	1.8712295684693518e-10
R1005_1100	1005	1100	5.3588103835725042e+03
C1005_1100	1005	1100	1.6522674219156211e-10
R1005_1101	1005	1101	6.4866439287782223e+03
C1005_1101	1005	1101	1.3649874903288722e-10
R1005_1104	1005	1104	2.9097339266841523e+03
C1005_1104	1005	1104	3.0429544556639145e-10
R1006_1025	1006	1025	6.5964387373964646e+03
C1006_1025	1006	1025	1.3422678765746626e-10
R1006_1031	1006	1031	4.5696839588313678e+03
C1006_1031	1006	1031	1.9375930363605131e-10
R1006_1032	1006	1032	4.4831448466390339e+03
C1006_1032	1006	1032	1.9749948127680709e-10
R1006_1100	1006	1100	2.2842682919398626e+03
C1006_1100	1006	1100	3.8761593146664853e-10
R1006_1102	1006	1102	7.7610926440276517e+03
C1006_1102	1006	1102	1.1408429486811386e-10
R1006_1104	1006	1104	9.8108347885183830e+03
C1006_1104	1006	1104	9.0249076738730249e-11
R1007_1031	1007	1031	3.6426008954369950e+03
C1007_1031	1007	1031	2.4307323451469655e-10
R1007_1055	1007	1055	4.9265883624156222e+03
C1007_1055	1007	1055	1.7972250096126529e-10
R1007_1094	1007	1094	7.3671538179057125e+03
C1007_1094	1007	1094	1.2018464709505706e-10
R1007_1098	1007	1098	3.4243302387471981e+03
C1007_1098	1007	1098	2.5856699557807059e-10
R1007_1099	1007	1099	2.7661397112547888e+03
C1007_1099	1007	1099	3.2009185150606604e-10
R1007_1103	1007	1103	3.2863805922856550e+03
C1007_1103	1007	1103	2.6942064585532302e-10
R1007_1104	1007	1104	6.4316838461825682e+03
C1007_1104	1007	1104	1.3766515936966141e-10
R1007_1105	1007	1105	3.3602198329265789e+03
C1007_1105	1007	1105	2.6350025466305456e-10
R1008_1009	1008	1009	6.2401470663223508e+03
C1008_1009	1008	1009	1.4189069140349997e-10
R1008_1014	1008	1014	6.2188730821641948e+03
C1008_1014	1008	1014	1.4237608164723482e-10
R1008_1018	1008	1018	1.4062523337319604e+04
C1008_1018	1008	1018	6.2963008875529875e-11
R1008_1019	1008	1019	2.1944707421421699e+03
C1008_1019	1008	1019	4.0347714129726049e-10
R1008_1060	1008	1060	9.6902618022274601e+03
C1008_1060	1008	1060	9.1372018607017683e-11
R1008_1061	1008	1061	4.4087209650785935e+03
C1008_1061	1008	1061	2.0083348179968475e-10
R1008_1063	1008	1063	9.1366770547936740e+03
C1008_1063	1008	1063	9.6908184057512889e-11
R1008_1107	1008	1107	4.6000832266765892e+03
C1008_1107	1008	1107	1.9247886137479442e-10
R1009_1011	1009	1011	4.4909561561469172e+03
C1009_1011	1009	1011	1.9715596209686859e-10
R1009_1018	1009	1018	3.1439093148728266e+03
C1009_1018	1009	1018	2.8162987320002133e-10
R1009_1063	1009	1063	2.2959141384198560e+03
C1009_1063	1009	1063	3.8564977970360098e-10
R1009_1068	1009	1068	4.5471677052253426e+03
C1009_1068	1009	1068	1.9471874342407206e-10
R1009_1107	1009	1107	8.7689555909118080e+03
C1009_1107	1009	1107	1.0097197693846835e-10
R1010_1016	1010	1016	3.5567704372478479e+03
C1010_1016	1010	1016	2.4893897352147298e-10
R1010_1072	1010	1072	4.9073771409641404e+03
C1010_1072	1010	1072	1.8042607206790793e-10
R1010_1076	1010	1076	4.6693017750018471e+03
C1010_1076	1010	1076	1.8962552098052175e-10
R1010_1079	1010	1079	3.6098613991052166e+03
C1010_1079	1010	1079	2.4527777767851988e-10
R1010_1081	1010	1081	4.3821782566170086e+03
C1010_1081	1010	1081	2.0204992354271168e-10
R1010_1108	1010	1108	6.1710092245595115e+03
C1010_1108	1010	1108	1.4348038537621882e-10
R1011_1016	1011	1016	3.1536848422266971e+03
C1011_1016	1011	1016	2.8075690057692628e-10
R1011_1063	1011	1063	3.8391633756625215e+03
C1011_1063	1011	1063	2.3062805488115077e-10
R1011_1067	1011	1067	3.2057877499672613e+03
C1011_1067	1011	1067	2.7619382528024267e-10
R1011_1068	1011	1068	3.3819049163055556e+03
C1011_1068	1011	1068	2.6181066695016516e-10
R1011_1072	1011	1072	2.8711168453897658e+03
C1011_1072	1011	1072	3.0838827863162117e-10
R1011_1096	1011	1096	3.0197860201360904e+03
C1011_1096	1011	1096	2.9320580193297858e-10
R1011_1109	1011	1109	4.0670212603826690e+03
C1011_1109	1011	1109	2.1770694693066111e-10
R1012_1013	1012	1013	1.5920055963784487e-06
C1012_1013	1012	1013	5.5616562134843148e-11
R1012_1064	1012	1064	5.2651456465019005e-06
C1012_1064	1012	1064	1.6816605677152759e-11
R1012_1065	1012	1065	9.8795096746428546e-07
C1012_1065	1012	1065	8.9621733351054013e-11
R1012_1066	1012	1066	1.1436377563458667e-06
C1012_1066	1012	1066	7.7421261827615451e-11
R1012_1111	1012	1111	5.3424481864602963e-06
C1012_1111	1012	1111	1.6573277845613420e-11
R1013_1039	1013	1039	2.2069529712629584e-06
C1013_1039	1013	1039	4.0119512886280821e-11
R1013_1064	1013	1064	2.8083893723962192e-06
C1013_1064	1013	1064	3.1527636103555283e-11
R1013_1066	1013	1066	5.1780942414652652e-06
C1013_1066	1013	1066	1.7099317633304597e-11
R1013_1111	1013	1111	2.3303127997116257e-06
C1013_1111	1013	1111	3.7995705203591980e-11
R1014_1049	1014	1049	9.7929888572327854e+02
C1014_1049	1014	1049	9.0413539176658863e-10
R1014_1050	1014	1050	2.4939369779026797e+03
C1014_1050	1014	1050	3.5502853101148072e-10
R1014_1059	1014	1059	9.9369778825470075e+02
C1014_1059	1014	1059	8.9103426833134196e-10
R1014_1060	1014	1060	1.9376152454834212e+03
C1014_1060	1014	1060	4.5696315806964780e-10
R1014_1061	1014	1061	1.8730749508357494e+03
C1014_1061	1014	1061	4.7270867687645602e-10
R1014_1112	1014	1112	1.4890261460204540e+03
C1014_1112	1014	1112	5.9462943888954211e-10
R1015_1050	1015	1050	4.3209691351934562e+03
C1015_1050	1015	1050	2.0491208198837513e-10
R1015_1060	1015	1060	3.3633842020581783e+03
C1015_1060	1015	1060	2.6325234600263027e-10
R1015_1062	1015	1062	7.2602244945963603e+03
C1015_1062	1015	1062	1.2195473877687936e-10
R1015_1113	1015	1113	6.2348989767629600e+03
C1015_1113	1015	1113	1.4201012478307909e-10
R1015_1114	1015	1114	6.2178915061947273e+03
C1015_1114	1015	1114	1.4239855758465388e-10
R1016_1017	1016	1017	2.9608311441832006e+03
C1016_1017	1016	1017	2.9904399764217529e-10
R1016_1068	1016	1068	2.9290152407519458e+03
C1016_1068	1016	1068	3.0229230950423214e-10
R1016_1072	1016	1072	2.4673592868193587e+03
C1016_1072	1016	1072	3.5885279717060671e-10
R1016_1081	1016	1081	3.0181777135165862e+03
C1016_1081	1016	1081	2.9336204350550556e-10
R1016_1108	1016	1108	3.4806576335940176e+03
C1016_1108	1016	1108	2.5438261239895194e-10
R1016_1109	1016	1109	4.0618998251703511e+03
C1016_1109	1016	1109	2.1798144213536004e-10
R1016_1115	1016	1115	5.9337738115625325e+03
C1016_1115	1016	1115	1.4921680701321576e-10
R1017_1018	1017	1018	1.5553984715040337e+04
C1017_1018	1017	1018	5.6925527311584726e-11
R1017_1068	1017	1068	5.8126365260561533e+03
C1017_1068	1017	1068	1.5232653508110416e-10
R1017_1069	1017	1069	6.6219306368759762e+03
C1017_1069	1017	1069	1.3371006587856882e-10
R1017_1081	1017	1081	5.4669463950006602e+03
C1017_1081	1017	1081	1.6195856292091797e-10
R1017_1083	1017	1083	8.5769154225824659e+03
C1017_1083	1017	1083	1.0323277519663415e-10
R1017_1115	1017	1115	7.9871727812154641e+03
C1017_1115	1017	1115	1.1085509302895782e-10
R1018_1019	1018	1019	5.7337607029785077e+03
C1018_1019	1018	1019	1.5442199763238338e-10
R1018_1068	1018	1068	1.1238066939311013e+03
C1018_1068	1018	1068	7.8787462868973044e-10
R1018_1069	1018	1069	6.3269876459404650e+03
C1018_1069	1018	1069	1.3994318169217613e-10
R1018_1107	1018	1107	3.9332105776948633e+03
C1018_1107	1018	1107	2.2511349550445818e-10
R1018_1116	1018	1116	6.2745286899986531e+03
C1018_1116	1018	1116	1.4111319358716492e-10
R1019_1060	1019	1060	6.3513518438504325e+03
C1019_1060	1019	1060	1.3940635056413838e-10
R1019_1062	1019	1062	5.9216061943523227e+03
C1019_1062	1019	1062	1.4952341520860676e-10
R1019_1107	1019	1107	3.3822223506918931e+03
C1019_1107	1019	1107	2.6178609502680154e-10
R1019_1116	1019	1116	8.7547228029937596e+03
C1019_1116	1019	1116	1.0113612979239307e-10
R1020_1021	1020	1021	1.1994187675769970e+03
C1020_1021	1020	1021	7.3820654273125709e-10
R1020_1022	1020	1022	1.0984458490248883e+03
C1020_1022	1020	1022	8.0606502585994881e-10
R1020_1023	1020	1023	1.4852789534824524e+03
C1020_1023	1020	1023	5.9612962240123785e-10
R1020_1025	1020	1025	2.7605089688720072e+03
C1020_1025	1020	1025	3.2074475818921099e-10
R1020_1071	1020	1071	4.4618064015387208e+03
C1020_1071	1020	1071	1.9844401617126419e-10
R1020_1100	1020	1100	1.8881928697535768e+03
C1020_1100	1020	1100	4.6892390914258337e-10
R1020_1123	1020	1123	2.5388440903178266e+03
C1020_1123	1020	1123	3.4874878102071974e-10
R1021_1023	1021	1023	7.0065183542935449e+02
C1021_1023	1021	1023	1.2637072179471586e-09
R1021_1036	1021	1036	2.2788225965791503e+03
C1021_1036	1021	1036	3.8854221606769416e-10
R1021_1037	1021	1037	1.1755943076734175e+03
C1021_1037	1021	1037	7.5316695217103008e-10
R1021_1071	1021	1071	2.2507380064731092e+03
C1021_1071	1021	1071	3.9339042534206157e-10
R1021_1100	1021	1100	3.5800716817693315e+03
C1021_1100	1021	1100	2.4731873001559883e-10
R1021_1110	1021	1110	1.7397011213666212e+03
C1021_1110	1021	1110	5.0894879058562647e-10
R1021_1121	1021	1121	2.2295193875920563e+03
C1021_1121	1021	1121	3.9713437193128752e-10
R1021_1122	1021	1122	1.1894100567232415e+03
C1021_1122	1021	1122	7.4441844231524284e-10
R1021_1123	1021	1123	2.4930640056697539e+03
C1021_1123	1021	1123	3.5515284793586160e-10
R1022_1023	1022	1023	1.7602591934561653e+03
C1022_1023	1022	1023	5.0300477622362666e-10
R1022_1024	1022	1024	2.1990151419123740e+03
C1022_1024	1022	1024	4.0264333101862837e-10
R1022_1025	1022	1025	1.3480509217594192e+03
C1022_1025	1022	1025	6.5681404716105904e-10
R1022_1026	1022	1026	2.9083167863253766e+03
C1022_1026	1022	1026	3.0444372011438146e-10
R1022_1123	1022	1123	2.7679991208568349e+03
C1022_1123	1022	1123	3.1987682908870239e-10
R1022_1124	1022	1124	2.7850225618883610e+03
C1022_1124	1022	1124	3.1792158304802007e-10
R1023_1024	1023	1024	5.4610247184661685e+03
C1023_1024	1023	1024	1.6213418311512175e-10
R1023_1033	1023	1033	4.0407167958711980e+03
C1023_1033	1023	1033	2.1912418672962189e-10
R1023_1037	1023	1037	2.6680930485480308e+03
C1023_1037	1023	1037	3.3185453640076108e-10
R1023_1122	1023	1122	1.9010964279377115e+03
C1023_1122	1023	1122	4.6574112111740294e-10
R1023_1123	1023	1123	3.3804843071994615e+03
C1023_1123	1023	1123	2.6192068982965315e-10
R1023_1124	1023	1124	3.8155990448744992e+03
C1023_1124	1023	1124	2.3205236485457889e-10
R1024_1026	1024	1026	6.1604039556968173e+03
C1024_1026	1024	1026	1.4372738996786265e-10
R1024_1033	1024	1033	6.6981957242154976e+03
C1024_1033	1024	1033	1.3218765443043270e-10
R1024_1124	1024	1124	5.0939031084228300e+03
C1024_1124	1024	1124	1.7381932142288876e-10
R1025_1026	1025	1026	2.0957116069293475e+03
C1025_1026	1025	1026	4.2249075625310977e-10
R1025_1027	1025	1027	6.2226628111128075e+03
C1025_1027	1025	1027	1.4228937170093252e-10
R1025_1032	1025	1032	1.8709986630750843e+03
C1025_1032	1025	1032	4.7323325193870956e-10
R1025_1100	1025	1100	4.1537496753336654e+03
C1025_1100	1025	1100	2.1316132432291444e-10
R1025_1123	1025	1123	1.8472432336446825e+03
C1025_1123	1025	1123	4.7931900118699275e-10
R1025_1124	1025	1124	5.6954077313053122e+03
C1025_1124	1025	1124	1.5546187796761545e-10
R1025_1125	1025	1125	2.6898269537060255e+03
C1025_1125	1025	1125	3.2917313899322621e-10
R1026_1027	1026	1027	5.5563727338489452e+03
C1026_1027	1026	1027	1.5935194129546152e-10
R1026_1124	1026	1124	5.5937607037348525e+03
C1026_1124	1026	1124	1.5828685362046719e-10
R1026_1125	1026	1125	5.7133517421339602e+03
C1026_1125	1026	1125	1.5497361647985854e-10
R1027_1029	1027	1029	6.5472635785265911e+03
C1027_1029	1027	1029	1.3523493763164740e-10
R1027_1032	1027	1032	3.3153804504112090e+03
C1027_1032	1027	1032	2.6706400515517935e-10
R1027_1125	1027	1125	5.4045626511568262e+03
C1027_1125	1027	1125	1.6382801696460665e-10
R1027_1127	1027	1127	1.1564175650725394e+04
C1027_1127	1027	1127	7.6565663514844643e-11
R1028_1029	1028	1029	7.3385590542798282e+03
C1028_1029	1028	1029	1.2065294769054508e-10
R1028_1030	1028	1030	2.7985876442625845e+03
C1028_1030	1028	1030	3.1638057986685065e-10
R1028_1040	1028	1040	3.0617942390164867e+03
C1028_1040	1028	1040	2.8918297984139377e-10
R1028_1041	1028	1041	2.9363919446586392e+03
C1028_1041	1028	1041	3.0153290105246200e-10
R1028_1128	1028	1128	1.2334959654707831e+04
C1028_1128	1028	1128	7.1781246674938750e-11
R1029_1030	1029	1030	7.3811018092080240e+03
C1029_1030	1029	1030	1.1995753541773779e-10
R1029_1032	1029	1032	6.2251267396406438e+03
C1029_1032	1029	1032	1.4223305303356961e-10
R1029_1040	1029	1040	1.8187455640967949e+03
C1029_1040	1029	1040	4.8682938349307081e-10
R1029_1127	1029	1127	5.2858103331951388e+03
C1029_1127	1029	1127	1.6750861757931950e-10
R1029_1128	1029	1128	5.2993199208754049e+03
C1029_1128	1029	1128	1.6708158686779867e-10
R1030_1041	1030	1041	2.1005343991478644e+03
C1030_1041	1030	1041	4.2152072446858902e-10
R1030_1042	1030	1042	8.8639587212514361e+03
C1030_1042	1030	1042	9.9889768166135399e-11
R1030_1128	1030	1128	6.4025759101873982e+03
C1030_1128	1030	1128	1.3829102444395457e-10
R1031_1032	1031	1032	5.0183473248044538e+03
C1031_1032	1031	1032	1.7643632941139673e-10
R1031_1040	1031	1040	5.4837046457919232e+03
C1031_1040	1031	1040	1.6146361609381200e-10
R1031_1055	1031	1055	7.5008148849408171e+03
C1031_1055	1031	1055	1.1804301203028375e-10
R1031_1102	1031	1102	6.8871987369683729e+03
C1031_1102	1031	1102	1.2856007435175982e-10
R1031_1103	1031	1103	3.3169987347416404e+03
C1031_1103	1031	1103	2.6693371101601133e-10
R1031_1104	1031	1104	1.1616753946418508e+04
C1031_1104	1031	1104	7.6219121605220757e-11
R1031_1126	1031	1126	1.1129878960634087e+04
C1031_1126	1031	1126	7.9553316332701297e-11
R1031_1131	1031	1131	1.0779705032222282e+04
C1031_1131	1031	1131	8.2137570467219663e-11
R1032_1040	1032	1040	6.6969337311193567e+03
C1032_1040	1032	1040	1.3221256432412194e-10
R1032_1100	1032	1100	6.4221179938317464e+03
C1032_1100	1032	1100	1.3787021393104554e-10
R1032_1102	1032	1102	4.4648130845643891e+03
C1032_1102	1032	1102	1.9831038050865820e-10
R1032_1123	1032	1123	6.9201542214282163e+03
C1032_1123	1032	1123	1.2794783950888059e-10
R1032_1125	1032	1125	2.8562125060152198e+03
C1032_1125	1032	1125	3.0999751588346344e-10
R1032_1126	1032	1126	1.3991536504252210e+03
C1032_1126	1032	1126	6.3282455177879121e-10
R1032_1127	1032	1127	3.5379093541445486e+03
C1032_1127	1032	1127	2.5026610155027290e-10
R1032_1132	1032	1132	4.4638491875894788e+03
C1032_1132	1032	1132	1.9835320246966823e-10
R1033_1034	1033	1034	1.3635643869655949e+04
C1033_1034	1033	1034	6.4934138069590162e-11
R1033_1037	1033	1037	3.9776132664614688e+03
C1033_1037	1033	1037	2.2260052005701371e-10
R1033_1038	1033	1038	1.3233782998979548e+04
C1033_1038	1033	1038	6.6905946830794672e-11
R1033_1122	1033	1122	6.7753945029573333e+03
C1033_1122	1033	1122	1.3068150958789651e-10
R1033_1124	1033	1124	1.3740474385795571e+04
C1033_1124	1033	1124	6.4438734561836923e-11
R1033_1133	1033	1133	1.7937519259009961e+04
C1033_1133	1033	1133	4.9361272811191937e-11
R1033_1135	1033	1135	9.8382499047922811e+03
C1033_1135	1033	1135	8.9997590045837959e-11
R1034_1035	1034	1035	5.6380509403047572e+03
C1034_1035	1034	1035	1.5704341643499589e-10
R1034_1038	1034	1038	2.2578432963505466e+03
C1034_1038	1034	1038	3.9215245058465404e-10
R1034_1064	1034	1064	4.8474458937479631e+03
C1034_1064	1034	1064	1.8265676422339789e-10
R1034_1135	1034	1135	1.1476035938977553e+04
C1034_1135	1034	1135	7.7153712868111303e-11
R1034_1136	1034	1136	6.0190928741457383e+03
C1034_1136	1034	1136	1.4710169791584474e-10
R1035_1039	1035	1039	3.1196988868990365e-06
C1035_1039	1035	1039	2.8381546226087914e-11
R1035_1064	1035	1064	8.0379042638146293e-06
C1035_1064	1035	1064	1.2117097030884728e-10
R1035_1136	1035	1136	1.9100197247628604e-05
C1035_1136	1035	1136	5.0992178052871252e-11
R1036_1037	1036	1037	1.2742033469437058e+03
C1036_1037	1036	1037	6.9488028251044755e-10
R1036_1038	1036	1038	4.3682960309874916e+03
C1036_1038	1036	1038	2.0269202806290658e-10
R1036_1071	1036	1071	6.0588151254966688e+03
C1036_1071	1036	1071	1.4613728317505286e-10
R1036_1074	1036	1074	3.6756772249972146e+03
C1036_1074	1036	1074	2.4088589054515553e-10
R1036_1075	1036	1075	2.2491220228867678e+03
C1036_1075	1036	1075	3.9367307451089616e-10
R1036_1110	1036	1110	4.4766660517029222e+03
C1036_1110	1036	1110	1.9778530975371438e-10
R1036_1138	1036	1138	4.1817176559024347e+03
C1036_1138	1036	1138	2.1173566810524477e-10
R1037_1038	1037	1038	3.2391301730651871e+03
C1037_1038	1037	1038	2.7335078690651346e-10
R1037_1110	1037	1110	3.1947806559375749e+03
C1037_1110	1037	1110	2.7714540591524751e-10
R1037_1122	1037	1122	1.2448176179519292e+03
C1037_1122	1037	1122	7.1128394146345696e-10
R1037_1135	1037	1135	6.0517166417440394e+03
C1037_1135	1037	1135	1.4630869786474865e-10
R1037_1137	1037	1137	1.9389863064295535e+03
C1037_1137	1037	1137	4.5664003854179293e-10
R1037_1138	1037	1138	5.4461364887713435e+03
C1037_1138	1037	1138	1.6257741309376399e-10
R1038_1064	1038	1064	2.4159835486062325e+03
C1038_1064	1038	1064	3.6648377933318024e-10
R1038_1074	1038	1074	7.2462407571928097e+03
C1038_1074	1038	1074	1.2219008605546399e-10
R1038_1135	1038	1135	2.7221132907603583e+03
C1038_1135	1038	1135	3.2526889483452737e-10
R1038_1136	1038	1136	4.6614674877816224e+03
C1038_1136	1038	1136	1.8994421478232130e-10
R1038_1137	1038	1137	5.3008556125170462e+03
C1038_1137	1038	1137	1.6703318226763959e-10
R1038_1138	1038	1138	2.3609837665050090e+03
C1038_1138	1038	1138	3.7502112223782702e-10
R1038_1139	1038	1139	3.3956203458184568e+03
C1038_1139	1038	1139	2.6075317365510279e-10
R1039_1064	1039	1064	4.6600749647659659e-06
C1039_1064	1039	1064	1.9000097388872515e-11
R1039_1111	1039	1111	5.8371859089814553e-06
C1039_1111	1039	1111	1.5168589719536598e-11
R1039_1136	1039	1136	8.6903176350453325e-06
C1039_1136	1039	1136	1.0188566389442234e-11
R1039_1140	1039	1140	1.7497283828950338e-05
C1039_1140	1039	1140	5.0603213067563090e-12
R1040_1041	1040	1041	2.2666659225362982e+03
C1040_1041	1040	1041	3.9062606134266835e-10
R1040_1055	1040	1055	1.2532859040300946e+03
C1040_1055	1040	1055	7.0647789052188927e-10
R1040_1103	1040	1103	3.4172538473100503e+03
C1040_1103	1040	1103	2.5910243173680894e-10
R1040_1126	1040	1126	4.1734448956393962e+03
C1040_1126	1040	1126	2.1215537855193094e-10
R1040_1127	1040	1127	2.6290088670269702e+03
C1040_1127	1040	1127	3.3678805454212141e-10
R1040_1128	1040	1128	1.7812637386464305e+03
C1040_1128	1040	1128	4.9707337688961394e-10
R1040_1130	1040	1130	1.4914782078508872e+03
C1040_1130	1040	1130	5.9365183952357224e-10
R1040_1131	1040	1131	1.8117613845342039e+03
C1040_1131	1040	1131	4.8870606761918449e-10
R1040_1141	1040	1141	3.6380794451867200e+03
C1040_1141	1040	1141	2.4337532894490075e-10
R1041_1042	1041	1042	1.3499968703542213e+03
C1041_1042	1041	1042	6.5586728469057710e-10
R1041_1044	1041	1044	3.4446149719778518e+03
C1041_1044	1041	1044	2.5704433990531152e-10
R1041_1052	1041	1052	1.9418588408826033e+03
C1041_1052	1041	1052	4.5596454441434292e-10
R1041_1055	1041	1055	5.9193563579815827e+03
C1041_1055	1041	1055	1.4958024625534041e-10
R1041_1056	1041	1056	3.3903988722048584e+03
C1041_1056	1041	1056	2.6115475348898727e-10
R1041_1128	1041	1128	2.5296626172818737e+03
C1041_1128	1041	1128	3.5001457334709086e-10
R1041_1130	1041	1130	2.4233573574516904e+03
C1041_1130	1041	1130	3.6536863990669236e-10
R1041_1142	1041	1142	7.7294883748651564e+03
C1041_1142	1041	1142	1.1455076180452197e-10
R1042_1043	1042	1043	3.6504916685407279e+03
C1042_1043	1042	1043	2.4254781604636377e-10
R1042_1044	1042	1044	4.6129362666578063e+03
C1042_1044	1042	1044	1.9194255686985880e-10
R1042_1056	1042	1056	1.6824571458952389e+03
C1042_1056	1042	1056	5.2626528043236839e-10
R1042_1128	1042	1128	7.3312731530183955e+03
C1042_1128	1042	1128	1.2077285393949070e-10
R1042_1142	1042	1142	5.1120556038142522e+03
C1042_1142	1042	1142	1.7320210309124253e-10
R1042_1143	1042	1143	7.3756807313389063e+03
C1042_1143	1042	1143	1.2004570343424697e-10
R1043_1044	1043	1044	5.0447316456327890e+03
C1043_1044	1043	1044	1.7551355431690894e-10
R1043_1056	1043	1056	6.4351836125172231e+03
C1043_1056	1043	1056	1.3759029034971928e-10
R1043_1057	1043	1057	6.9367032130117223e+03
C1043_1057	1043	1057	1.2764259252711721e-10
R1043_1143	1043	1143	9.8631203504418263e+03
C1043_1143	1043	1143	8.9770655760105067e-11
R1044_1045	1044	1045	5.3254782695682761e+03
C1044_1045	1044	1045	1.6626089468050331e-10
R1044_1046	1044	1046	3.9287585363636231e+03
C1044_1046	1044	1046	2.2536859252223868e-10
R1044_1052	1044	1052	3.1596105117712837e+03
C1044_1052	1044	1052	2.8023035700170295e-10
R1044_1056	1044	1056	3.7889650164476679e+03
C1044_1056	1044	1056	2.3368354626037736e-10
R1044_1057	1044	1057	2.0530480227265430e+03
C1044_1057	1044	1057	4.3127037063854114e-10
R1044_1129	1044	1129	7.3732882518210909e+03
C1044_1129	1044	1129	1.2008465578181011e-10
R1044_1144	1044	1144	1.0003179893919287e+04
C1044_1144	1044	1144	8.8513731742265949e-11
R1045_1046	1045	1046	3.5485896290963847e+03
C1045_1046	1045	1046	2.4951286968774233e-10
R1045_1047	1045	1047	6.4925669728544890e+03
C1045_1047	1045	1047	1.3637422384735470e-10
R1045_1048	1045	1048	7.9034946869737760e+03
C1045_1048	1045	1048	1.1202876914174586e-10
R1045_1057	1045	1057	9.9505456828829156e+03
C1045_1057	1045	1057	8.8981932239466154e-11
R1045_1144	1045	1144	4.7311669611047610e+03
C1045_1144	1045	1144	1.8714595975561359e-10
R1046_1048	1046	1048	7.7054600153633182e+03
C1046_1048	1046	1048	1.1490797174141873e-10
R1046_1052	1046	1052	1.9204325416730933e+03
C1046_1052	1046	1052	4.6105174875271458e-10
R1046_1053	1046	1053	2.6163186350957599e+03
C1046_1053	1046	1053	3.3842161647394022e-10
R1046_1055	1046	1055	6.9326467451261587e+03
C1046_1055	1046	1055	1.2771727945354692e-10
R1046_1144	1046	1144	5.2107973667366341e+03
C1046_1144	1046	1144	1.6992001787521266e-10
R1047_1048	1047	1048	2.7150769770506945e+03
C1047_1048	1047	1048	3.2611185214417146e-10
R1047_1051	1047	1051	1.0344213848647882e+04
C1047_1051	1047	1051	8.5595560441331698e-11
R1047_1144	1047	1144	1.5477355501635770e+04
C1047_1144	1047	1144	5.7207368636484573e-11
R1047_1147	1047	1147	1.4650092504050801e+04
C1047_1147	1047	1147	6.0437760475244691e-11
R1048_1049	1048	1049	3.6488347800953302e+03
C1048_1049	1048	1049	2.4265795385694812e-10
R1048_1051	1048	1051	3.6327041712043374e+03
C1048_1051	1048	1051	2.4373544884786482e-10
R1048_1053	1048	1053	1.8076976845546963e+03
C1048_1053	1048	1053	4.8980467766550902e-10
R1048_1054	1048	1054	1.6427282406030754e+03
C1048_1054	1048	1054	5.3899285336139751e-10
R1048_1097	1048	1097	4.6376194411183887e+03
C1048_1097	1048	1097	1.9092096558196161e-10
R1048_1144	1048	1144	4.9717286719432977e+03
C1048_1144	1048	1144	1.7809072862254906e-10
R1048_1145	1048	1145	4.9903949451118342e+03
C1048_1145	1048	1145	1.7742459092687259e-10
R1048_1147	1048	1147	3.0210662724371027e+03
C1048_1147	1048	1147	2.9308154864995073e-10
R1048_1148	1048	1148	1.1892532437804561e+04
C1048_1148	1048	1148	7.4451660008543497e-11
R1049_1050	1049	1050	6.5397093746587816e+03
C1049_1050	1049	1050	1.3539115134549815e-10
R1049_1051	1049	1051	3.9682997828117609e+03
C1049_1051	1049	1051	2.2312295697393897e-10
R1049_1059	1049	1059	7.9816671692801981e+02
C1049_1059	1049	1059	1.1093155889884705e-09
R1049_1097	1049	1097	4.5235416649681720e+03
C1049_1097	1049	1097	1.9573574143396997e-10
R1049_1112	1049	1112	3.3186958416919447e+03
C1049_1112	1049	1112	2.6679720707655866e-10
R1049_1145	1049	1145	3.3978214977892571e+03
C1049_1145	1049	1145	2.6058425443363778e-10
R1049_1148	1049	1148	5.7369055418089856e+03
C1049_1148	1049	1148	1.5433734706756319e-10
R1050_1051	1050	1051	7.6352518493569360e+03
C1050_1051	1050	1051	1.1596458102093551e-10
R1050_1060	1050	1060	6.7029796604154953e+03
C1050_1060	1050	1060	1.3209331171461677e-10
R1050_1112	1050	1112	6.0105223985842313e+03
C1050_1112	1050	1112	1.4731145198103897e-10
R1050_1114	1050	1114	7.0320273481918011e+03
C1050_1114	1050	1114	1.2591230634614560e-10
R1050_1148	1050	1148	7.4546499195741890e+03
C1050_1148	1050	1148	1.1877402577619303e-10
R1051_1147	1051	1147	8.3180050095435363e+03
C1051_1147	1051	1147	1.0644605054747245e-10
R1051_1148	1051	1148	4.7776340141100345e+03
C1051_1148	1051	1148	1.8532578658914580e-10
R1052_1055	1052	1055	3.3210132665651959e+03
C1052_1055	1052	1055	2.6661103423286131e-10
R1052_1053	1052	1053	6.9257662093272593e+03
C1052_1053	1052	1053	1.2784416264406449e-10
R1052_1056	1052	1056	3.0249053377062787e+03
C1052_1056	1052	1056	2.9270958355721444e-10
R1052_1129	1052	1129	1.7145903889051051e+03
C1052_1129	1052	1129	5.1640251072759511e-10
R1052_1130	1052	1130	2.3756901828937666e+03
C1052_1130	1052	1130	3.7269960034161287e-10
R1052_1144	1052	1144	6.4344546905999423e+03
C1052_1144	1052	1144	1.3760587715280722e-10
R1052_1150	1052	1150	2.9530568544426983e+03
C1052_1150	1052	1150	2.9983126818839950e-10
R1053_1055	1053	1055	3.7337200947355927e+03
C1053_1055	1053	1055	2.3714117803003174e-10
R1053_1097	1053	1097	2.7265320953675032e+03
C1053_1097	1053	1097	3.2474174179147396e-10
R1053_1054	1053	1054	1.2643961954018612e+03
C1053_1054	1053	1054	7.0027004582894116e-10
R1053_1098	1053	1098	1.2860665441128338e+03
C1053_1098	1053	1098	6.8847042616351383e-10
R1053_1144	1053	1144	5.3182217804370102e+03
C1053_1144	1053	1144	1.6648775065323494e-10
R1053_1146	1053	1146	5.5068028656685201e+03
C1053_1146	1053	1146	1.6078635885443321e-10
R1053_1150	1053	1150	2.1634443444964331e+03
C1053_1150	1053	1150	4.0926348946873041e-10
R1053_1151	1053	1151	2.5099348765630834e+03
C1053_1151	1053	1151	3.5276563944656057e-10
R1054_1097	1054	1097	6.9614407046082024e+03
C1054_1097	1054	1097	1.2718901435357878e-10
R1054_1144	1054	1144	4.9193646881698924e+03
C1054_1144	1054	1144	1.7998640837286545e-10
R1054_1145	1054	1145	5.2700814965007057e+03
C1054_1145	1054	1145	1.6800855589954568e-10
R1054_1146	1054	1146	1.3055578046274250e+03
C1054_1146	1054	1146	6.7819194107048945e-10
R1054_1147	1054	1147	2.7654074552242892e+03
C1054_1147	1054	1147	3.2017660906616310e-10
R1054_1149	1054	1149	2.7273712085810062e+03
C1054_1149	1054	1149	3.2464183053419594e-10
R1054_1150	1054	1150	6.1370193505754396e+03
C1054_1150	1054	1150	1.4427505131085805e-10
R1054_1151	1054	1151	4.5555551561963712e+03
C1054_1151	1054	1151	1.9436023741160765e-10
R1055_1098	1055	1098	2.6323405940970592e+03
C1055_1098	1055	1098	3.3636178528170856e-10
R1055_1103	1055	1103	1.2177938993909336e+03
C1055_1103	1055	1103	7.2706784139979096e-10
R1055_1130	1055	1130	1.3207189844663628e+03
C1055_1130	1055	1130	6.7040664374015503e-10
R1055_1150	1055	1150	4.0928664216179204e+03
C1055_1150	1055	1150	2.1633219618977740e-10
R1055_1152	1055	1152	3.8979775732166904e+03
C1055_1152	1055	1152	2.2714824933416293e-10
R1056_1057	1056	1057	1.4069586748503787e+03
C1056_1057	1056	1057	6.2931399303121593e-10
R1056_1129	1056	1129	5.9951299419718396e+02
C1056_1129	1056	1129	1.4768967316307736e-09
R1056_1130	1056	1130	4.9870746777299437e+03
C1056_1130	1056	1130	1.7754271570343358e-10
R1056_1142	1056	1142	2.3342233264156034e+03
C1056_1142	1056	1142	3.7932050960163921e-10
R1056_1143	1056	1143	1.6490712953580548e+03
C1056_1143	1056	1143	5.3691964937619842e-10
R1056_1153	1056	1153	2.6582435387064038e+03
C1056_1153	1056	1153	3.3308414703450248e-10
R1057_1129	1057	1129	2.3717763674362841e+03
C1057_1129	1057	1129	3.7331461509462322e-10
R1057_1143	1057	1143	7.9520004729538969e+03
C1057_1143	1057	1143	1.1134541361151316e-10
R1057_1144	1057	1144	5.3601445604049686e+03
C1057_1144	1057	1144	1.6518561611948482e-10
R1057_1153	1057	1153	4.9344271000130384e+03
C1057_1153	1057	1153	1.7943699719419509e-10
R1058_1059	1058	1059	3.6452277848618887e+03
C1058_1059	1058	1059	2.4289806672082831e-10
R1058_1061	1058	1061	5.9706257599224919e+03
C1058_1061	1058	1061	1.4829580973628036e-10
R1058_1063	1058	1063	3.2109127351996412e+03
C1058_1063	1058	1063	2.7575298823714327e-10
R1058_1094	1058	1094	3.0405288295840328e+03
C1058_1094	1058	1094	2.9120552092286263e-10
R1058_1095	1058	1095	1.3015823742347163e+03
C1058_1095	1058	1095	6.8026334654431270e-10
R1058_1097	1058	1097	2.2029632509086418e+03
C1058_1097	1058	1097	4.0192172127011076e-10
R1058_1099	1058	1099	1.4171981257146817e+03
C1058_1099	1058	1099	6.2476711310459191e-10
R1058_1106	1058	1106	1.5240906066820205e+03
C1058_1106	1058	1106	5.8094891328513389e-10
R1058_1154	1058	1154	2.7305215673866937e+03
C1058_1154	1058	1154	3.2426727269816441e-10
R1059_1061	1059	1061	2.6833890441929807e+03
C1059_1061	1059	1061	3.2996288168355638e-10
R1059_1097	1059	1097	1.6491142415911838e+03
C1059_1097	1059	1097	5.3690566691467319e-10
R1059_1112	1059	1112	2.1116690624235594e+03
C1059_1112	1059	1112	4.1929807916199058e-10
R1059_1145	1059	1145	3.4115515176382273e+03
C1059_1145	1059	1145	2.5953551547507158e-10
R1059_1154	1059	1154	5.0537643777255907e+03
C1059_1154	1059	1154	1.7519985411319792e-10
R1060_1061	1060	1061	4.6312856540971870e+03
C1060_1061	1060	1061	1.9118207077481638e-10
R1060_1062	1060	1062	3.4178171458240872e+03
C1060_1062	1060	1062	2.5905972845323535e-10
R1060_1107	1060	1107	1.0660412152507799e+04
C1060_1107	1060	1107	8.3056711976347970e-11
R1060_1112	1060	1112	3.4178171458240708e+03
C1060_1112	1060	1112	2.5905972845323659e-10
R1060_1113	1060	1113	1.1277098518757595e+04
C1060_1113	1060	1113	7.8514768690479357e-11
R1060_1114	1060	1114	4.9655578163271121e+03
C1060_1114	1060	1114	1.7831204759889800e-10
R1060_1155	1060	1155	5.2006242954346899e+03
C1060_1155	1060	1155	1.7025240267351270e-10
R1060_1156	1060	1156	5.4880475193432821e+03
C1060_1156	1060	1156	1.6133584459304247e-10
R1060_1157	1060	1157	4.6618297680065343e+03
C1060_1157	1060	1157	1.8992945383302102e-10
R1061_1063	1061	1063	4.9551966918816997e+03
C1061_1063	1061	1063	1.7868489118718897e-10
R1061_1107	1061	1107	3.4240604702833111e+03
C1061_1107	1061	1107	2.5858736707028411e-10
R1061_1112	1061	1112	3.4419357116612100e+03
C1061_1112	1061	1112	2.5724442751798612e-10
R1061_1154	1061	1154	2.1308484723201832e+03
C1061_1154	1061	1154	4.1552404744008298e-10
R1061_1156	1061	1156	5.0404005770865315e+03
C1061_1156	1061	1156	1.7566436797207746e-10
R1061_1157	1061	1157	6.2826872347384997e+03
C1061_1157	1061	1157	1.4092994742827641e-10
R1062_1107	1062	1107	1.2836728417572513e+04
C1062_1107	1062	1107	6.8975423713718876e-11
R1062_1113	1062	1113	8.2354012189829918e+03
C1062_1113	1062	1113	1.0751373954423345e-10
R1062_1116	1062	1116	1.1223555396727270e+04
C1062_1116	1062	1116	7.8889331446449106e-11
R1062_1117	1062	1117	1.2574630619123958e+04
C1062_1117	1062	1117	7.0413104648451673e-11
R1062_1157	1062	1157	6.3571336610279259e+03
C1062_1157	1062	1157	1.3927956039811044e-10
R1063_1068	1063	1068	7.6168369506321933e+03
C1063_1068	1063	1068	1.1624494359519024e-10
R1063_1095	1063	1095	1.6767907992330202e+03
C1063_1095	1063	1095	5.2804367849883182e-10
R1063_1096	1063	1096	3.8906534177215403e+03
C1063_1096	1063	1096	2.2757585593900638e-10
R1063_1107	1063	1107	2.8533855115916649e+03
C1063_1107	1063	1107	3.1030464621869447e-10
R1063_1109	1063	1109	7.8120548653308651e+03
C1063_1109	1063	1109	1.1334006186123987e-10
R1063_1154	1063	1154	5.3639743753674575e+03
C1063_1154	1063	1154	1.6506767552172444e-10
R1063_1158	1063	1158	4.8630004849181432e+03
C1063_1158	1063	1158	1.8207252589136931e-10
R1064_1065	1064	1065	6.2815285934737944e-06
C1064_1065	1064	1065	1.5505153632635496e-10
R1064_1074	1064	1074	5.3887674118596997e+03
C1064_1074	1064	1074	1.6430822004886570e-10
R1064_1111	1064	1111	1.2506423246555624e-06
C1064_1111	1064	1111	7.0797122746013912e-11
R1064_1136	1064	1136	4.8254277113576730e-06
C1064_1136	1064	1136	2.0183923937014231e-10
R1064_1138	1064	1138	7.1441068548544035e+03
C1064_1138	1064	1138	1.2393694546972795e-10
R1064_1139	1064	1139	9.0910404096085138e-06
C1064_1139	1064	1139	1.5583145435121886e-10
R1064_1159	1064	1159	1.1603255144122110e-05
C1064_1159	1064	1159	1.2209246724292201e-10
R1065_1066	1065	1066	1.9533321621628395e-06
C1065_1066	1065	1066	4.5328633749603265e-11
R1065_1074	1065	1074	4.6509074028443792e+03
C1065_1074	1065	1074	1.9037549127692800e-10
R1065_1088	1065	1088	7.6852904489857617e-06
C1065_1088	1065	1088	1.6513367458289770e-10
R1065_1111	1065	1111	7.0494653576106104e-06
C1065_1111	1065	1111	1.2560084159348354e-11
R1065_1159	1065	1159	1.0051908211033212e-05
C1065_1159	1065	1159	6.7531562293054241e-11
R1065_1160	1065	1160	1.0246711190465736e-05
C1065_1160	1065	1160	8.6410045647022454e-12
R1066_1078	1066	1078	8.8747855845875210e-06
C1066_1078	1066	1078	9.9767906870637042e-12
R1066_1088	1066	1088	9.3314474692729804e-06
C1066_1088	1066	1088	9.4885470299816596e-12
R1066_1111	1066	1111	1.0933087342622454e-05
C1066_1111	1066	1111	8.0985247254744790e-12
R1066_1160	1066	1160	1.1834911414813768e-05
C1066_1160	1066	1160	7.4814145257709367e-12
R1067_1072	1067	1072	2.4313392853905830e+03
C1067_1072	1067	1072	3.6416915854578544e-10
R1067_1073	1067	1073	2.7856708549431037e+03
C1067_1073	1067	1073	3.1784759499811199e-10
R1067_1093	1067	1093	2.2432108601020223e+03
C1067_1093	1067	1093	3.9471045609137717e-10
R1067_1095	1067	1095	9.7631674848722905e+03
C1067_1095	1067	1095	9.0689705269517057e-11
R1067_1096	1067	1096	3.4082920846749880e+03
C1067_1096	1067	1096	2.5978371562730448e-10
R1067_1161	1067	1161	8.3971245832482145e+03
C1067_1161	1067	1161	1.0544309220639172e-10
R1068_1069	1068	1069	5.5897251628633312e+03
C1068_1069	1068	1069	1.5840112991287840e-10
R1068_1107	1068	1107	5.7471386053406541e+03
C1068_1107	1068	1107	1.5406254181467023e-10
R1068_1109	1068	1109	3.6035603627900418e+03
C1068_1109	1068	1109	2.4570666023600841e-10
R1068_1115	1068	1115	7.9025927154981264e+03
C1068_1115	1068	1115	1.1204155567369248e-10
R1068_1116	1068	1116	1.4830932808929683e+04
C1068_1116	1068	1116	5.9700815390849234e-11
R1068_1164	1068	1164	7.8135858216054085e+03
C1068_1164	1068	1164	1.1331785455683117e-10
R1069_1083	1069	1083	6.7866400210007969e+03
C1069_1083	1069	1083	1.3046496925726599e-10
R1069_1115	1069	1115	3.1356161080696597e+03
C1069_1115	1069	1115	2.8237473950377161e-10
R1069_1116	1069	1116	7.8367241998151740e+03
C1069_1116	1069	1116	1.1298327708417789e-10
R1069_1119	1069	1119	5.2369108227802417e+03
C1069_1119	1069	1119	1.6907272467739621e-10
R1069_1164	1069	1164	5.8979970294964214e+03
C1069_1164	1069	1164	1.5012194432651288e-10
R1070_1071	1070	1071	1.4249873241979656e+04
C1070_1071	1070	1071	6.2135204058628780e-11
R1070_1074	1070	1074	8.2085085744538283e+03
C1070_1074	1070	1074	1.0786597512434385e-10
R1070_1075	1070	1075	7.5877769004919746e+03
C1070_1075	1070	1075	1.1669014433497531e-10
R1070_1076	1070	1076	6.6306558302515250e+03
C1070_1076	1070	1076	1.3353411854984077e-10
R1070_1088	1070	1088	8.1630882074778456e+03
C1070_1088	1070	1088	1.0846615388633275e-10
R1070_1089	1070	1089	9.2106499195469387e+03
C1070_1089	1070	1089	9.6129891965707545e-11
R1070_1091	1070	1091	3.6608694136619310e+03
C1070_1091	1070	1091	2.4186024729418697e-10
R1070_1165	1070	1165	4.4112963730577940e+03
C1070_1165	1070	1165	2.0071623097186082e-10
R1071_1073	1071	1073	3.8581160394290105e+03
C1071_1073	1071	1073	2.2949511436442940e-10
R1071_1075	1071	1075	5.0393602372340283e+03
C1071_1075	1071	1075	1.7570063262355367e-10
R1071_1076	1071	1076	1.0692683384081140e+04
C1071_1076	1071	1076	8.2806041280356072e-11
R1071_1093	1071	1093	8.8620303166105878e+03
C1071_1093	1071	1093	9.9911504482264220e-11
R1071_1100	1071	1100	1.1051625442679360e+04
C1071_1100	1071	1100	8.0116611469718691e-11
R1071_1101	1071	1101	4.6077042560108839e+03
C1071_1101	1071	1101	1.9216050607956134e-10
R1071_1110	1071	1110	4.3548656650519533e+03
C1071_1110	1071	1110	2.0331712842615024e-10
R1071_1121	1071	1121	1.5903715631954488e+04
C1071_1121	1071	1121	5.5673705578649506e-11
R1071_1161	1071	1161	9.3199782131307002e+03
C1071_1161	1071	1161	9.5002237285550115e-11
R1071_1165	1071	1165	7.6810494050392090e+03
C1071_1165	1071	1165	1.1527315279590762e-10
R1071_1166	1071	1166	6.9947645899617955e+03
C1071_1166	1071	1166	1.2658307085425960e-10
R1071_1167	1071	1167	9.5103556719116168e+03
C1071_1167	1071	1167	9.3100490901201767e-11
R1072_1073	1072	1073	1.2440290263707934e+03
C1072_1073	1072	1073	7.1173482525808332e-10
R1072_1076	1072	1076	1.9662218883967846e+03
C1072_1076	1072	1076	4.5031478233718157e-10
R1072_1096	1072	1096	2.2736120633742844e+03
C1072_1096	1072	1096	3.8943265474495396e-10
R1072_1108	1072	1108	1.0912780540084959e+03
C1072_1108	1072	1108	8.1135946832951402e-10
R1072_1109	1072	1109	2.4097837315442798e+03
C1072_1109	1072	1109	3.6742665746713729e-10
R1072_1161	1072	1161	1.7944598985370894e+03
C1072_1161	1072	1161	4.9341798187957649e-10
R1072_1162	1072	1162	4.3412854251743747e+03
C1072_1162	1072	1162	2.0395313714357674e-10
R1072_1167	1072	1167	3.3447819512996684e+03
C1072_1167	1072	1167	2.6471644328143914e-10
R1073_1076	1073	1076	4.0351520150954270e+03
C1073_1076	1073	1076	2.1942637560807259e-10
R1073_1093	1073	1093	6.5662560260142009e+03
C1073_1093	1073	1093	1.3484377980269835e-10
R1073_1161	1073	1161	4.6529390105630600e+03
C1073_1161	1073	1161	1.9029236783244536e-10
R1073_1167	1073	1167	7.1771375724969002e+03
C1073_1167	1073	1167	1.2336656121696243e-10
R1074_1075	1074	1075	1.2122144475071939e+03
C1074_1075	1074	1075	7.3041431202274594e-10
R1074_1088	1074	1088	2.6765809020547345e+03
C1074_1088	1074	1088	3.3080217415445557e-10
R1074_1138	1074	1138	2.4658073625621569e+03
C1074_1138	1074	1138	3.5907865113192951e-10
R1074_1159	1074	1159	1.9425630047027853e+03
C1074_1159	1074	1159	4.5579926085098602e-10
R1074_1165	1074	1165	4.2197905598460893e+03
C1074_1165	1074	1165	2.0982529088654444e-10
R1074_1168	1074	1168	6.2297111811421682e+03
C1074_1168	1074	1168	1.4212838379734732e-10
R1075_1110	1075	1110	6.3412270100420455e+03
C1075_1110	1075	1110	1.3962893621342368e-10
R1075_1138	1075	1138	7.1090086853832945e+03
C1075_1138	1075	1138	1.2454883949157269e-10
R1075_1165	1075	1165	3.3177626157217001e+03
C1075_1165	1075	1165	2.6687225225346583e-10
R1075_1168	1075	1168	7.1479955065793902e+03
C1075_1168	1075	1168	1.2386952130635984e-10
R1076_1079	1076	1079	5.4179542738162618e+03
C1076_1079	1076	1079	1.6342308128716170e-10
R1076_1091	1076	1091	5.8497638074771203e+03
C1076_1091	1076	1091	1.5135974901555253e-10
R1076_1108	1076	1108	7.1782047371563276e+03
C1076_1108	1076	1108	1.2334822063751306e-10
R1076_1165	1076	1165	1.0349067249634987e+04
C1076_1165	1076	1165	8.5555418700291951e-11
R1076_1167	1076	1167	2.7055248337469211e+03
C1076_1167	1076	1167	3.2726322473771949e-10
R1076_1169	1076	1169	7.6508085972879489e+03
C1076_1169	1076	1169	1.1572878479980044e-10
R1077_1089	1077	1089	2.5981106087183560e-06
C1077_1089	1077	1089	3.4079333602227794e-11
R1077_1078	1077	1078	5.7987898795308081e-06
C1077_1078	1077	1078	1.5269026815843879e-11
R1077_1087	1077	1087	1.0139989851198285e-05
C1077_1087	1077	1087	8.7319493874578831e-12
R1077_1090	1077	1090	4.3342710301681397e-06
C1077_1090	1077	1090	2.0428320599638458e-11
R1077_1171	1077	1171	7.8597847597934988e-06
C1077_1171	1077	1171	1.1265178484649275e-11
R1078_1088	1078	1088	2.5649791307845701e-06
C1078_1088	1078	1088	3.4519531604499645e-11
R1078_1089	1078	1089	4.6549958727387057e-06
C1078_1089	1078	1089	1.9020828501381152e-11
R1078_1160	1078	1160	9.9608605034994574e-06
C1078_1160	1078	1160	8.8889788325911598e-12
R1078_1171	1078	1171	7.6300815550410846e-06
C1078_1171	1078	1171	1.1604316091680784e-11
R1079_1080	1079	1080	3.3097629560262180e+03
C1079_1080	1079	1080	2.6751727947401265e-10
R1079_1081	1079	1081	3.7439132114402928e+03
C1079_1081	1079	1081	2.3649554134813322e-10
R1079_1082	1079	1082	1.7059341134546150e+03
C1079_1082	1079	1082	5.1902284778570720e-10
R1079_1091	1079	1091	2.6333830146394412e+03
C1079_1091	1079	1091	3.3622863699575826e-10
R1079_1092	1079	1092	2.0599134895930479e+03
C1079_1092	1079	1092	4.2983299355689042e-10
R1079_1108	1079	1108	3.5783063025066272e+03
C1079_1108	1079	1108	2.4744074622112655e-10
R1079_1169	1079	1169	3.8048930786624533e+03
C1079_1169	1079	1169	2.3270529904384442e-10
R1079_1172	1079	1172	4.1120499438600364e+03
C1079_1172	1079	1172	2.1532296392024011e-10
R1080_1081	1080	1081	5.0331429534376430e+03
C1080_1081	1080	1081	1.7591767011013621e-10
R1080_1082	1080	1082	1.5278201965004125e+03
C1080_1082	1080	1082	5.7953074827006383e-10
R1080_1084	1080	1084	4.8261659283362633e-06
C1080_1084	1080	1084	2.6296241590586316e-10
R1080_1086	1080	1086	1.1779689375682148e-06
C1080_1086	1080	1086	7.5164866700801832e-11
R1080_1090	1080	1090	3.2351331015260442e-06
C1080_1090	1080	1090	2.7368851726141942e-11
R1080_1092	1080	1092	8.0100150842865246e-06
C1080_1092	1080	1092	1.2159286201678771e-10
R1080_1172	1080	1172	4.6656306799324366e-06
C1080_1172	1080	1172	2.0875219787223778e-10
R1080_1173	1080	1173	6.6149729763756477e-06
C1080_1173	1080	1173	1.4723577290102154e-10
R1081_1082	1081	1082	1.2436220078171004e+03
C1081_1082	1081	1082	7.1196776523290557e-10
R1081_1083	1081	1083	3.2396775595099207e+03
C1081_1083	1081	1083	2.7330460066956201e-10
R1081_1084	1081	1084	5.7253687953552608e+03
C1081_1084	1081	1084	1.5464834028129355e-10
R1081_1108	1081	1108	2.1865034731578507e+03
C1081_1108	1081	1108	4.0494734747493307e-10
R1081_1115	1081	1115	2.5423875162168733e+03
C1081_1115	1081	1115	3.4826271606994126e-10
R1081_1173	1081	1173	6.2074986608445361e+03
C1081_1173	1081	1173	1.4263696700975814e-10
R1082_1084	1082	1084	1.2304041197160857e+04
C1082_1084	1082	1084	7.1961623625277628e-11
R1082_1108	1082	1108	2.8473209301840543e+03
C1082_1108	1082	1108	3.1096557199218337e-10
R1082_1115	1082	1115	7.0761592680267831e+03
C1082_1115	1082	1115	1.2512702840094535e-10
R1082_1169	1082	1169	5.3673225895684327e+03
C1082_1169	1082	1169	1.6496470389554014e-10
R1082_1170	1082	1170	1.8154985939482413e+03
C1082_1170	1082	1170	4.8770006468275066e-10
R1082_1172	1082	1172	2.1932122813453057e+03
C1082_1172	1082	1172	4.0370865566961372e-10
R1082_1173	1082	1173	2.3715499722278350e+03
C1082_1173	1082	1173	3.7335025281724816e-10
R1083_1084	1083	1084	4.7353891261606850e+03
C1083_1084	1083	1084	1.8697909677760138e-10
R1083_1115	1083	1115	1.6721316587000676e+03
C1083_1115	1083	1115	5.2951499189264421e-10
R1083_1119	1083	1119	7.3092392426255938e+03
C1083_1119	1083	1119	1.2113692715603925e-10
R1083_1118	1083	1118	4.6387944488158500e+03
C1083_1118	1083	1118	1.9087260525760561e-10
R1083_1173	1083	1173	5.3931730545716018e+03
C1083_1173	1083	1173	1.6417399789340372e-10
R1084_1085	1084	1085	2.8220054411165407e-06
C1084_1085	1084	1085	3.1375516460722329e-11
R1084_1086	1084	1086	5.0980370168962089e-06
C1084_1086	1084	1086	1.7367837439498652e-11
R1084_1118	1084	1118	8.6387921623638925e-06
C1084_1118	1084	1118	6.1496012263015782e-11
R1084_1173	1084	1173	5.6051944332013547e-06
C1084_1173	1084	1173	2.2641502756096759e-10
R1084_1174	1084	1174	6.1258494738613538e-06
C1084_1174	1084	1174	1.4453812250497356e-11
R1085_1086	1085	1086	1.0523813226579148e-05
C1085_1086	1085	1086	8.4134786758070672e-12
R1085_1120	1085	1120	2.1360933750369586e-05
C1085_1120	1085	1120	4.1450378155153474e-12
R1085_1118	1085	1118	1.5913895644025340e-05
C1085_1118	1085	1118	5.5638091483427491e-12
R1085_1174	1085	1174	6.6092079903661890e-06
C1085_1174	1085	1174	1.3396745615974217e-11
R1086_1087	1086	1087	5.6383052912078396e-06
C1086_1087	1086	1087	1.5703633201286364e-11
R1086_1090	1086	1090	2.7162104910769923e-06
C1086_1090	1086	1090	3.2597576093925136e-11
R1086_1172	1086	1172	3.3508708625788631e-06
C1086_1172	1086	1172	2.6423542356943388e-11
R1086_1173	1086	1173	3.9672837623900285e-06
C1086_1173	1086	1173	2.2318009870980173e-11
R1086_1174	1086	1174	2.4952507828753853e-06
C1086_1174	1086	1174	3.5484160060244275e-11
R1086_1175	1086	1175	3.7579417670720461e-06
C1086_1175	1086	1175	2.3561269348509975e-11
R1087_1090	1087	1090	4.4387183075000176e-07
C1087_1090	1087	1090	1.9947622722620734e-10
R1087_1171	1087	1171	1.2884656529161150e-05
C1087_1171	1087	1171	6.8718850184021535e-12
R1087_1175	1087	1175	6.6253748399667585e-06
C1087_1175	1087	1175	1.3364055666085793e-11
R1088_1089	1088	1089	4.6483728902506379e-06
C1088_1089	1088	1089	2.7302031959175228e-10
R1088_1091	1088	1091	7.9813810965930061e+03
C1088_1091	1088	1091	1.1093553496373663e-10
R1088_1159	1088	1159	1.0106943121203731e-05
C1088_1159	1088	1159	1.4016800447040317e-10
R1088_1160	1088	1160	5.5088727623465660e-06
C1088_1160	1088	1160	1.6072594519733396e-11
R1088_1165	1088	1165	8.8591812581373615e+03
C1088_1165	1088	1165	9.9943635410633760e-11
R1088_1171	1088	1171	1.0047578328088285e-05
C1088_1171	1088	1171	8.8122605546133149e-12
R1088_1176	1088	1176	9.5577434791575912e-06
C1088_1176	1088	1176	1.0190278291313620e-10
R1089_1090	1089	1090	5.1958126929900927e-06
C1089_1090	1089	1090	1.7041006556963821e-11
R1089_1091	1089	1091	3.5779866229456984e+03
C1089_1091	1089	1091	2.4746285411515853e-10
R1089_1092	1089	1092	9.9104569748803385e-06
C1089_1092	1089	1092	1.4294699550038664e-10
R1089_1171	1089	1171	8.3102067920300059e-06
C1089_1171	1089	1171	1.0654593848966198e-11
R1089_1176	1089	1176	9.9665541101586757e-06
C1089_1176	1089	1176	6.8109906193711038e-11
R1090_1092	1090	1092	5.7160553451661674e-07
C1090_1092	1090	1092	1.5490031643041429e-10
R1090_1171	1090	1171	7.5442698348012605e-06
C1090_1171	1090	1171	1.1736308497551569e-11
R1090_1172	1090	1172	5.3217413883258612e-06
C1090_1172	1090	1172	1.6637764165735596e-11
R1090_1175	1090	1175	4.6873106540622924e-06
C1090_1175	1090	1175	1.8889697036244985e-11
R1090_1176	1090	1176	8.0226541566865291e-06
C1090_1176	1090	1176	1.1036481997195935e-11
R1091_1092	1091	1092	3.6759945374973086e+03
C1091_1092	1091	1092	2.4086509723238349e-10
R1091_1165	1091	1165	3.1757995879405275e+03
C1091_1165	1091	1165	2.7880184412838992e-10
R1091_1167	1091	1167	1.2565297306671930e+04
C1091_1167	1091	1167	7.0465406435696489e-11
R1091_1169	1091	1169	3.6597995823367460e+03
C1091_1169	1091	1169	2.4193094779650986e-10
R1091_1172	1091	1172	9.5843673212013182e+03
C1091_1172	1091	1172	9.2381557595501290e-11
R1091_1176	1091	1176	2.3308233862536631e+03
C1091_1176	1091	1176	3.7987381923567158e-10
R1092_1172	1092	1172	8.7592691023423166e-06
C1092_1172	1092	1172	1.6173381957361753e-10
R1092_1176	1092	1176	1.2695627633436467e-05
C1092_1176	1092	1176	7.6716227587749947e-11
R1093_1094	1093	1094	1.9556528093698005e+03
C1093_1094	1093	1094	4.5274845179974565e-10
R1093_1095	1093	1095	4.4907093129003679e+03
C1093_1095	1093	1095	1.9716679927522274e-10
R1093_1096	1093	1096	4.1194970163800408e+03
C1093_1096	1093	1096	2.1493371112526046e-10
R1093_1101	1093	1101	2.0503147789729396e+03
C1093_1101	1093	1101	4.3184529067460138e-10
R1093_1161	1093	1161	2.6289077528844214e+03
C1093_1161	1093	1161	3.3680100822424223e-10
R1093_1181	1093	1181	3.5329231726357461e+03
C1093_1181	1093	1181	2.5061931393187678e-10
R1094_1095	1094	1095	2.9852698963027638e+03
C1094_1095	1094	1095	2.9659588997181975e-10
R1094_1099	1094	1099	3.1265471845930892e+03
C1094_1099	1094	1099	2.8319380115647765e-10
R1094_1101	1094	1101	7.2503893684606419e+03
C1094_1101	1094	1101	1.2212016992516181e-10
R1094_1104	1094	1104	3.3554727155371061e+03
C1094_1104	1094	1104	2.6387303869293194e-10
R1094_1105	1094	1105	3.4230297268721674e+03
C1094_1105	1094	1105	2.5866523295112069e-10
R1094_1106	1094	1106	2.4903806527289635e+03
C1094_1106	1094	1106	3.5553552053568867e-10
R1094_1181	1094	1181	3.1772518660846786e+03
C1094_1181	1094	1181	2.7867440763866796e-10
R1095_1096	1095	1096	1.7542398829270423e+03
C1095_1096	1095	1096	5.0473073284745513e-10
R1095_1106	1095	1106	1.8839349608889470e+03
C1095_1106	1095	1106	4.6998373090449443e-10
R1095_1154	1095	1154	4.6782844955978644e+03
C1095_1154	1095	1154	1.8926142318474958e-10
R1095_1158	1095	1158	2.8430784391494803e+03
C1095_1158	1095	1158	3.1142960022055427e-10
R1095_1181	1095	1181	6.4556443698312432e+03
C1095_1181	1095	1181	1.3715420660991986e-10
R1096_1109	1096	1109	1.3752205065512308e+03
C1096_1109	1096	1109	6.4383768092612840e-10
R1096_1158	1096	1158	1.0196964213144862e+03
C1096_1158	1096	1158	8.6831606269502287e-10
R1096_1161	1096	1161	1.4264233942394403e+03
C1096_1161	1096	1161	6.2072648645257201e-10
R1096_1162	1096	1162	7.5334073638060590e+02
C1096_1162	1096	1162	1.1753231160098382e-09
R1096_1181	1096	1181	2.1789053626820883e+03
C1096_1181	1096	1181	4.0635944858573763e-10
R1097_1098	1097	1098	1.8975941678082338e+03
C1097_1098	1097	1098	4.6660070773862033e-10
R1097_1099	1097	1099	2.1195946851588174e+03
C1097_1099	1097	1099	4.1773023300143690e-10
R1097_1106	1097	1106	2.4645359622409346e+03
C1097_1106	1097	1106	3.5926389197214770e-10
R1097_1145	1097	1145	7.2524789688203134e+02
C1097_1145	1097	1145	1.2208498439038182e-09
R1097_1146	1097	1146	1.3655425294717525e+03
C1097_1146	1097	1146	6.4840073640365955e-10
R1097_1151	1097	1151	2.9330802436766767e+03
C1097_1151	1097	1151	3.0187335774697703e-10
R1097_1154	1097	1154	2.0547820170120544e+03
C1097_1154	1097	1154	4.3090642918294815e-10
R1097_1182	1097	1182	1.2070080692645952e+03
C1097_1182	1097	1182	7.3356492325645135e-10
R1098_1099	1098	1099	2.0424902551418918e+03
C1098_1099	1098	1099	4.3349963578577271e-10
R1098_1103	1098	1103	2.8976289074900033e+03
C1098_1103	1098	1103	3.0556665810839502e-10
R1098_1105	1098	1105	1.5403539636355802e+03
C1098_1105	1098	1105	5.7481514158616737e-10
R1098_1150	1098	1150	3.0154370247621814e+03
C1098_1150	1098	1150	2.9362867618494878e-10
R1098_1151	1098	1151	9.1130867852745860e+02
C1098_1151	1098	1151	9.7159041997790162e-10
R1098_1152	1098	1152	1.2195842719132031e+03
C1098_1152	1098	1152	7.2600049220954095e-10
R1098_1182	1098	1182	1.6070126949934513e+03
C1098_1182	1098	1182	5.5097186503782288e-10
R1099_1105	1099	1105	1.5183789445136838e+03
C1099_1105	1099	1105	5.8313425966505863e-10
R1099_1106	1099	1106	1.5306954633758558e+03
C1099_1106	1099	1106	5.7844215448791017e-10
R1099_1182	1099	1182	2.9364296149718707e+03
C1099_1182	1099	1182	3.0152903280417357e-10
R1100_1101	1100	1101	1.3408574639738943e+03
C1100_1101	1100	1101	6.6033773573209461e-10
R1100_1102	1100	1102	1.1100549393375532e+03
C1100_1102	1100	1102	7.9763509923967444e-10
R1100_1104	1100	1104	1.5945354378319437e+03
C1100_1104	1100	1104	5.5528322588043912e-10
R1100_1121	1100	1121	7.7860406160783089e+02
C1100_1121	1100	1121	1.1371874683925932e-09
R1100_1123	1100	1123	8.4494788724344050e+02
C1100_1123	1100	1123	1.0478975035828444e-09
R1100_1132	1100	1132	2.6520802752827803e+03
C1100_1132	1100	1132	3.3385821309861802e-10
R1100_1183	1100	1183	3.2427578522124927e+03
C1100_1183	1100	1183	2.7304498888064986e-10
R1101_1104	1101	1104	2.1798613528197970e+03
C1101_1104	1101	1104	4.0618123742349553e-10
R1101_1110	1101	1110	5.3309280860981662e+03
C1101_1110	1101	1110	1.6609092589505541e-10
R1101_1121	1101	1121	4.0482810377800538e+03
C1101_1121	1101	1121	2.1871475162839362e-10
R1101_1161	1101	1161	3.1644025570750946e+03
C1101_1161	1101	1161	2.7980598730093501e-10
R1101_1163	1101	1163	3.1196270330058160e+03
C1101_1163	1101	1163	2.8382199933909512e-10
R1101_1166	1101	1166	2.3281066805849541e+03
C1101_1166	1101	1166	3.8031710019299115e-10
R1101_1181	1101	1181	1.2840567827128532e+03
C1101_1181	1101	1181	6.8954799633498888e-10
R1101_1183	1101	1183	1.2993434263779652e+03
C1101_1183	1101	1183	6.8143553407445432e-10
R1102_1103	1102	1103	1.6068928977237529e+03
C1102_1103	1102	1103	5.5101294115758530e-10
R1102_1104	1102	1104	9.2892739008281251e+02
C1102_1104	1102	1104	9.5316253041162487e-10
R1102_1126	1102	1126	1.0022668065718616e+03
C1102_1126	1102	1126	8.8341624794347243e-10
R1102_1131	1102	1131	1.9533076768583780e+03
C1102_1131	1102	1131	4.5329201957782304e-10
R1102_1132	1102	1132	7.7616604020679790e+02
C1102_1132	1102	1132	1.1407594971097850e-09
R1102_1121	1102	1121	2.8805106509016191e+03
C1102_1121	1102	1121	3.0738257517737629e-10
R1102_1179	1102	1179	9.9256064452128658e+02
C1102_1179	1102	1179	8.9205509667073163e-10
R1102_1180	1102	1180	2.0300387012251770e+03
C1102_1180	1102	1180	4.3615857232949726e-10
R1102_1183	1102	1183	2.3064729815014130e+03
C1102_1183	1102	1183	3.8388430681881690e-10
R1102_1184	1102	1184	1.9058447754853080e+03
C1102_1184	1102	1184	4.6458074292778396e-10
R1103_1104	1103	1104	4.0840493565265174e+03
C1103_1104	1103	1104	2.1679923634739033e-10
R1103_1105	1103	1105	2.7336359330061991e+03
C1103_1105	1103	1105	3.2389784279953419e-10
R1103_1130	1103	1130	3.9627990573481766e+03
C1103_1130	1103	1130	2.2343267192874120e-10
R1103_1131	1103	1131	1.7164347029918290e+03
C1103_1131	1103	1131	5.1584763472602366e-10
R1103_1152	1103	1152	1.3231112363138025e+03
C1103_1152	1103	1152	6.6919451471577195e-10
R1103_1179	1103	1179	6.3794292383846696e+03
C1103_1179	1103	1179	1.3879278985845390e-10
R1103_1184	1103	1184	5.5073199332757686e+03
C1103_1184	1103	1184	1.6077126305123708e-10
R1104_1105	1104	1105	2.3228342427450307e+03
C1104_1105	1104	1105	3.8118035519127202e-10
R1104_1181	1104	1181	4.4782803950719044e+03
C1104_1181	1104	1181	1.9771401153763250e-10
R1104_1183	1104	1183	3.6398422319835795e+03
C1104_1183	1104	1183	2.4325746152395165e-10
R1104_1184	1104	1184	3.0076282496490762e+03
C1104_1184	1104	1184	2.9439103114000506e-10
R1105_1106	1105	1106	2.4657996860198200e+03
C1105_1106	1105	1106	3.5907976901773489e-10
R1105_1152	1105	1152	2.1910564185885314e+03
C1105_1152	1105	1152	4.0410587978851909e-10
R1105_1181	1105	1181	4.2372141841382218e+03
C1105_1181	1105	1181	2.0896247940793664e-10
R1105_1182	1105	1182	1.0534119140021323e+03
C1105_1182	1105	1182	8.4052474623730901e-10
R1105_1184	1105	1184	1.3334533974147066e+03
C1105_1184	1105	1184	6.6400429397581204e-10
R1105_1185	1105	1185	4.4140636338197237e+03
C1105_1185	1105	1185	2.0059039813474556e-10
R1105_1186	1105	1186	6.3989437360522998e+03
C1105_1186	1105	1186	1.3836952131825455e-10
R1106_1154	1106	1154	1.6501949322376433e+03
C1106_1154	1106	1154	5.3655405455607796e-10
R1106_1158	1106	1158	3.7049479968104461e+03
C1106_1158	1106	1158	2.3898278260916171e-10
R1106_1181	1106	1181	4.5395190665139025e+03
C1106_1181	1106	1181	1.9504682516510549e-10
R1106_1182	1106	1182	1.7004409576174955e+03
C1106_1182	1106	1182	5.2069951487205354e-10
R1106_1186	1106	1186	3.0779479826150564e+03
C1106_1186	1106	1186	2.8766528437161538e-10
R1107_1109	1107	1109	5.6658245082557651e+03
C1107_1109	1107	1109	1.5627359802793786e-10
R1107_1116	1107	1116	2.9077786805806627e+03
C1107_1116	1107	1116	3.0450005965488008e-10
R1107_1154	1107	1154	4.8243927868813353e+03
C1107_1154	1107	1154	1.8352957995204356e-10
R1107_1157	1107	1157	1.5486845440801037e+03
C1107_1157	1107	1157	5.7172313437526189e-10
R1107_1158	1107	1158	6.3434086286889105e+03
C1107_1158	1107	1158	1.3958091517162802e-10
R1107_1164	1107	1164	3.4828955633938162e+03
C1107_1164	1107	1164	2.5421915919787940e-10
R1107_1187	1107	1187	4.0338080647287006e+03
C1107_1187	1107	1187	2.1949948224905200e-10
R1108_1109	1108	1109	1.5913260693235015e+03
C1108_1109	1108	1109	5.5640311484145159e-10
R1108_1115	1108	1115	2.1348426685545855e+03
C1108_1115	1108	1115	4.1474662032096296e-10
R1108_1161	1108	1161	4.1578673963443671e+03
C1108_1161	1108	1161	2.1295022118273130e-10
R1108_1162	1108	1162	4.2374851765618469e+03
C1108_1162	1108	1162	2.0894911599865445e-10
R1108_1167	1108	1167	2.4278764033294265e+03
C1108_1167	1108	1167	3.6468857330867266e-10
R1108_1169	1108	1169	1.7749996468018956e+03
C1108_1169	1108	1169	4.9882758190701775e-10
R1108_1170	1108	1170	2.2316808114481987e+03
C1108_1170	1108	1170	3.9674973999773190e-10
R1108_1188	1108	1188	1.0304221734305970e+03
C1108_1188	1108	1188	8.5927768688455595e-10
R1109_1115	1109	1115	1.2984494642141251e+03
C1109_1115	1109	1115	6.8190469179013589e-10
R1109_1158	1109	1158	2.1596542594568209e+03
C1109_1158	1109	1158	4.0998172639109993e-10
R1109_1162	1109	1162	8.6518980996532218e+02
C1109_1162	1109	1162	1.0233809639245387e-09
R1109_1164	1109	1164	1.6644426019103112e+03
C1109_1164	1109	1164	5.3196113863210942e-10
R1109_1187	1109	1187	1.7957848226710564e+03
C1109_1187	1109	1187	4.9305393971590931e-10
R1109_1188	1109	1188	1.0253437811309273e+03
C1109_1188	1109	1188	8.6353357575681227e-10
R1110_1121	1110	1121	1.1149886570524588e+03
C1110_1121	1110	1121	7.9410564053688145e-10
R1110_1122	1110	1122	1.7090601929914553e+03
C1110_1122	1110	1122	5.1807349169499191e-10
R1110_1134	1110	1134	1.5086104658034462e+03
C1110_1134	1110	1134	5.8691014133224210e-10
R1110_1137	1110	1137	1.1179944546503843e+03
C1110_1137	1110	1137	7.9197063815212345e-10
R1110_1138	1110	1138	1.4184007226740732e+03
C1110_1138	1110	1138	6.2423740170601690e-10
R1110_1165	1110	1165	3.1300478249230223e+03
C1110_1165	1110	1165	2.8287707767588989e-10
R1110_1166	1110	1166	9.8667401692391797e+02
C1110_1166	1110	1166	8.9737721528373273e-10
R1110_1168	1110	1168	1.6990180641182908e+03
C1110_1168	1110	1168	5.2113559025606360e-10
R1110_1178	1110	1178	1.3848277690273226e+03
C1110_1178	1110	1178	6.3937104779600276e-10
R1110_1183	1110	1183	4.0053259256247879e+03
C1110_1183	1110	1183	2.2106035766911633e-10
R1110_1189	1110	1189	1.0503783977503394e+03
C1110_1189	1110	1189	8.4295220046066862e-10
R1111_1136	1111	1136	3.1328857004579165e-06
C1111_1136	1111	1136	2.8262083789733644e-11
R1111_1139	1111	1139	2.6022078191315801e-06
C1111_1139	1111	1139	3.4025675243550906e-11
R1111_1140	1111	1140	2.6867714478272642e-06
C1111_1140	1111	1140	3.2954748808873181e-11
R1111_1159	1111	1159	2.9644174518682082e-06
C1111_1159	1111	1159	2.9868221870775981e-11
R1111_1160	1111	1160	3.4917161364596395e-06
C1111_1160	1111	1160	2.5357696533652184e-11
R1111_1191	1111	1191	3.0667382487336839e-06
C1111_1191	1111	1191	2.8871677655098435e-11
R1112_1114	1112	1114	2.0994426689091738e+03
C1112_1114	1112	1114	4.2173991927107251e-10
R1112_1145	1112	1145	9.8257777330839679e+02
C1112_1145	1112	1145	9.0111826844886092e-10
R1112_1148	1112	1148	1.3964961906862954e+03
C1112_1148	1112	1148	6.3402878404191629e-10
R1112_1154	1112	1154	2.6304840026947095e+03
C1112_1154	1112	1154	3.3659918889184006e-10
R1112_1155	1112	1155	2.4373717985739431e+03
C1112_1155	1112	1155	3.6326783719169992e-10
R1112_1156	1112	1156	1.3241526927317054e+03
C1112_1156	1112	1156	6.6866818801190938e-10
R1112_1192	1112	1192	1.7133754359153615e+03
C1112_1192	1112	1192	5.1676869128625616e-10
R1112_1194	1112	1194	1.8176321571853298e+03
C1112_1194	1112	1194	4.8712759520666900e-10
R1112_1195	1112	1195	2.9395224638788609e+03
C1112_1195	1112	1195	3.0121177591942654e-10
R1113_1114	1113	1114	4.9505490492408117e+03
C1113_1114	1113	1114	1.7885264298831317e-10
R1113_1155	1113	1155	4.0447035923703752e+03
C1113_1155	1113	1155	2.1890819969359130e-10
R1113_1117	1113	1117	4.3587914958033653e+03
C1113_1117	1113	1117	2.0313400688068684e-10
R1113_1157	1113	1157	6.9838160844168551e+03
C1113_1157	1113	1157	1.2678151471881611e-10
R1113_1197	1113	1197	3.4853038044340483e+03
C1113_1197	1113	1197	2.5404350133654320e-10
R1113_1196	1113	1196	6.5565789322810024e+03
C1113_1196	1113	1196	1.3504280065030305e-10
R1113_1199	1113	1199	4.7955118428759988e+03
C1113_1199	1113	1199	1.8463488584963860e-10
R1114_1148	1114	1148	9.2649430578329702e+03
C1114_1148	1114	1148	9.5566564864252450e-11
R1114_1155	1114	1155	3.2173076438752373e+03
C1114_1155	1114	1155	2.7520488548416084e-10
R1114_1194	1114	1194	4.1466991437505176e+03
C1114_1194	1114	1194	2.1352375733224174e-10
R1114_1199	1114	1199	1.1375400811820686e+04
C1114_1199	1114	1199	7.7836271121095092e-11
R1115_1119	1115	1119	6.6555630625289305e+03
C1115_1119	1115	1119	1.3303439143788467e-10
R1115_1118	1115	1118	1.3535347805251331e+04
C1115_1118	1115	1118	6.5415295893355821e-11
R1115_1164	1115	1164	4.0182755543400108e+03
C1115_1164	1115	1164	2.2034795019064527e-10
R1115_1170	1115	1170	8.8148542736754935e+03
C1115_1170	1115	1170	1.0044621887218231e-10
R1115_1173	1115	1173	7.0340992388976347e+03
C1115_1173	1115	1173	1.2587521893403948e-10
R1115_1188	1115	1188	5.0757709558050728e+03
C1115_1188	1115	1188	1.7444025536403719e-10
R1115_1200	1115	1200	3.2363583015637396e+03
C1115_1200	1115	1200	2.7358490599516888e-10
R1116_1117	1116	1117	1.0448474806922211e+04
C1116_1117	1116	1117	8.4741438158361815e-11
R1116_1157	1116	1157	3.4617327466747706e+03
C1116_1157	1116	1157	2.5577329230585603e-10
R1116_1119	1116	1119	9.7154971605779538e+03
C1116_1119	1116	1119	9.1134685859691844e-11
R1116_1164	1116	1164	2.5984586937195618e+03
C1116_1164	1116	1164	3.4074768394050081e-10
R1116_1201	1116	1201	7.3657091196310093e+03
C1116_1201	1116	1201	1.2020821991737241e-10
R1117_1157	1117	1157	3.5358344903576235e+03
C1117_1157	1117	1157	2.5041296025438298e-10
R1117_1197	1117	1197	1.0973007625439554e+03
C1117_1197	1117	1197	8.0690619374697850e-10
R1117_1196	1117	1196	5.2462901187454690e+03
C1117_1196	1117	1196	1.6877045715339276e-10
R1117_1198	1117	1198	3.9735486623220681e+03
C1117_1198	1117	1198	2.2282822155815193e-10
R1117_1201	1117	1201	3.5400855098623774e+03
C1117_1201	1117	1201	2.5011225837152763e-10
R1118_1119	1118	1119	5.7239416769210911e+03
C1118_1119	1118	1119	1.5468689788891542e-10
R1118_1173	1118	1173	9.3721342641491314e-06
C1118_1173	1118	1173	1.9839445162067889e-10
R1118_1120	1118	1120	2.7753649948183266e-06
C1118_1120	1118	1120	3.1902786961466270e-11
R1118_1174	1118	1174	5.2843007382861873e-06
C1118_1174	1118	1174	1.6755647067641357e-11
R1118_1200	1118	1200	5.1671620675619442e+03
C1118_1200	1118	1200	1.7135494689791547e-10
R1118_1202	1118	1202	5.1814935200674751e-06
C1118_1202	1118	1202	1.3100876472940425e-10
R1118_1203	1118	1203	1.6992030546536335e-05
C1118_1203	1118	1203	1.0942655927782910e-10
R1119_1164	1119	1164	4.2687771487529753e+03
C1119_1164	1119	1164	2.0741742912455730e-10
R1119_1200	1119	1200	3.0536227344629028e+03
C1119_1200	1119	1200	2.8995683445346602e-10
R1119_1201	1119	1201	6.5338664595341352e+03
C1119_1201	1119	1201	1.3551222498709142e-10
R1119_1203	1119	1203	9.5834317443391665e+03
C1119_1203	1119	1203	9.2390576290482567e-11
R1120_1174	1120	1174	5.4710478162480676e-06
C1120_1174	1120	1174	1.6183714919662356e-11
R1120_1202	1120	1202	5.4128534360983672e-06
C1120_1202	1120	1202	1.6357708409304684e-11
R1120_1203	1120	1203	7.6547967402556307e-06
C1120_1203	1120	1203	1.1566849019565628e-11
R1120_1204	1120	1204	4.3915600566212999e-06
C1120_1204	1120	1204	2.0161827921834408e-11
R1120_1205	1120	1205	1.5412342430044902e-05
C1120_1205	1120	1205	5.7448683463842596e-12
R1121_1122	1121	1122	1.7794883418237087e+03
C1121_1122	1121	1122	4.9756930736201328e-10
R1121_1123	1121	1123	1.6616936819433786e+03
C1121_1123	1121	1123	5.3284115557597131e-10
R1121_1132	1121	1132	2.2131957745822751e+03
C1121_1132	1121	1132	4.0006347014968279e-10
R1121_1134	1121	1134	1.4886633611615860e+03
C1121_1134	1121	1134	5.9477434912424977e-10
R1121_1178	1121	1178	2.7049383460081722e+03
C1121_1178	1121	1178	3.2733418231386375e-10
R1121_1180	1121	1180	1.0377121357108374e+03
C1121_1180	1121	1180	8.5324123254421063e-10
R1121_1183	1121	1183	1.7678546783052286e+03
C1121_1183	1121	1183	5.0084364544534608e-10
R1121_1206	1121	1206	3.9170309756679871e+03
C1121_1206	1121	1206	2.2604334435956460e-10
R1122_1123	1122	1123	5.1726456826628510e+03
C1122_1123	1122	1123	1.7117329042421308e-10
R1122_1124	1122	1124	6.1966282681171133e+03
C1122_1124	1122	1124	1.4288718693287705e-10
R1122_1133	1122	1133	2.5234670815484656e+03
C1122_1133	1122	1133	3.5087391794177243e-10
R1122_1134	1122	1134	4.6923061323474003e+03
C1122_1134	1122	1134	1.8869586866811168e-10
R1122_1135	1122	1135	1.3503659255210927e+04
C1122_1135	1122	1135	6.5568803608423833e-11
R1122_1137	1122	1137	4.3813374557613797e+03
C1122_1137	1122	1137	2.0208869794671725e-10
R1122_1206	1122	1206	1.2179069692279096e+04
C1122_1206	1122	1206	7.2700034080707339e-11
R1123_1124	1123	1124	1.2505502633492563e+03
C1123_1124	1123	1124	7.0802334592185693e-10
R1123_1125	1123	1125	2.2715522232633430e+03
C1123_1125	1123	1125	3.8978579168564976e-10
R1123_1132	1123	1132	2.0490351754589765e+03
C1123_1132	1123	1132	4.3211497406415650e-10
R1123_1206	1123	1206	2.9443313189350224e+03
C1123_1206	1123	1206	3.0071981913375836e-10
R1124_1125	1124	1125	4.0334978142083296e+03
C1124_1125	1124	1125	2.1951636581555570e-10
R1124_1133	1124	1133	7.3544775033565602e+03
C1124_1133	1124	1133	1.2039179959363500e-10
R1124_1206	1124	1206	6.4782835000194718e+03
C1124_1206	1124	1206	1.3667490496477016e-10
R1125_1127	1125	1127	3.5679869690380133e+03
C1125_1127	1125	1127	2.4815639445530908e-10
R1125_1126	1125	1126	3.5721036092772974e+03
C1125_1126	1125	1126	2.4787040874190560e-10
R1125_1132	1125	1132	4.0737093472842057e+03
C1125_1132	1125	1132	2.1734952256480368e-10
R1125_1206	1125	1206	3.4511938899135603e+03
C1125_1206	1125	1206	2.5655434320503402e-10
R1126_1127	1126	1127	1.0026941616732180e+03
C1126_1127	1126	1127	8.8303972990376448e-10
R1126_1131	1126	1131	7.8512296633091876e+02
C1126_1131	1126	1131	1.1277453592241600e-09
R1126_1132	1126	1132	6.5528692304486356e+02
C1126_1132	1126	1132	1.3511925090551223e-09
R1126_1179	1126	1179	2.9033709856689252e+03
C1126_1179	1126	1179	3.0496233036371792e-10
R1126_1206	1126	1206	3.2572086853246838e+03
C1126_1206	1126	1206	2.7183360577700907e-10
R1126_1207	1126	1207	2.9064450481547533e+03
C1126_1207	1126	1207	3.0463978056703174e-10
R1127_1128	1127	1128	4.4982845315212535e+03
C1127_1128	1127	1128	1.9683476567467478e-10
R1127_1131	1127	1131	2.9735540522421402e+03
C1127_1131	1127	1131	2.9776448187729102e-10
R1127_1141	1127	1141	3.6218942830738920e+03
C1127_1141	1127	1141	2.4446290048768283e-10
R1127_1206	1127	1206	7.7463994713207794e+03
C1127_1206	1127	1206	1.1430068704538859e-10
R1127_1207	1127	1207	3.1234331339134787e+03
C1127_1207	1127	1207	2.8347614427417634e-10
R1128_1130	1128	1130	8.5446492999046695e+03
C1128_1130	1128	1130	1.0362260060338328e-10
R1128_1141	1128	1141	4.2636826522820584e+03
C1128_1141	1128	1141	2.0766526355475726e-10
R1128_1142	1128	1142	7.7351704737725877e+03
C1128_1142	1128	1142	1.1446661514470342e-10
R1128_1207	1128	1207	2.0667623127155650e+04
C1128_1207	1128	1207	4.2840861585898991e-11
R1129_1130	1129	1130	9.1873178303177137e+03
C1129_1130	1129	1130	9.6374023197299250e-11
R1129_1142	1129	1142	1.3908929781182378e+04
C1129_1142	1129	1142	6.3658296909220000e-11
R1129_1144	1129	1144	5.9473682501343574e+03
C1129_1144	1129	1144	1.4887572863509800e-10
R1129_1150	1129	1150	5.2131888712673090e+03
C1129_1150	1129	1150	1.6984206856191608e-10
R1129_1149	1129	1149	1.0747778853882630e+04
C1129_1149	1129	1149	8.2381559365649121e-11
R1129_1153	1129	1153	2.7246889314122350e+03
C1129_1153	1129	1153	3.2496141907879315e-10
R1129_1208	1129	1208	7.3729815554581846e+03
C1129_1208	1129	1208	1.2008965098312620e-10
R1130_1131	1130	1131	2.9246530057711502e+03
C1130_1131	1130	1131	3.0274319037260953e-10
R1130_1141	1130	1141	1.9605402848458336e+03
C1130_1141	1130	1141	4.5161978488476941e-10
R1130_1142	1130	1142	5.8934641258681904e+03
C1130_1142	1130	1142	1.5023740923672212e-10
R1130_1150	1130	1150	3.7422467454247258e+03
C1130_1150	1130	1150	2.3660085556424458e-10
R1130_1152	1130	1152	3.2644244349223686e+03
C1130_1152	1130	1152	2.7123273929330704e-10
R1130_1208	1130	1208	4.6114382181587480e+03
C1130_1208	1130	1208	1.9200491035821130e-10
R1130_1209	1130	1209	6.6988646563803895e+03
C1130_1209	1130	1209	1.3217445449605785e-10
R1131_1141	1131	1141	1.1141299377582845e+03
C1131_1141	1131	1141	7.9471770005707858e-10
R1131_1152	1131	1152	4.6983819214958758e+03
C1131_1152	1131	1152	1.8845185353048086e-10
R1131_1179	1131	1179	2.3360742075377216e+03
C1131_1179	1131	1179	3.7901997241485440e-10
R1131_1207	1131	1207	3.7108543905365987e+03
C1131_1207	1131	1207	2.3860240486880605e-10
R1131_1209	1131	1209	3.0325287534939507e+03
C1131_1209	1131	1209	2.9197374655717873e-10
R1132_1179	1132	1179	1.3951048566578545e+03
C1132_1179	1132	1179	6.3466109910987601e-10
R1132_1180	1132	1180	1.6252865505090460e+03
C1132_1180	1132	1180	5.4477703111656423e-10
R1132_1206	1132	1206	6.5775226242908252e+02
C1132_1206	1132	1206	1.3461280671694596e-09
R1132_1207	1132	1207	3.5457582525217531e+03
C1132_1207	1132	1207	2.4971211194961973e-10
R1132_1212	1132	1212	2.5302927876679755e+03
C1132_1212	1132	1212	3.4992740208378785e-10
R1133_1135	1133	1135	8.4907550081720929e+03
C1133_1135	1133	1135	1.0428033559416228e-10
R1133_1134	1133	1134	4.3151533973621390e+03
C1133_1134	1133	1134	2.0518825176441192e-10
R1133_1137	1133	1137	6.2932764290044352e+03
C1133_1137	1133	1137	1.4069281584697035e-10
R1133_1206	1133	1206	9.6265572031329757e+03
C1133_1206	1133	1206	9.1976681072630974e-11
R1133_1214	1133	1214	9.4479301341527716e+03
C1133_1214	1133	1214	9.3715636031150512e-11
R1133_1215	1133	1215	7.9016661290971897e+03
C1133_1215	1133	1215	1.1205469419158617e-10
R1134_1137	1134	1137	1.2628349468376643e+03
C1134_1137	1134	1137	7.0113579285814557e-10
R1134_1178	1134	1178	1.3331594369205591e+03
C1134_1178	1134	1178	6.6415070634403104e-10
R1134_1180	1134	1180	1.9191117111805363e+03
C1134_1180	1134	1180	4.6136906806500444e-10
R1134_1189	1134	1189	3.4742323437730829e+03
C1134_1189	1134	1189	2.5485307086238747e-10
R1134_1206	1134	1206	4.7695826626647513e+03
C1134_1206	1134	1206	1.8563862801474530e-10
R1134_1211	1134	1211	1.5004760318005108e+03
C1134_1211	1134	1211	5.9009191945407698e-10
R1134_1213	1134	1213	1.1289362015069712e+03
C1134_1213	1134	1213	7.8429479054537385e-10
R1134_1214	1134	1214	2.0729037143671112e+03
C1134_1214	1134	1214	4.2713936762389941e-10
R1134_1215	1134	1215	2.2057781502357689e+03
C1134_1215	1134	1215	4.0140880967805410e-10
R1134_1216	1134	1216	3.6009734844163972e+03
C1134_1216	1134	1216	2.4588317174001582e-10
R1135_1136	1135	1136	4.9869970147887916e+03
C1135_1136	1135	1136	1.7754548059169012e-10
R1135_1137	1135	1137	1.7329858425616806e+03
C1135_1137	1135	1137	5.1092095500975571e-10
R1135_1139	1135	1139	4.9765166182714611e+03
C1135_1139	1135	1139	1.7791938611219602e-10
R1135_1215	1135	1215	6.6456108148237290e+03
C1135_1215	1135	1215	1.3323361935745335e-10
R1135_1217	1135	1217	4.6991953149181927e+03
C1135_1217	1135	1217	1.8841923400994322e-10
R1136_1139	1136	1139	4.7321591381110604e-06
C1136_1139	1136	1139	2.0581739338648190e-10
R1136_1140	1136	1140	2.5645623262899833e-06
C1136_1140	1136	1140	3.4525141877947209e-11
R1136_1217	1136	1217	1.5701401981992378e-05
C1136_1217	1136	1217	6.2030171574045140e-11
R1137_1138	1137	1138	2.1405255277589804e+03
C1137_1138	1137	1138	4.1364551378510664e-10
R1137_1139	1137	1139	6.0243421890401942e+03
C1137_1139	1137	1139	1.4697352074568432e-10
R1137_1189	1137	1189	4.0684479090593304e+03
C1137_1189	1137	1189	2.1763060545236735e-10
R1137_1211	1137	1211	5.9542540239641858e+03
C1137_1211	1137	1211	1.4870356187969815e-10
R1137_1215	1137	1215	4.2349313591771752e+03
C1137_1215	1137	1215	2.0907511990277742e-10
R1137_1217	1137	1217	1.0754425122187999e+04
C1137_1217	1137	1217	8.2330647304731121e-11
R1137_1218	1137	1218	5.9591274364368173e+03
C1137_1218	1137	1218	1.4858195115716888e-10
R1138_1139	1138	1139	1.7400791771851636e+03
C1138_1139	1138	1139	5.0883821455314264e-10
R1138_1159	1138	1159	2.2437640569687478e+03
C1138_1159	1138	1159	3.9461314078458502e-10
R1138_1168	1138	1168	1.6574538749431083e+03
C1138_1168	1138	1168	5.3420417610739959e-10
R1138_1189	1138	1189	2.5074306839703554e+03
C1138_1189	1138	1189	3.5311794952512759e-10
R1138_1190	1138	1190	2.6660542091396196e+03
C1138_1190	1138	1190	3.3210831897740724e-10
R1138_1218	1138	1218	5.9895981471137029e+03
C1138_1218	1138	1218	1.4782607446322088e-10
R1139_1140	1139	1140	5.5080145212593624e-06
C1139_1140	1139	1140	1.6075098899658609e-11
R1139_1159	1139	1159	7.3099714440342266e-06
C1139_1159	1139	1159	9.2862341626717104e-11
R1139_1190	1139	1190	1.0951455936179216e-05
C1139_1190	1139	1190	8.8934353986529276e-11
R1139_1191	1139	1191	1.6786199232280582e-06
C1139_1191	1139	1191	5.2746829073570255e-11
R1139_1217	1139	1217	5.6186390855584777e-06
C1139_1217	1139	1217	1.7334458470546706e-10
R1139_1218	1139	1218	5.2772298044205156e-06
C1139_1218	1139	1218	1.8455907644578851e-10
R1139_1219	1139	1219	6.6338412032092319e-06
C1139_1219	1139	1219	1.3346999944340900e-11
R1140_1191	1140	1191	1.1955490356057566e-05
C1140_1191	1140	1191	7.4059595661116420e-12
R1140_1217	1140	1217	1.5154490352498246e-05
C1140_1217	1140	1217	5.8426166839324763e-12
R1140_1219	1140	1219	1.0170798894294127e-05
C1140_1219	1140	1219	8.7054988590593880e-12
R1141_1142	1141	1142	5.2975504577118472e+03
C1141_1142	1141	1142	1.6713739468230307e-10
R1141_1207	1141	1207	2.4800719596534623e+03
C1141_1207	1141	1207	3.5701334320304111e-10
R1141_1208	1141	1208	7.4896516621846386e+03
C1141_1208	1141	1208	1.1821895351562111e-10
R1141_1209	1141	1209	3.4357390805076234e+03
C1141_1209	1141	1209	2.5770838848716689e-10
R1141_1220	1141	1220	1.3679864729348776e+04
C1141_1220	1141	1220	6.4724235160046788e-11
R1142_1143	1142	1143	7.5560942435083261e+03
C1142_1143	1142	1143	1.1717942539701521e-10
R1142_1153	1142	1153	6.3388410371727732e+03
C1142_1153	1142	1153	1.3968149327418872e-10
R1142_1207	1142	1207	1.0804944746461540e+04
C1142_1207	1142	1207	8.1945701942618609e-11
R1142_1208	1142	1208	2.6550695401694520e+03
C1142_1208	1142	1208	3.3348233193300498e-10
R1142_1220	1142	1220	6.2716746461331904e+03
C1142_1220	1142	1220	1.4117740980806557e-10
R1142_1221	1142	1221	7.1145323553662465e+03
C1142_1221	1142	1221	1.2445214069933340e-10
R1143_1153	1143	1153	6.6210053468308151e+03
C1143_1153	1143	1153	1.3372875195212022e-10
R1143_1221	1143	1221	1.9528964003698202e+04
C1143_1221	1143	1221	4.5338748206629300e-11
R1144_1147	1144	1147	1.2848987130098751e+04
C1144_1147	1144	1147	6.8909616978750534e-11
R1144_1149	1144	1149	7.0915853961274652e+03
C1144_1149	1144	1149	1.2485484306280860e-10
R1144_1150	1144	1150	1.3054199810029808e+04
C1144_1150	1144	1150	6.7826354321596541e-11
R1144_1153	1144	1153	1.8184665087756923e+04
C1144_1153	1144	1153	4.8690409057691174e-11
R1144_1223	1144	1223	2.5429559106173052e+04
C1144_1223	1144	1223	3.4818487336064892e-11
R1145_1146	1145	1146	9.8697572430713160e+02
C1145_1146	1145	1146	8.9710289715744959e-10
R1145_1147	1145	1147	3.4256946955079347e+03
C1145_1147	1145	1147	2.5846400815024091e-10
R1145_1148	1145	1148	2.4553026986207360e+03
C1145_1148	1145	1148	3.6061491815138849e-10
R1145_1154	1145	1154	5.0816196871576858e+03
C1145_1154	1145	1154	1.7423948193872872e-10
R1145_1182	1145	1182	6.3104773554030153e+03
C1145_1182	1145	1182	1.4030931922161270e-10
R1145_1192	1145	1192	1.2754241004429703e+03
C1145_1192	1145	1192	6.9421518802450357e-10
R1145_1194	1145	1194	7.7584297787005535e+03
C1145_1194	1145	1194	1.1412345113063551e-10
R1145_1225	1145	1225	4.6018479359752500e+03
C1145_1225	1145	1225	1.9240504988836769e-10
R1146_1147	1146	1147	4.6099361749347363e+03
C1146_1147	1146	1147	1.9206747080669403e-10
R1146_1149	1146	1149	3.5541475107556848e+03
C1146_1149	1146	1149	2.4912268807654012e-10
R1146_1151	1146	1151	1.9173273912166776e+03
C1146_1151	1146	1151	4.6179843137699101e-10
R1146_1182	1146	1182	4.6521504298365680e+03
C1146_1182	1146	1182	1.9032462407521610e-10
R1146_1192	1146	1192	4.7573561695922763e+03
C1146_1192	1146	1192	1.8611572271156728e-10
R1146_1222	1146	1222	2.0298009458995959e+03
C1146_1222	1146	1222	4.3620966060176285e-10
R1146_1224	1146	1224	3.9752623265145685e+03
C1146_1224	1146	1224	2.2273216431387505e-10
R1146_1225	1146	1225	7.0580325360749312e+03
C1146_1225	1146	1225	1.2544838482600613e-10
R1147_1148	1147	1148	1.0860160018097389e+04
C1147_1148	1147	1148	8.1529073257165337e-11
R1147_1149	1147	1149	6.8275498877225773e+03
C1147_1149	1147	1149	1.2968323868159145e-10
R1147_1223	1147	1223	1.0951784520819814e+04
C1147_1223	1147	1223	8.0846987083865706e-11
R1147_1224	1147	1224	8.6192835438475777e+03
C1147_1224	1147	1224	1.0272533409485174e-10
R1147_1225	1147	1225	9.0960414197868286e+03
C1147_1225	1147	1225	9.7341111461292182e-11
R1148_1194	1148	1194	4.6827573603689507e+03
C1148_1194	1148	1194	1.8908064491947936e-10
R1148_1225	1148	1225	1.2423072847481964e+04
C1148_1225	1148	1225	7.1272123456916367e-11
R1149_1150	1149	1150	1.3871757430346440e+03
C1149_1150	1149	1150	6.3828882976501643e-10
R1149_1151	1149	1151	2.4663568057005364e+03
C1149_1151	1149	1151	3.5899865731248422e-10
R1149_1153	1149	1153	7.1392520329177532e+03
C1149_1153	1149	1153	1.2402122485906086e-10
R1149_1208	1149	1208	5.3532195393122156e+03
C1149_1208	1149	1208	1.6539930320394803e-10
R1149_1222	1149	1222	5.3645916548221421e+03
C1149_1222	1149	1222	1.6504868192607199e-10
R1149_1223	1149	1223	1.4455361928758257e+03
C1149_1223	1149	1223	6.1251927559039618e-10
R1149_1224	1149	1224	1.9177685123981689e+03
C1149_1224	1149	1224	4.6169220944856594e-10
R1149_1226	1149	1226	2.3341336975591203e+03
C1149_1226	1149	1226	3.7933507520409445e-10
R1150_1151	1150	1151	1.9967737235510585e+03
C1150_1151	1150	1151	4.4342469617707768e-10
R1150_1152	1150	1152	2.2330019445160783e+03
C1150_1152	1150	1152	3.9651500701755201e-10
R1150_1208	1150	1208	3.8665830109853964e+03
C1150_1208	1150	1208	2.2899257023175913e-10
R1150_1226	1150	1226	6.1135098724174240e+03
C1150_1226	1150	1226	1.4482986045295857e-10
R1151_1152	1151	1152	2.1495490535756248e+03
C1151_1152	1151	1152	4.1190908401330400e-10
R1151_1182	1151	1182	2.0583479323740230e+03
C1151_1182	1151	1182	4.3015991989206146e-10
R1151_1185	1151	1185	3.5177311879706012e+03
C1151_1185	1151	1185	2.5170166064076178e-10
R1151_1222	1151	1222	3.1657200788482883e+03
C1151_1222	1151	1222	2.7968953654996616e-10
R1151_1226	1151	1226	3.9856503569490183e+03
C1151_1226	1151	1226	2.2215164462589257e-10
R1152_1179	1152	1179	4.5757257524685292e+03
C1152_1179	1152	1179	1.9350346362483181e-10
R1152_1182	1152	1182	5.3177062683126305e+03
C1152_1182	1152	1182	1.6650389040403948e-10
R1152_1184	1152	1184	4.1049544908589714e+03
C1152_1184	1152	1184	2.1569515171768058e-10
R1152_1185	1152	1185	2.2728914816949732e+03
C1152_1185	1152	1185	3.8955611776049817e-10
R1152_1208	1152	1208	6.2925990270867414e+03
C1152_1208	1152	1208	1.4070796150981173e-10
R1152_1209	1152	1209	2.3489173980834312e+03
C1152_1209	1152	1209	3.7694760250932884e-10
R1152_1226	1152	1226	3.8136325044161663e+03
C1152_1226	1152	1226	2.3217202514261396e-10
R1152_1227	1152	1227	5.0247019807408296e+03
C1152_1227	1152	1227	1.7621319335827677e-10
R1153_1208	1153	1208	5.3770415269350678e+03
C1153_1208	1153	1208	1.6466653219334385e-10
R1153_1221	1153	1221	1.0737334450063385e+04
C1153_1221	1153	1221	8.2461693432188215e-11
R1153_1223	1153	1223	1.1407663341333850e+04
C1153_1223	1153	1223	7.7616138836410636e-11
R1153_1228	1153	1228	1.5263343301045536e+04
C1153_1228	1153	1228	5.8009491383145987e-11
R1154_1156	1154	1156	5.9829007729536670e+03
C1154_1156	1154	1156	1.4799155381326548e-10
R1154_1157	1154	1157	1.3022294877982369e+04
C1154_1157	1154	1157	6.7992530502210834e-11
R1154_1158	1154	1158	2.1559787824753053e+03
C1154_1158	1154	1158	4.1068065645963370e-10
R1154_1182	1154	1182	5.2800340419240229e+03
C1154_1182	1154	1182	1.6769186991403507e-10
R1154_1186	1154	1186	5.7379737965425875e+03
C1154_1186	1154	1186	1.5430861364921338e-10
R1154_1187	1154	1187	7.9769112469701622e+03
C1154_1187	1154	1187	1.1099769751560232e-10
R1154_1192	1154	1192	4.8983321850514449e+03
C1154_1192	1154	1192	1.8075923564393809e-10
R1154_1193	1154	1193	3.5864625819668781e+03
C1154_1193	1154	1193	2.4687802018400565e-10
R1154_1229	1154	1229	4.2989048529027159e+03
C1154_1229	1154	1229	2.0596380054844572e-10
R1155_1156	1155	1156	9.1093225604566771e+02
C1155_1156	1155	1156	9.7199190809597530e-10
R1155_1157	1155	1157	2.2050517963111683e+03
C1155_1157	1155	1157	4.0154103553540888e-10
R1155_1194	1155	1194	2.4947103380902340e+03
C1155_1194	1155	1194	3.5491847216932258e-10
R1155_1195	1155	1195	1.2489743479948904e+03
C1155_1195	1155	1195	7.0891670683345573e-10
R1155_1197	1155	1197	4.3656566726751489e+03
C1155_1197	1155	1197	2.0281457019785319e-10
R1155_1199	1155	1199	1.5114766686421081e+03
C1155_1199	1155	1199	5.8579718765718646e-10
R1155_1230	1155	1230	1.9173047786066127e+03
C1155_1230	1155	1230	4.6180387780782136e-10
R1155_1231	1155	1231	3.3964360803893028e+03
C1155_1231	1155	1231	2.6069054760439145e-10
R1155_1232	1155	1232	2.2562959268502013e+03
C1155_1232	1155	1232	3.9242138904006637e-10
R1156_1157	1156	1157	9.2546782600140762e+02
C1156_1157	1156	1157	9.5672562224616283e-10
R1156_1187	1156	1187	8.7717070930976461e+03
C1156_1187	1156	1187	1.0094030412811274e-10
R1156_1192	1156	1192	6.3213056039783332e+03
C1156_1192	1156	1192	1.4006897264115169e-10
R1156_1195	1156	1195	3.4766653885554792e+03
C1156_1195	1156	1195	2.5467471923373188e-10
R1156_1229	1156	1229	6.0849130946805844e+03
C1156_1229	1156	1229	1.4551050572505808e-10
R1156_1231	1156	1231	2.1791756888127688e+03
C1156_1231	1156	1231	4.0630903981054543e-10
R1156_1232	1156	1232	1.0308575160205133e+04
C1156_1232	1156	1232	8.5891480436407930e-11
R1157_1164	1157	1164	3.9377399149909420e+03
C1157_1164	1157	1164	2.2485456145267957e-10
R1157_1187	1157	1187	3.1691140529996355e+03
C1157_1187	1157	1187	2.7939000202972555e-10
R1157_1197	1157	1197	5.6989111308426081e+03
C1157_1197	1157	1197	1.5536630794400315e-10
R1157_1201	1157	1201	6.7292561526224299e+03
C1157_1201	1157	1201	1.3157751192974684e-10
R1157_1231	1157	1231	3.9940894438657160e+03
C1157_1231	1157	1231	2.2168226178806837e-10
R1157_1232	1157	1232	2.9777441365901818e+03
C1157_1232	1157	1232	2.9734548741783235e-10
R1157_1233	1157	1233	4.6385118394287920e+03
C1157_1233	1157	1233	1.9088423450246809e-10
R1158_1162	1158	1162	1.2320240859685509e+03
C1158_1162	1158	1162	7.1867002584120067e-10
R1158_1181	1158	1181	3.5900445477833487e+03
C1158_1181	1158	1181	2.4663169771714858e-10
R1158_1186	1158	1186	1.2122986241008605e+03
C1158_1186	1158	1186	7.3036359532017053e-10
R1158_1187	1158	1187	1.5308793931494458e+03
C1158_1187	1158	1187	5.7837265669795641e-10
R1158_1229	1158	1229	3.7301942970946061e+03
C1158_1229	1158	1229	2.3736532501527863e-10
R1158_1235	1158	1235	4.3090712447372889e+03
C1158_1235	1158	1235	2.0547787015157169e-10
R1159_1160	1159	1160	2.1539408285565126e-06
C1159_1160	1159	1160	4.1106922249733906e-11
R1159_1165	1159	1165	9.8513056349958297e+03
C1159_1165	1159	1165	8.9878318113959822e-11
R1159_1168	1159	1168	5.4837379302771806e+03
C1159_1168	1159	1168	1.6146263606277877e-10
R1159_1176	1159	1176	1.1153888087183184e-05
C1159_1176	1159	1176	8.7320282513432024e-11
R1159_1190	1159	1190	6.8191733348272148e-06
C1159_1190	1159	1190	1.4282679308381562e-10
R1159_1191	1159	1191	7.2989778266987646e-06
C1159_1191	1159	1191	1.2130722996050857e-11
R1159_1236	1159	1236	8.2712405892143521e-06
C1159_1236	1159	1236	1.0704788140905741e-11
R1160_1171	1160	1171	9.3889026841521890e-06
C1160_1171	1160	1171	9.4304820433864442e-12
R1160_1176	1160	1176	9.8355104907537185e-06
C1160_1176	1160	1176	9.0022656427683659e-12
R1160_1191	1160	1191	1.0561791437292663e-05
C1160_1191	1160	1191	8.3832253927460850e-12
R1160_1236	1160	1236	5.9246718661185766e-06
C1160_1236	1160	1236	1.4944604557147625e-11
R1161_1162	1161	1162	1.7776012170406550e+03
C1161_1162	1161	1162	4.9809753346931349e-10
R1161_1163	1161	1163	2.0614406245715559e+03
C1161_1163	1161	1163	4.2951456915428882e-10
R1161_1166	1161	1166	2.4539072269991716e+03
C1161_1166	1161	1166	3.6081999024174959e-10
R1161_1167	1161	1167	1.3826908441871446e+03
C1161_1167	1161	1167	6.4035918471747702e-10
R1161_1181	1161	1181	3.8254403049120197e+03
C1161_1181	1161	1181	2.3145539104690419e-10
R1161_1188	1161	1188	8.6347703177943167e+03
C1161_1188	1161	1188	1.0254109247994138e-10
R1161_1238	1161	1238	4.6511814796784920e+03
C1161_1238	1161	1238	1.9036427315693638e-10
R1162_1181	1162	1181	9.0754563816548834e+03
C1162_1181	1162	1181	9.7561901513821864e-11
R1162_1163	1162	1163	6.4765064935883738e+03
C1162_1163	1162	1163	1.3671240545756400e-10
R1162_1186	1162	1186	1.0656196524390094e+04
C1162_1186	1162	1186	8.3089569498219902e-11
R1162_1187	1162	1187	9.1358853733412161e+03
C1162_1187	1162	1187	9.6916581756123856e-11
R1162_1188	1162	1188	6.2223206813606193e+03
C1162_1188	1162	1188	1.4229719537797711e-10
R1162_1235	1162	1235	4.0867561227065476e+03
C1162_1235	1162	1235	2.1665564450506309e-10
R1162_1238	1162	1238	9.9113971103536387e+03
C1162_1238	1162	1238	8.9333397889493737e-11
R1163_1166	1163	1166	1.3546925248471955e+03
C1163_1166	1163	1166	6.5359390818213315e-10
R1163_1181	1163	1181	1.1237675043777019e+03
C1163_1181	1163	1181	7.8790210452856072e-10
R1163_1178	1163	1178	5.5625835256931159e+03
C1163_1178	1163	1178	1.5917402005926268e-10
R1163_1183	1163	1183	3.5373097543891181e+03
C1163_1183	1163	1183	2.5030852347645448e-10
R1163_1186	1163	1186	4.8559569185237951e+03
C1163_1186	1163	1186	1.8233662212332114e-10
R1163_1234	1163	1234	1.6494342677785610e+03
C1163_1234	1163	1234	5.3680149551668502e-10
R1163_1235	1163	1235	2.6145302817851898e+03
C1163_1235	1163	1235	3.3865309874913357e-10
R1163_1237	1163	1237	3.7468772274963007e+03
C1163_1237	1163	1237	2.3630845846839910e-10
R1163_1238	1163	1238	3.8218948079287547e+03
C1163_1238	1163	1238	2.3167010768144233e-10
R1164_1187	1164	1187	1.8724949319656889e+03
C1164_1187	1164	1187	4.7285510181355415e-10
R1164_1188	1164	1188	4.4184646734038861e+03
C1164_1188	1164	1188	2.0039059880451487e-10
R1164_1200	1164	1200	1.3048469584207353e+03
C1164_1200	1164	1200	6.7856140215219420e-10
R1164_1201	1164	1201	5.6202168486922883e+03
C1164_1201	1164	1201	1.5754174714913701e-10
R1164_1233	1164	1233	2.0966039255501464e+03
C1164_1233	1164	1233	4.2231094338319870e-10
R1164_1240	1164	1240	5.9094327270660260e+03
C1164_1240	1164	1240	1.4983143435150017e-10
R1165_1166	1165	1166	5.3707615449946325e+03
C1165_1166	1165	1166	1.6485907525073060e-10
R1165_1167	1165	1167	2.9070051077379853e+03
C1165_1167	1165	1167	3.0458108908827025e-10
R1165_1168	1165	1168	1.2386091943114845e+03
C1165_1168	1165	1168	7.1484919195370980e-10
R1165_1169	1165	1169	5.3332466498401382e+03
C1165_1169	1165	1169	1.6601871989673309e-10
R1165_1176	1165	1176	3.1604673824631082e+03
C1165_1176	1165	1176	2.8015438052391777e-10
R1165_1241	1165	1241	3.6845388597926672e+03
C1165_1241	1165	1241	2.4030653913359015e-10
R1166_1167	1166	1167	3.5625874521733781e+03
C1166_1167	1166	1167	2.4853250441890067e-10
R1166_1168	1166	1168	5.4601460797888622e+03
C1166_1168	1166	1168	1.6216027350942932e-10
R1166_1178	1166	1178	3.9352799636298782e+03
C1166_1178	1166	1178	2.2499511848790937e-10
R1166_1183	1166	1183	7.7215352312728282e+03
C1166_1183	1166	1183	1.1466874852995346e-10
R1166_1189	1166	1189	7.0516360512731799e+03
C1166_1189	1166	1189	1.2556217809059172e-10
R1166_1237	1166	1237	3.5563421662160631e+03
C1166_1237	1166	1237	2.4896895189421072e-10
R1166_1238	1166	1238	6.2277728535648484e+03
C1166_1238	1166	1238	1.4217261973406373e-10
R1166_1241	1166	1241	4.5301310698594361e+03
C1166_1241	1166	1241	1.9545102957197071e-10
R1167_1169	1167	1169	1.0007393493208893e+03
C1167_1169	1167	1169	8.8476463157050155e-10
R1167_1188	1167	1188	8.1586025219287721e+03
C1167_1188	1167	1188	1.0852578971952157e-10
R1167_1238	1167	1238	4.0430141952702411e+03
C1167_1238	1167	1238	2.1899967176365985e-10
R1167_1241	1167	1241	3.7021820119883814e+03
C1167_1241	1167	1241	2.3916133210977819e-10
R1168_1176	1168	1176	3.6971450293769649e+03
C1168_1176	1168	1176	2.3948716500559056e-10
R1168_1189	1168	1189	1.4176037792114587e+03
C1168_1189	1168	1189	6.2458833327357081e-10
R1168_1190	1168	1190	1.8411093330941260e+03
C1168_1190	1168	1190	4.8091591617320498e-10
R1168_1237	1168	1237	5.8468690644120370e+03
C1168_1237	1168	1237	1.5143468614497492e-10
R1168_1239	1168	1239	3.7632126610274677e+03
C1168_1239	1168	1239	2.3528268568756747e-10
R1168_1241	1168	1241	2.4654732677206125e+03
C1168_1241	1168	1241	3.5912730967007828e-10
R1169_1170	1169	1170	2.5501143985600816e+03
C1169_1170	1169	1170	3.4720747516266342e-10
R1169_1172	1169	1172	3.8717450179005555e+03
C1169_1172	1169	1172	2.2868726571775018e-10
R1169_1176	1169	1176	5.9501480047948744e+03
C1169_1176	1169	1176	1.4880617776003101e-10
R1169_1188	1169	1188	8.0657212174762981e+03
C1169_1188	1169	1188	1.0977552506792947e-10
R1169_1238	1169	1238	4.4665618035730631e+03
C1169_1238	1169	1238	1.9823273932797748e-10
R1169_1241	1169	1241	2.6544020597831800e+03
C1169_1241	1169	1241	3.3356618995854895e-10
R1169_1243	1169	1243	4.8662759133797817e+03
C1169_1243	1169	1243	1.8194997518853152e-10
R1170_1172	1170	1172	2.6994615025497055e+03
C1170_1172	1170	1172	3.2799829923994140e-10
R1170_1173	1170	1173	4.2995881752591022e+03
C1170_1173	1170	1173	2.0593106725777130e-10
R1170_1188	1170	1188	2.2495512521247651e+03
C1170_1188	1170	1188	3.9359795908792799e-10
R1170_1200	1170	1200	1.4624442187606679e+04
C1170_1200	1170	1200	6.0543764359801588e-11
R1170_1238	1170	1238	5.1333656560050422e+03
C1170_1238	1170	1238	1.7248309219200701e-10
R1170_1240	1170	1240	5.5743687844432461e+03
C1170_1240	1170	1240	1.5883749639438927e-10
R1170_1242	1170	1242	2.7610077455055180e+03
C1170_1242	1170	1242	3.2068681558076804e-10
R1170_1243	1170	1243	5.4107232121990046e+03
C1170_1243	1170	1243	1.6364148506131987e-10
R1171_1175	1171	1175	6.5836003129741677e-06
C1171_1175	1171	1175	1.3448853812633843e-11
R1171_1176	1171	1176	1.0221030889101271e-06
C1171_1176	1171	1176	8.6627150559159927e-11
R1171_1177	1171	1177	4.5221798922916936e-06
C1171_1177	1171	1177	1.9579468371199592e-11
R1171_1236	1171	1236	8.9827131336165117e-06
C1171_1236	1171	1236	9.8569192684830106e-12
R1171_1244	1171	1244	7.9087972942393979e-06
C1171_1244	1171	1244	1.1195365727035646e-11
R1172_1173	1172	1173	5.2250336971868026e-06
C1172_1173	1172	1173	1.4403848998825677e-10
R1172_1174	1172	1174	8.1057664618080480e-06
C1172_1174	1172	1174	1.0923319662265487e-11
R1172_1175	1172	1175	1.8067384189278810e-06
C1172_1175	1172	1175	4.9006473345787811e-11
R1172_1176	1172	1176	7.2895058841207589e-06
C1172_1176	1172	1176	1.0324512742626353e-10
R1172_1242	1172	1242	6.4085894639142420e-06
C1172_1242	1172	1242	1.0592363098616118e-10
R1172_1243	1172	1243	8.3571400588464208e-06
C1172_1243	1172	1243	1.6951613095144716e-10
R1172_1244	1172	1244	4.8432823687830280e-06
C1172_1244	1172	1244	1.8281378500805420e-11
R1172_1245	1172	1245	5.8321443585473042e-06
C1172_1245	1172	1245	1.5181702085312306e-11
R1173_1174	1173	1174	1.9889851453698444e-06
C1173_1174	1173	1174	4.4516108315899947e-11
R1173_1200	1173	1200	8.3950014327843510e+03
C1173_1200	1173	1200	1.0546975945021788e-10
R1173_1202	1173	1202	7.8415770149665843e-06
C1173_1202	1173	1202	1.2420469212214833e-10
R1173_1240	1173	1240	1.0605958048382496e+04
C1173_1240	1173	1240	8.3483149533580733e-11
R1173_1242	1173	1242	1.1847307119379697e-05
C1173_1242	1173	1242	1.1957738871119674e-10
R1173_1245	1173	1245	7.3138261596578692e-06
C1173_1245	1173	1245	1.2106095528819883e-11
R1174_1175	1174	1175	1.0944278282442060e-05
C1174_1175	1174	1175	8.0902436766477363e-12
R1174_1202	1174	1202	5.5901805655281767e-06
C1174_1202	1174	1202	1.5838822580435607e-11
R1174_1204	1174	1204	1.0494215807449959e-05
C1174_1204	1174	1204	8.4372076765510348e-12
R1174_1245	1174	1245	3.5888505065687253e-06
C1174_1245	1174	1245	2.4671375418937211e-11
R1175_1176	1175	1176	6.6769977823744940e-06
C1175_1176	1175	1176	1.3260732001997532e-11
R1175_1244	1175	1244	3.2936779528620758e-06
C1175_1244	1175	1244	2.6882372665809845e-11
R1175_1245	1175	1245	7.8328855238464198e-06
C1175_1245	1175	1245	1.1303864699725703e-11
R1176_1190	1176	1190	1.3149000749491729e-05
C1176_1190	1176	1190	7.4071077905572988e-11
R1176_1236	1176	1236	4.9255875663217623e-06
C1176_1236	1176	1236	1.7975901753406375e-11
R1176_1177	1176	1177	3.7913491542662850e-06
C1176_1177	1176	1177	2.3353659757336420e-11
R1176_1239	1176	1239	6.3418236361852806e-06
C1176_1239	1176	1239	1.1867343008189542e-10
R1176_1241	1176	1241	4.0787398448149802e+03
C1176_1241	1176	1241	2.1708145539744866e-10
R1176_1243	1176	1243	7.7717545319956679e-06
C1176_1243	1176	1243	1.2532056370106962e-10
R1176_1244	1176	1244	4.5166290254807901e-06
C1176_1244	1176	1244	1.9603531233246416e-11
R1176_1246	1176	1246	5.4949465492327408e-06
C1176_1246	1176	1246	1.6113328378483157e-11
R1177_1236	1177	1236	4.6650250736192235e-06
C1177_1236	1177	1236	1.8979936178844026e-11
R1177_1239	1177	1239	4.6467067268795801e-06
C1177_1239	1177	1239	1.9054759289588060e-11
R1177_1244	1177	1244	3.6076680364689076e-06
C1177_1244	1177	1244	2.4542689980052189e-11
R1177_1246	1177	1246	1.8740774549668330e-06
C1177_1246	1177	1246	4.7245580984574096e-11
R1177_1247	1177	1247	2.8873762288969738e-06
C1177_1247	1177	1247	3.0665168357302887e-11
R1178_1180	1178	1180	2.5427048936137448e+03
C1178_1180	1178	1180	3.4821924633244581e-10
R1178_1183	1178	1183	1.5690731569099898e+03
C1178_1183	1178	1183	5.6429413619163209e-10
R1178_1189	1178	1189	2.4348814059765441e+03
C1178_1189	1178	1189	3.6363938692319606e-10
R1178_1211	1178	1211	2.1916476003327193e+03
C1178_1211	1178	1211	4.0399687502935352e-10
R1178_1213	1178	1213	4.4425613865410005e+03
C1178_1213	1178	1213	1.9930366846081813e-10
R1178_1234	1178	1234	3.0615102085024550e+03
C1178_1234	1178	1234	2.8920980868886430e-10
R1178_1237	1178	1237	2.3021478339741793e+03
C1178_1237	1178	1237	3.8460552733987930e-10
R1178_1248	1178	1248	2.0019057601719671e+03
C1178_1248	1178	1248	4.4228794347639078e-10
R1179_1180	1179	1180	2.7562073013916984e+03
C1179_1180	1179	1180	3.2124535090409323e-10
R1179_1184	1179	1184	2.4663373980008932e+03
C1179_1184	1179	1184	3.5900148228611476e-10
R1179_1207	1179	1207	3.8895820367323754e+03
C1179_1207	1179	1207	2.2763854145208807e-10
R1179_1209	1179	1209	1.9448607544172210e+03
C1179_1209	1179	1209	4.5526075822601312e-10
R1179_1210	1179	1210	2.2802941425680128e+03
C1179_1210	1179	1210	3.8829147747705150e-10
R1179_1212	1179	1212	2.7343974940624935e+03
C1179_1212	1179	1212	3.2380763353631285e-10
R1179_1227	1179	1227	4.1528408169557470e+03
C1179_1227	1179	1227	2.1320797514917965e-10
R1179_1249	1179	1249	3.3979953073457223e+03
C1179_1249	1179	1249	2.6057092538824828e-10
R1180_1183	1180	1183	1.7429654466792426e+03
C1180_1183	1180	1183	5.0799560220022159e-10
R1180_1184	1180	1184	5.0466193091286177e+03
C1180_1184	1180	1184	1.7544790432248440e-10
R1180_1206	1180	1206	5.7209747707467795e+03
C1180_1206	1180	1206	1.5476711874826588e-10
R1180_1212	1180	1212	1.4483698903333461e+03
C1180_1212	1180	1212	6.1132089779650044e-10
R1180_1213	1180	1213	2.4844814952163383e+03
C1180_1213	1180	1213	3.5637970474113005e-10
R1180_1214	1180	1214	7.0105778540080546e+03
C1180_1214	1180	1214	1.2629754638468105e-10
R1180_1248	1180	1248	5.8304768078481693e+03
C1180_1248	1180	1248	1.5186044141504410e-10
R1180_1249	1180	1249	2.2021961890447792e+03
C1180_1249	1180	1249	4.0206171734592717e-10
R1181_1183	1181	1183	1.6794575675550334e+03
C1181_1183	1181	1183	5.2720521125698888e-10
R1181_1184	1181	1184	3.3990334609181882e+03
C1181_1184	1181	1184	2.6049134022376463e-10
R1181_1186	1181	1186	1.3421136524691874e+03
C1181_1186	1181	1186	6.5971967431448789e-10
R1181_1234	1181	1234	3.4855538350799047e+03
C1181_1234	1181	1234	2.5402527793110452e-10
R1181_1250	1181	1250	4.4559470858951581e+03
C1181_1250	1181	1250	1.9870495870624272e-10
R1182_1185	1182	1185	1.7140252325042359e+03
C1182_1185	1182	1185	5.1657278137404086e-10
R1182_1184	1182	1184	6.7548554087863631e+03
C1182_1184	1182	1184	1.3107886521868307e-10
R1182_1186	1182	1186	4.3920554700761895e+03
C1182_1186	1182	1186	2.0159553715396060e-10
R1182_1192	1182	1192	6.4442779021890201e+03
C1182_1192	1182	1192	1.3739612026961740e-10
R1182_1193	1182	1193	2.7861803295789564e+03
C1182_1193	1182	1193	3.1778947410550543e-10
R1182_1222	1182	1222	4.1477997008906950e+03
C1182_1222	1182	1222	2.1346710196971809e-10
R1182_1250	1182	1250	8.1115562332937452e+03
C1182_1250	1182	1250	1.0915522943252415e-10
R1183_1184	1183	1184	1.2234451197976962e+03
C1183_1184	1183	1184	7.2370943933015096e-10
R1183_1234	1183	1234	1.6033132653029199e+03
C1183_1234	1183	1234	5.5224315850259895e-10
R1183_1248	1183	1248	6.8683625398148242e+03
C1183_1248	1183	1248	1.2891264498159000e-10
R1183_1249	1183	1249	3.4830801081606974e+03
C1183_1249	1183	1249	2.5420568985063085e-10
R1183_1250	1183	1250	3.7400237532371270e+03
C1183_1250	1183	1250	2.3674148618271152e-10
R1184_1185	1184	1185	2.4391383582887897e+03
C1184_1185	1184	1185	3.6300473841146820e-10
R1184_1186	1184	1186	7.3199008417814102e+03
C1184_1186	1184	1186	1.2096048851455751e-10
R1184_1227	1184	1227	4.3157313705781244e+03
C1184_1227	1184	1227	2.0516077245590742e-10
R1184_1249	1184	1249	4.2978838135085762e+03
C1184_1249	1184	1249	2.0601273094378708e-10
R1184_1250	1184	1250	1.8453819430397868e+03
C1184_1250	1184	1250	4.7980245229965939e-10
R1185_1222	1185	1222	2.2735354957344221e+03
C1185_1222	1185	1222	3.8944576997421472e-10
R1185_1193	1185	1193	4.8792001940979080e+03
C1185_1193	1185	1193	1.8146801657596280e-10
R1185_1226	1185	1226	2.5636498976150588e+03
C1185_1226	1185	1226	3.4537429721729844e-10
R1185_1227	1185	1227	1.7591981043575586e+03
C1185_1227	1185	1227	5.0330817177826937e-10
R1185_1250	1185	1250	2.2851883901216684e+03
C1185_1250	1185	1250	3.8745986349635635e-10
R1185_1251	1185	1251	2.5287833940142023e+03
C1185_1251	1185	1251	3.5013626860878827e-10
R1186_1193	1186	1193	2.0262680795646386e+03
C1186_1193	1186	1193	4.3697020677058685e-10
R1186_1229	1186	1229	3.5049631179015119e+03
C1186_1229	1186	1229	2.5261857312499120e-10
R1186_1234	1186	1234	3.8465128053374942e+03
C1186_1234	1186	1234	2.3018739999289127e-10
R1186_1235	1186	1235	2.9127116175350056e+03
C1186_1235	1186	1235	3.0398436164075855e-10
R1186_1250	1186	1250	1.6724893922872736e+03
C1186_1250	1186	1250	5.2940173240149123e-10
R1186_1252	1186	1252	3.4172345701275631e+03
C1186_1252	1186	1252	2.5910389337625950e-10
R1187_1188	1187	1188	3.1652978994526543e+03
C1187_1188	1187	1188	2.7972684083008661e-10
R1187_1229	1187	1229	1.8128781649063021e+03
C1187_1229	1187	1229	4.8840501189762126e-10
R1187_1231	1187	1231	2.7785683584645631e+03
C1187_1231	1187	1231	3.1866006787368820e-10
R1187_1233	1187	1233	2.0752580169726079e+03
C1187_1233	1187	1233	4.2665479398636484e-10
R1187_1235	1187	1235	2.8744897167793692e+03
C1187_1235	1187	1235	3.0802642170939458e-10
R1187_1240	1187	1240	5.1940505663184222e+03
C1187_1240	1187	1240	1.7046787866133362e-10
R1187_1253	1187	1253	2.0055660083881037e+03
C1187_1253	1187	1253	4.4148074807650997e-10
R1188_1200	1188	1200	3.2175031603460484e+03
C1188_1200	1188	1200	2.7518816224092578e-10
R1188_1235	1188	1235	3.2929366951999527e+03
C1188_1235	1188	1235	2.6888424031675343e-10
R1188_1238	1188	1238	8.1855788059833560e+02
C1188_1238	1188	1238	1.0816813357814009e-09
R1188_1240	1188	1240	9.4946504074656798e+02
C1188_1240	1188	1240	9.3254490023539128e-10
R1188_1253	1188	1253	4.0222116632891989e+03
C1188_1253	1188	1253	2.2013231918678813e-10
R1189_1190	1189	1190	1.4320284329091501e+03
C1189_1190	1189	1190	6.1829692857514107e-10
R1189_1211	1189	1211	4.9534915757164327e+02
C1189_1211	1189	1211	1.7874639901289030e-09
R1189_1218	1189	1218	2.2869808388467509e+03
C1189_1218	1189	1218	3.8715618717054385e-10
R1189_1237	1189	1237	1.2819191426654058e+03
C1189_1237	1189	1237	6.9069783906885891e-10
R1189_1239	1189	1239	3.1480707929443943e+03
C1189_1239	1189	1239	2.8125758279783372e-10
R1189_1254	1189	1254	1.8420623504645973e+03
C1189_1254	1189	1254	4.8066710742808651e-10
R1190_1191	1190	1191	2.3304342835031648e-06
C1190_1191	1190	1191	3.7993724515973792e-11
R1190_1218	1190	1218	3.1920666568224835e-06
C1190_1218	1190	1218	3.0511914806489669e-10
R1190_1236	1190	1236	7.5362484935250484e-07
C1190_1236	1190	1236	1.1748800248037588e-10
R1190_1239	1190	1239	3.3959007168713386e-06
C1190_1239	1190	1239	4.1717063209674169e-10
R1190_1254	1190	1254	2.8430799285061348e-06
C1190_1254	1190	1254	2.3876256826663743e-10
R1190_1255	1190	1255	3.0987928989639563e-06
C1190_1255	1190	1255	2.8573022159565064e-11
R1191_1218	1191	1218	3.7636585935595556e-06
C1191_1218	1191	1218	2.3525480850339230e-11
R1191_1219	1191	1219	4.2527480590730938e-06
C1191_1219	1191	1219	2.0819920893526460e-11
R1191_1236	1191	1236	4.4373867264244300e-06
C1191_1236	1191	1236	1.9953608650500816e-11
R1191_1255	1191	1255	3.3372346197728175e-06
C1191_1255	1191	1255	2.6531511343373126e-11
R1192_1193	1192	1193	1.3496036620509972e+03
C1192_1193	1192	1193	6.5605837224420840e-10
R1192_1194	1192	1194	5.7235207089999858e+03
C1192_1194	1192	1194	1.5469827519060388e-10
R1192_1195	1192	1195	2.4553658624522232e+03
C1192_1195	1192	1195	3.6060564139949165e-10
R1192_1222	1192	1222	1.4427688772524270e+03
C1192_1222	1192	1222	6.1369412361193246e-10
R1192_1225	1192	1225	2.7437333886184097e+03
C1192_1225	1192	1225	3.2270583773660574e-10
R1192_1229	1192	1229	3.0109134002553551e+03
C1192_1229	1192	1229	2.9406982665954713e-10
R1192_1231	1192	1231	6.5146545628088215e+03
C1192_1231	1192	1231	1.3591185429151101e-10
R1192_1251	1192	1251	5.1239693509112867e+03
C1192_1251	1192	1251	1.7279939067990918e-10
R1192_1256	1192	1256	1.8019191937939515e+03
C1192_1256	1192	1256	4.9137540947979215e-10
R1193_1222	1193	1222	1.6572733889176352e+03
C1193_1222	1193	1222	5.3426235382821596e-10
R1193_1229	1193	1229	5.7998787078880412e+02
C1193_1229	1193	1229	1.5266160316349363e-09
R1193_1250	1193	1250	1.8150118883934892e+03
C1193_1250	1193	1250	4.8783084417353645e-10
R1193_1251	1193	1251	6.0426802730858549e+02
C1193_1251	1193	1251	1.4652749139213314e-09
R1193_1252	1193	1252	2.5298336844389455e+03
C1193_1252	1193	1252	3.4999090538885135e-10
R1193_1256	1193	1256	3.4534621367893160e+03
C1193_1256	1193	1256	2.5638583735079662e-10
R1194_1195	1194	1195	9.2570115564733862e+02
C1194_1195	1194	1195	9.5648447265989506e-10
R1194_1199	1194	1199	4.7556844472417170e+03
C1194_1199	1194	1199	1.8618114627297035e-10
R1194_1225	1194	1225	3.4498637460143545e+03
C1194_1225	1194	1225	2.5665326137095383e-10
R1194_1230	1194	1230	3.7980749893224497e+03
C1194_1230	1194	1230	2.3312303843109549e-10
R1194_1257	1194	1257	3.0613246229166962e+03
C1194_1257	1194	1257	2.8922734135147414e-10
R1195_1225	1195	1225	4.2808337029666009e+03
C1195_1225	1195	1225	2.0683325799047236e-10
R1195_1230	1195	1230	9.9664545948894283e+02
C1195_1230	1195	1230	8.8839895197437882e-10
R1195_1231	1195	1231	1.1931432867059805e+03
C1195_1231	1195	1231	7.4208922898477389e-10
R1195_1256	1195	1256	1.5613279654435357e+03
C1195_1256	1195	1256	5.6709339824607187e-10
R1195_1257	1195	1257	1.5971709447265714e+03
C1195_1257	1195	1257	5.5436694777313268e-10
R1196_1197	1196	1197	2.6649233993146818e+03
C1196_1197	1196	1197	3.3224924285917433e-10
R1196_1198	1196	1198	4.9366400095676408e+03
C1196_1198	1196	1198	1.7935656235495820e-10
R1196_1199	1196	1199	1.4112766419838319e+04
C1196_1199	1196	1199	6.2738853273683238e-11
R1196_1260	1196	1260	5.7595446086682450e+03
C1196_1260	1196	1260	1.5373069259111646e-10
R1196_1261	1196	1261	2.5965305103031755e+04
C1196_1261	1196	1261	3.4100072315214853e-11
R1197_1198	1197	1198	2.0761643627370545e+03
C1197_1198	1197	1198	4.2646853861451144e-10
R1197_1199	1197	1199	2.6859813549752907e+03
C1197_1199	1197	1199	3.2964442588550489e-10
R1197_1201	1197	1201	5.2359999821217507e+03
C1197_1201	1197	1201	1.6910213611979574e-10
R1197_1232	1197	1232	1.6570526865549109e+03
C1197_1232	1197	1232	5.3433351207487966e-10
R1197_1260	1197	1260	2.2847501228070037e+03
C1197_1260	1197	1260	3.8753418715749547e-10
R1197_1263	1197	1263	7.0356670509889964e+03
C1197_1263	1197	1263	1.2584716918569046e-10
R1198_1201	1198	1201	2.5768101987928130e+03
C1198_1201	1198	1201	3.4361039944455426e-10
R1198_1260	1198	1260	3.2883747838521772e+03
C1198_1260	1198	1260	2.6925725925399947e-10
R1198_1261	1198	1261	3.7604780852339741e+03
C1198_1261	1198	1261	2.3545378051176960e-10
R1198_1263	1198	1263	2.3888690200665783e+03
C1198_1263	1198	1263	3.7064350295577245e-10
R1198_1258	1198	1258	3.2729869472059650e+03
C1198_1258	1198	1258	2.7052316308681013e-10
R1199_1230	1199	1230	2.4777073226095504e+03
C1199_1230	1199	1230	3.5735406422719310e-10
R1199_1232	1199	1232	6.2534236490307085e+03
C1199_1232	1199	1232	1.4158944466160412e-10
R1199_1257	1199	1257	1.5521832139249194e+04
C1199_1257	1199	1257	5.7043445242594195e-11
R1199_1260	1199	1260	4.6916511206344030e+03
C1199_1260	1199	1260	1.8872221291259911e-10
R1199_1264	1199	1264	1.3354062239634428e+04
C1199_1264	1199	1264	6.6303328965481800e-11
R1200_1201	1200	1201	8.4801622405233702e+03
C1200_1201	1200	1201	1.0441059458378414e-10
R1200_1202	1200	1202	2.1691653270752158e+03
C1200_1202	1200	1202	4.0818409304644861e-10
R1200_1203	1200	1203	7.2765057842668248e+03
C1200_1203	1200	1203	1.2168186323914457e-10
R1200_1233	1200	1233	3.3727206852903532e+03
C1200_1233	1200	1233	2.6252360166130256e-10
R1200_1240	1200	1240	2.5338743940437284e+03
C1200_1240	1200	1240	3.4943278316451543e-10
R1200_1262	1200	1262	8.0125589463389088e+03
C1200_1262	1200	1262	1.1050387118893707e-10
R1200_1265	1200	1265	6.8987066469383763e+03
C1200_1265	1200	1265	1.2834561998558760e-10
R1201_1203	1201	1203	5.8288354678295118e+03
C1201_1203	1201	1203	1.5190320375086933e-10
R1201_1232	1201	1232	6.7288438717590543e+03
C1201_1232	1201	1232	1.3158557377383969e-10
R1201_1233	1201	1233	7.0900091895239648e+03
C1201_1233	1201	1233	1.2488260001246185e-10
R1201_1263	1201	1263	6.8544770413898304e+03
C1201_1263	1201	1263	1.2917379055375323e-10
R1201_1258	1201	1258	5.6601040068717512e+03
C1201_1258	1201	1258	1.5643153917755601e-10
R1201_1265	1201	1265	4.1836362128157543e+03
C1201_1265	1201	1265	2.1163856909635026e-10
R1202_1203	1202	1203	7.4942928359123815e-06
C1202_1203	1202	1203	9.0578401509021177e-11
R1202_1204	1202	1204	1.7309948609797931e-06
C1202_1204	1202	1204	5.1150861372218492e-11
R1202_1240	1202	1240	4.5659990721682761e+03
C1202_1240	1202	1240	1.9391567271596868e-10
R1202_1242	1202	1242	1.1676039672103806e-05
C1202_1242	1202	1242	8.3415326279081547e-11
R1202_1245	1202	1245	5.7913248438191346e-06
C1202_1245	1202	1245	1.5288708638835455e-11
R1202_1262	1202	1262	5.9877289052077268e-06
C1202_1262	1202	1262	1.6265944472685689e-10
R1202_1265	1202	1265	1.1569010330164274e-05
C1202_1265	1202	1265	8.4187033384921333e-11
R1203_1204	1203	1204	8.2475638747752457e-06
C1203_1204	1203	1204	1.0735518937998267e-11
R1203_1205	1203	1205	4.8465075103546481e-06
C1203_1205	1203	1205	1.8269213032442172e-11
R1203_1258	1203	1258	1.4836247473259323e-05
C1203_1258	1203	1258	3.5807657543586775e-11
R1203_1265	1203	1265	8.4417343832241146e-06
C1203_1265	1203	1265	1.1537447338209883e-10
R1203_1267	1203	1267	7.4917754615504255e-06
C1203_1267	1203	1267	1.1818544031974528e-11
R1203_1259	1203	1259	2.2106008746209413e-05
C1203_1259	1203	1259	4.0053308214302838e-12
R1204_1205	1204	1205	1.6246975770569600e-05
C1204_1205	1204	1205	5.4497451969115511e-12
R1204_1245	1204	1245	1.2985968604526860e-05
C1204_1245	1204	1245	6.8182729272219722e-12
R1204_1262	1204	1262	1.2730315309349163e-05
C1204_1262	1204	1262	6.9551991461652735e-12
R1204_1265	1204	1265	1.0649415509232233e-05
C1204_1265	1204	1265	8.3142476780289903e-12
R1204_1266	1204	1266	1.1341722660866402e-05
C1204_1266	1204	1266	7.8067398416914040e-12
R1204_1267	1204	1267	1.1235666270296865e-05
C1204_1267	1204	1267	7.8804296994895136e-12
R1205_1267	1205	1267	5.7866506354042251e-06
C1205_1267	1205	1267	1.5301058202525290e-11
R1205_1259	1205	1259	1.4983350403633308e-05
C1205_1259	1205	1259	5.9093510987055010e-12
R1206_1207	1206	1207	4.2902115215584327e+03
C1206_1207	1206	1207	2.0638114863352215e-10
R1206_1212	1206	1212	2.6957556171978781e+03
C1206_1212	1206	1212	3.2844920216482936e-10
R1206_1214	1206	1214	3.2867906163730422e+03
C1206_1214	1206	1214	2.6938703587910797e-10
R1206_1271	1206	1271	9.8144523769139778e+03
C1206_1271	1206	1271	9.0215811101465456e-11
R1207_1209	1207	1209	5.2100316880777455e+03
C1207_1209	1207	1209	1.6994498972551886e-10
R1207_1210	1207	1210	6.1775611565843319e+03
C1207_1210	1207	1210	1.4332820983184920e-10
R1207_1212	1207	1212	7.8518332861984381e+03
C1207_1212	1207	1212	1.1276586619030045e-10
R1207_1220	1207	1220	7.9370053178547814e+03
C1207_1220	1207	1220	1.1155577528821813e-10
R1207_1271	1207	1271	1.0471146418811239e+04
C1207_1271	1207	1271	8.4557960158914438e-11
R1208_1209	1208	1209	1.6041109007118027e+03
C1208_1209	1208	1209	5.5196855859972478e-10
R1208_1220	1208	1220	3.6329511783712023e+03
C1208_1220	1208	1220	2.4371887708575501e-10
R1208_1221	1208	1221	7.9911781998671286e+03
C1208_1221	1208	1221	1.1079952912509473e-10
R1208_1223	1208	1223	9.4564766337056244e+03
C1208_1223	1208	1223	9.3630938455884390e-11
R1208_1226	1208	1226	2.5290624119660611e+03
C1208_1226	1208	1226	3.5009763994384249e-10
R1208_1228	1208	1228	3.8492044505164108e+03
C1208_1228	1208	1228	2.3002643613311103e-10
R1208_1272	1208	1272	7.6247283729376568e+03
C1208_1272	1208	1272	1.1612463269414355e-10
R1209_1210	1209	1210	1.2725209803530386e+03
C1209_1210	1209	1210	6.9579896549474268e-10
R1209_1220	1209	1220	4.0909058824561448e+03
C1209_1220	1209	1220	2.1643587194149825e-10
R1209_1226	1209	1226	4.1679897447173089e+03
C1209_1226	1209	1226	2.1243305188603647e-10
R1209_1227	1209	1227	2.3301840596737788e+03
C1209_1227	1209	1227	3.7997804423396354e-10
R1209_1272	1209	1272	4.7763619500167688e+03
C1209_1272	1209	1272	1.8537514345973957e-10
R1210_1212	1210	1212	4.1718930651971305e+03
C1210_1212	1210	1212	2.1223429456674299e-10
R1210_1220	1210	1220	5.9526399225832693e+03
C1210_1220	1210	1220	1.4874388392633609e-10
R1210_1227	1210	1227	3.4454030988417030e+03
C1210_1227	1210	1227	2.5698554169109145e-10
R1210_1249	1210	1249	4.8861186167338501e+03
C1210_1249	1210	1249	1.8121106979835513e-10
R1210_1270	1210	1270	1.4554798436837600e+03
C1210_1270	1210	1270	6.0833462279975058e-10
R1210_1271	1210	1271	5.8875605161381927e+03
C1210_1271	1210	1271	1.5038805618609077e-10
R1210_1272	1210	1272	5.6075040370719034e+03
C1210_1272	1210	1272	1.5789891114591928e-10
R1211_1213	1211	1213	5.6992159670011924e+03
C1211_1213	1211	1213	1.5535799780647527e-10
R1211_1215	1211	1215	1.0194899617738140e+04
C1211_1215	1211	1215	8.6849190761962682e-11
R1211_1216	1211	1216	2.3279106664819592e+03
C1211_1216	1211	1216	3.8034912355038254e-10
R1211_1218	1211	1218	3.7580448695177515e+03
C1211_1218	1211	1218	2.3560622942046479e-10
R1211_1237	1211	1237	7.3588562122525655e+03
C1211_1237	1211	1237	1.2032016337345597e-10
R1211_1248	1211	1248	3.1028416065076199e+03
C1211_1248	1211	1248	2.8535738976910798e-10
R1211_1254	1211	1254	4.0860685864456464e+03
C1211_1254	1211	1254	2.1669209974524693e-10
R1211_1273	1211	1273	8.4639512139759845e+03
C1211_1273	1211	1273	1.0461057245202030e-10
R1212_1214	1212	1214	4.7382694347233210e+03
C1212_1214	1212	1214	1.8686543555573507e-10
R1212_1213	1212	1213	3.4021810091977873e+03
C1212_1213	1212	1213	2.6025034508930386e-10
R1212_1249	1212	1249	3.2589174908479422e+03
C1212_1249	1212	1249	2.7169107048169594e-10
R1212_1270	1212	1270	4.7424260872155783e+03
C1212_1270	1212	1270	1.8670165131025926e-10
R1212_1271	1212	1271	1.7823213250285555e+03
C1212_1271	1212	1271	4.9677842556577968e-10
R1212_1274	1212	1274	7.3691588899853559e+03
C1212_1274	1212	1274	1.2015194609296305e-10
R1212_1275	1212	1275	1.0854890052363598e+04
C1212_1275	1212	1275	8.1568654995930105e-11
R1213_1214	1213	1214	2.6875384502402521e+03
C1213_1214	1213	1214	3.2945343781810755e-10
R1213_1215	1213	1215	6.8852910807761500e+03
C1213_1215	1213	1215	1.2859569353169457e-10
R1213_1216	1213	1216	1.0067113483862641e+03
C1213_1216	1213	1216	8.7951604312329112e-10
R1213_1248	1213	1248	2.2396153752002260e+03
C1213_1248	1213	1248	3.9534412538172625e-10
R1213_1249	1213	1249	7.0073524189175114e+03
C1213_1249	1213	1249	1.2635568025801943e-10
R1213_1274	1213	1274	3.4340532600982915e+03
C1213_1274	1213	1274	2.5783490081183454e-10
R1213_1275	1213	1275	3.3087439423180349e+03
C1213_1275	1213	1275	2.6759966837436651e-10
R1214_1215	1214	1215	3.4615373900619616e+03
C1214_1215	1214	1215	2.5578772722260008e-10
R1214_1271	1214	1271	8.6369488112025174e+03
C1214_1271	1214	1271	1.0251522858993579e-10
R1214_1275	1214	1275	3.9338829891688365e+03
C1214_1275	1214	1275	2.2507501726355980e-10
R1215_1216	1215	1216	2.7947897167174306e+03
C1215_1216	1215	1216	3.1681051937601683e-10
R1215_1217	1215	1217	7.2552792074576682e+03
C1215_1217	1215	1217	1.2203786461999731e-10
R1215_1218	1215	1218	6.1247553826697658e+03
C1215_1218	1215	1218	1.4456394196661750e-10
R1215_1275	1215	1275	7.7253806039655028e+03
C1215_1275	1215	1275	1.1461167120303529e-10
R1215_1276	1215	1276	7.3166128282725258e+03
C1215_1276	1215	1276	1.2101484696287401e-10
R1216_1218	1216	1218	5.9373201125405294e+03
C1216_1218	1216	1218	1.4912768133048107e-10
R1216_1248	1216	1248	3.4330893600880318e+03
C1216_1248	1216	1248	2.5790729247935918e-10
R1216_1273	1216	1273	2.5729348870735480e+03
C1216_1273	1216	1273	3.4412793971132085e-10
R1216_1274	1216	1274	3.7976419561420348e+03
C1216_1274	1216	1274	2.3314962071871648e-10
R1216_1275	1216	1275	2.0298274697767172e+03
C1216_1275	1216	1275	4.3620396062400160e-10
R1216_1276	1216	1276	5.0833553231263750e+03
C1216_1276	1216	1276	1.7417999046256872e-10
R1217_1218	1217	1218	9.0601459125739830e-06
C1217_1218	1217	1218	1.5636282928168862e-10
R1217_1219	1217	1219	3.6048457327352425e-06
C1217_1219	1217	1219	2.4561904928679775e-11
R1217_1276	1217	1276	2.2070484055900391e-05
C1217_1276	1217	1276	4.4129555855194663e-11
R1218_1219	1218	1219	3.7766900192368394e-06
C1218_1219	1218	1219	2.3444306447975781e-11
R1218_1254	1218	1254	7.3847515068296248e-06
C1218_1254	1218	1254	1.9183719957060420e-10
R1218_1255	1218	1255	1.4613480696401929e-06
C1218_1255	1218	1255	6.0589177903249567e-11
R1218_1273	1218	1273	6.0142423954568054e-06
C1218_1273	1218	1273	1.6194236860685478e-10
R1218_1276	1218	1276	5.6450967089168351e-06
C1218_1276	1218	1276	1.7253214765259887e-10
R1218_1277	1218	1277	6.3511577357146103e-06
C1218_1277	1218	1277	1.3941061118998894e-11
R1219_1255	1219	1255	1.4627995552287990e-05
C1219_1255	1219	1255	6.0529057350001046e-12
R1219_1276	1219	1276	2.0267976332895475e-05
C1219_1276	1219	1276	4.3685603691126344e-12
R1219_1277	1219	1277	1.3602668679795625e-05
C1219_1277	1219	1277	6.5091549499778233e-12
R1220_1221	1220	1221	1.0167227872175969e+04
C1220_1221	1220	1221	8.7085564800123294e-11
R1220_1228	1220	1228	1.0503228498142391e+04
C1220_1228	1220	1228	8.4299678128167543e-11
R1220_1271	1220	1271	1.1945168074266045e+04
C1220_1271	1220	1271	7.4123593422472919e-11
R1220_1270	1220	1270	1.0058843916776757e+04
C1220_1270	1220	1270	8.8023911000671192e-11
R1220_1272	1220	1272	3.4888116476009577e+03
C1220_1272	1220	1272	2.5378807202413701e-10
R1220_1279	1220	1279	9.0492194832579316e+03
C1220_1279	1220	1279	9.7844768086145298e-11
R1220_1280	1220	1280	9.3467615192372759e+03
C1220_1280	1220	1280	9.4730006738446527e-11
R1221_1228	1221	1228	7.5632864179346834e+03
C1221_1228	1221	1228	1.1706799567981756e-10
R1221_1280	1221	1280	2.3565347977881378e+04
C1221_1280	1221	1280	3.7572913522476356e-11
R1222_1224	1222	1224	1.5790119556569678e+03
C1222_1224	1222	1224	5.6074229110672592e-10
R1222_1225	1222	1225	4.6465316190113799e+03
C1222_1225	1222	1225	1.9055477381823697e-10
R1222_1226	1222	1226	2.3553311596107305e+03
C1222_1226	1222	1226	3.7592114301512265e-10
R1222_1251	1222	1251	1.6737201944183371e+03
C1222_1251	1222	1251	5.2901242672028996e-10
R1222_1256	1222	1256	5.7549299203438486e+03
C1222_1256	1222	1256	1.5385396415862830e-10
R1222_1282	1222	1282	3.0730585584321693e+03
C1222_1282	1222	1282	2.8812297743903980e-10
R1223_1224	1223	1224	9.0785584663868121e+02
C1223_1224	1223	1224	9.7528565242846218e-10
R1223_1225	1223	1225	6.9700402640945749e+03
C1223_1225	1223	1225	1.2703208993800817e-10
R1223_1226	1223	1226	2.2377604445160828e+03
C1223_1226	1223	1226	3.9567183514653313e-10
R1223_1228	1223	1228	4.4282146621218781e+03
C1223_1228	1223	1228	1.9994938124244678e-10
R1223_1283	1223	1283	3.8818468586817362e+03
C1223_1283	1223	1283	2.2809214632456825e-10
R1224_1225	1224	1225	1.5906904146140589e+03
C1224_1225	1224	1225	5.5662545870990535e-10
R1224_1226	1224	1226	1.6265597573746561e+03
C1224_1226	1224	1226	5.4435060112953216e-10
R1224_1282	1224	1282	2.9389764096146378e+03
C1224_1282	1224	1282	3.0126774029332791e-10
R1224_1283	1224	1283	3.4464235197435714e+03
C1224_1283	1224	1283	2.5690945312660791e-10
R1225_1256	1225	1256	4.6564232324407321e+03
C1225_1256	1225	1256	1.9014997939435477e-10
R1225_1257	1225	1257	1.2769406973763675e+04
C1225_1257	1225	1257	6.9339068252676298e-11
R1225_1282	1225	1282	7.5833185750490347e+03
C1225_1282	1225	1282	1.1675874789346761e-10
R1225_1283	1225	1283	1.2362164538117955e+04
C1225_1283	1225	1283	7.1623280774970046e-11
R1225_1284	1225	1284	9.5573713795471522e+03
C1225_1284	1225	1284	9.2642500384028524e-11
R1226_1227	1226	1227	2.0233835253917380e+03
C1226_1227	1226	1227	4.3759315551834314e-10
R1226_1228	1226	1228	7.4797587571642607e+03
C1226_1228	1226	1228	1.1837531268664629e-10
R1226_1251	1226	1251	8.3495254122508068e+03
C1226_1251	1226	1251	1.0604420466831241e-10
R1226_1272	1226	1272	7.4359167959905781e+03
C1226_1272	1226	1272	1.1907325027862267e-10
R1226_1282	1226	1282	3.2298710419600357e+03
C1226_1282	1226	1282	2.7413440666742126e-10
R1226_1283	1226	1283	6.1461796638969763e+03
C1226_1283	1226	1283	1.4406002266757714e-10
R1226_1285	1226	1285	8.5814489602246995e+03
C1226_1285	1226	1285	1.0317823782486449e-10
R1227_1249	1227	1249	7.8035711462321888e+02
C1227_1249	1227	1249	1.1346328047864449e-09
R1227_1250	1227	1250	1.3934277708183597e+03
C1227_1250	1227	1250	6.3542495724769003e-10
R1227_1251	1227	1251	1.6850280222592526e+03
C1227_1251	1227	1251	5.2546234840228233e-10
R1227_1270	1227	1270	1.3893784687259783e+03
C1227_1270	1227	1270	6.3727688432648936e-10
R1227_1272	1227	1272	1.6310201939955141e+03
C1227_1272	1227	1272	5.4286193693959591e-10
R1227_1281	1227	1281	6.8887835587714926e+02
C1227_1281	1227	1281	1.2853049804019402e-09
R1227_1282	1227	1282	2.1013389712683074e+03
C1227_1282	1227	1282	4.2135933031574957e-10
R1227_1285	1227	1285	1.9990927517386592e+03
C1227_1285	1227	1285	4.4291030565236652e-10
R1228_1272	1228	1272	3.6651708888612643e+03
C1228_1272	1228	1272	2.4157639808579068e-10
R1228_1280	1228	1280	6.9011655494886354e+03
C1228_1280	1228	1280	1.2829989012009834e-10
R1228_1283	1228	1283	6.9982022130482619e+03
C1228_1283	1228	1283	1.2652089132965068e-10
R1228_1285	1228	1285	7.5407442966432536e+03
C1228_1285	1228	1285	1.1741795595617031e-10
R1228_1286	1228	1286	7.1015983244265453e+03
C1228_1286	1228	1286	1.2467880345393903e-10
R1229_1231	1229	1231	2.1846778183300635e+03
C1229_1231	1229	1231	4.0528574706580823e-10
R1229_1235	1229	1235	9.8473533527097352e+03
C1229_1235	1229	1235	8.9914391206075258e-11
R1229_1252	1229	1252	4.1392937445926564e+03
C1229_1252	1229	1252	2.1390576178766288e-10
R1229_1251	1229	1251	9.3850574698211112e+03
C1229_1251	1229	1251	9.4343458689217485e-11
R1229_1253	1229	1253	8.8156254849015368e+03
C1229_1253	1229	1253	1.0043743160555661e-10
R1229_1256	1229	1256	4.7758881848349583e+03
C1229_1256	1229	1256	1.8539353256039381e-10
R1229_1287	1229	1287	7.0128925536335992e+03
C1229_1287	1229	1287	1.2625586017872708e-10
R1230_1231	1230	1231	1.8150768280839823e+03
C1230_1231	1230	1231	4.8781339059606583e-10
R1230_1232	1230	1232	2.0035717662191466e+03
C1230_1232	1230	1232	4.4192017307712185e-10
R1230_1256	1230	1256	6.6657793200253655e+03
C1230_1256	1230	1256	1.3283049725934084e-10
R1230_1257	1230	1257	1.9559147559874382e+03
C1230_1257	1230	1257	4.5268781729344779e-10
R1230_1260	1230	1260	6.6264600283564869e+03
C1230_1260	1230	1260	1.3361867089079899e-10
R1230_1264	1230	1264	2.2731575707912784e+03
C1230_1264	1230	1264	3.8951051747450517e-10
R1230_1287	1230	1287	4.7786721283606103e+03
C1230_1287	1230	1287	1.8528552658911025e-10
R1230_1288	1230	1288	2.0992286014518963e+03
C1230_1288	1230	1288	4.2178292592222435e-10
R1231_1232	1231	1232	2.8580443160881186e+03
C1231_1232	1231	1232	3.0979882877110053e-10
R1231_1233	1231	1233	6.1239903119134206e+03
C1231_1233	1231	1233	1.4458200235515298e-10
R1231_1253	1231	1253	8.2345664870263790e+03
C1231_1253	1231	1253	1.0752463813304366e-10
R1231_1256	1231	1256	6.3160510927502410e+03
C1231_1256	1231	1256	1.4018550019589159e-10
R1231_1287	1231	1287	3.2929246268839056e+03
C1231_1287	1231	1287	2.6888522575685916e-10
R1231_1288	1231	1288	7.2181579198316804e+03
C1231_1288	1231	1288	1.2266547664014631e-10
R1231_1289	1231	1289	4.1057885751379845e+03
C1231_1289	1231	1289	2.1565133359801497e-10
R1232_1233	1232	1233	1.5117462004992778e+03
C1232_1233	1232	1233	5.8569274485861208e-10
R1232_1260	1232	1260	2.1713127779174679e+03
C1232_1260	1232	1260	4.0778039474774136e-10
R1232_1263	1232	1263	2.6660376511777199e+03
C1232_1263	1232	1263	3.3211038160277549e-10
R1232_1265	1232	1265	3.1947885127915392e+03
C1232_1265	1232	1265	2.7714472433930835e-10
R1232_1288	1232	1288	8.2383825660994341e+02
C1232_1288	1232	1288	1.0747483193405677e-09
R1232_1289	1232	1289	2.1230064249305756e+03
C1232_1289	1232	1289	4.1705892704915119e-10
R1233_1240	1233	1240	2.2357847454181970e+03
C1233_1240	1233	1240	3.9602147904197505e-10
R1233_1253	1233	1253	1.6634812479381555e+03
C1233_1253	1233	1253	5.3226856797902292e-10
R1233_1262	1233	1262	2.4905207907849176e+03
C1233_1262	1233	1262	3.5551551505857928e-10
R1233_1265	1233	1265	2.6240232239155143e+03
C1233_1265	1233	1265	3.3742795171560874e-10
R1233_1289	1233	1289	1.2856346565388978e+03
C1233_1289	1233	1289	6.8870170634919502e-10
R1234_1235	1234	1235	3.9101942579741990e+03
C1234_1235	1234	1235	2.2643856629228433e-10
R1234_1237	1234	1237	2.8557759904201353e+03
C1234_1237	1234	1237	3.1004490011478088e-10
R1234_1248	1234	1248	4.3926655236466768e+03
C1234_1248	1234	1248	2.0156753955738210e-10
R1234_1249	1234	1249	5.9697894650006247e+03
C1234_1249	1234	1249	1.4831658417620721e-10
R1234_1250	1234	1250	1.7271064255162325e+03
C1234_1250	1234	1250	5.1266023252466809e-10
R1234_1252	1234	1252	3.9354138490068640e+03
C1234_1252	1234	1252	2.2498746400545479e-10
R1234_1290	1234	1290	1.8366335143980152e+03
C1234_1290	1234	1290	4.8208789328893944e-10
R1234_1291	1234	1291	5.5710827266599490e+03
C1234_1291	1234	1291	1.5893118539828937e-10
R1235_1237	1235	1237	1.0085605836213417e+04
C1235_1237	1235	1237	8.7790341609505680e-11
R1235_1238	1235	1238	2.9201369702307379e+03
C1235_1238	1235	1238	3.0321138724874188e-10
R1235_1252	1235	1252	6.2563917511668988e+03
C1235_1252	1235	1252	1.4152227304737716e-10
R1235_1253	1235	1253	3.6995417474752744e+03
C1235_1253	1235	1253	2.3933201518924550e-10
R1235_1291	1235	1291	3.8532150416698955e+03
C1235_1291	1235	1291	2.2978701477202781e-10
R1236_1239	1236	1239	2.6734076059727661e-06
C1236_1239	1236	1239	3.3119483154078361e-11
R1236_1247	1236	1247	6.0046311914679233e-06
C1236_1247	1236	1247	1.4745598080330158e-11
R1236_1254	1236	1254	5.7331175855814838e-06
C1236_1254	1236	1254	1.5443932005280791e-11
R1236_1255	1236	1255	5.9305180832410773e-06
C1236_1255	1236	1255	1.4929872386732719e-11
R1236_1293	1236	1293	5.4905357227888748e-06
C1236_1293	1236	1293	1.6126273034250626e-11
R1237_1238	1237	1238	2.1353938341489043e+03
C1237_1238	1237	1238	4.1463957024718946e-10
R1237_1239	1237	1239	1.9040062100819059e+03
C1237_1239	1237	1239	4.6502935600294669e-10
R1237_1241	1237	1241	2.0288565575561927e+03
C1237_1241	1237	1241	4.3641270665606274e-10
R1237_1248	1237	1248	3.0830493791276026e+03
C1237_1248	1237	1248	2.8718929631627998e-10
R1237_1254	1237	1254	2.3815399800055734e+03
C1237_1254	1237	1254	3.7178413511157089e-10
R1237_1290	1237	1290	1.5270916182678882e+03
C1237_1290	1237	1290	5.7980724346080239e-10
R1237_1291	1237	1291	2.2336753465731581e+03
C1237_1291	1237	1291	3.9639546680693082e-10
R1237_1292	1237	1292	2.2255211780190743e+03
C1237_1292	1237	1292	3.9784783467578899e-10
R1237_1294	1237	1294	3.9233938632803729e+03
C1237_1294	1237	1294	2.2567675144388795e-10
R1238_1240	1238	1240	2.1599144814602710e+03
C1238_1240	1238	1240	4.0993233264559056e-10
R1238_1241	1238	1241	1.0263317066828317e+03
C1238_1241	1238	1241	8.6270235629933807e-10
R1238_1242	1238	1242	3.2383528677420054e+03
C1238_1242	1238	1242	2.7341639959000913e-10
R1238_1243	1238	1243	1.9665810495830422e+03
C1238_1243	1238	1243	4.5023254032053657e-10
R1238_1253	1238	1253	2.8931451590537367e+03
C1238_1253	1238	1253	3.0604022025275590e-10
R1238_1291	1238	1291	3.4016149635681572e+03
C1238_1291	1238	1291	2.6029365203968632e-10
R1238_1294	1238	1294	1.6419762016728810e+03
C1238_1294	1238	1294	5.3923971662799749e-10
R1239_1241	1239	1241	1.2017938547676974e+03
C1239_1241	1239	1241	7.3674763620017711e-10
R1239_1243	1239	1243	3.4308018258243270e-06
C1239_1243	1239	1243	2.8388718099799417e-10
R1239_1246	1239	1246	5.9666775390907373e-07
C1239_1246	1239	1246	1.4839393882092193e-10
R1239_1247	1239	1247	8.7621281803117916e-07
C1239_1247	1239	1247	1.0105065384566118e-10
R1239_1254	1239	1254	2.8649303986810533e-06
C1239_1254	1239	1254	3.3995962322310801e-10
R1239_1292	1239	1292	2.5145120870393135e-06
C1239_1292	1239	1292	2.6996134519151331e-10
R1239_1293	1239	1293	3.2937636798498368e-06
C1239_1293	1239	1293	2.6881672996660360e-11
R1239_1294	1239	1294	3.5590656903228794e-06
C1239_1294	1239	1294	2.7365627488816633e-10
R1240_1242	1240	1242	9.3765466469716455e+02
C1240_1242	1240	1242	9.4429091544696259e-10
R1240_1253	1240	1253	1.1624467479418720e+03
C1240_1253	1240	1253	7.6168545635973986e-10
R1240_1262	1240	1262	9.2400859007651354e+02
C1240_1262	1240	1262	9.5823652637978412e-10
R1240_1294	1240	1294	2.9810203709260786e+03
C1240_1294	1240	1294	2.9701869545592453e-10
R1241_1243	1241	1243	2.2220492990020657e+03
C1241_1243	1241	1243	3.9846945884488089e-10
R1241_1294	1241	1294	6.8434631142991084e+03
C1241_1294	1241	1294	1.2938168393864175e-10
R1242_1243	1242	1243	2.5138550275527184e-06
C1242_1243	1242	1243	3.8743708297459275e-10
R1242_1244	1242	1244	4.2145323263151824e-06
C1242_1244	1242	1244	2.1008707803034758e-11
R1242_1245	1242	1245	1.2433049065594748e-06
C1242_1245	1242	1245	7.1214935051625238e-11
R1242_1262	1242	1262	5.2308373508852029e-06
C1242_1262	1242	1262	1.2977292543852035e-10
R1242_1294	1242	1294	6.5845164251024283e-06
C1242_1294	1242	1294	2.1515172218177860e-10
R1242_1296	1242	1296	4.0788652119312409e-06
C1242_1296	1242	1296	2.1707478322893054e-11
R1243_1244	1243	1244	1.5888104447624795e-06
C1243_1244	1243	1244	5.5728408924978237e-11
R1243_1246	1243	1246	8.9786884168399770e-07
C1243_1246	1243	1246	9.8613376541650886e-11
R1243_1294	1243	1294	3.9810416533180709e-06
C1243_1294	1243	1294	2.4464970319621610e-10
R1243_1296	1243	1296	5.0881852677530232e-06
C1243_1296	1243	1296	1.7401465062827930e-11
R1244_1245	1244	1245	3.6439405686384665e-06
C1244_1245	1244	1245	2.4298387007745043e-11
R1244_1246	1244	1246	7.8656432223074202e-07
C1244_1246	1244	1246	1.1256787991462680e-10
R1244_1247	1244	1247	4.6759536211347807e-06
C1244_1247	1244	1247	1.8935576642548533e-11
R1244_1296	1244	1296	3.6410121349936909e-06
C1244_1296	1244	1296	2.4317929984090377e-11
R1245_1262	1245	1262	6.8069295115248563e-06
C1245_1262	1245	1262	1.3007609087194041e-11
R1245_1266	1245	1266	1.2327873578771987e-05
C1245_1266	1245	1266	7.1822506618225645e-12
R1245_1296	1245	1296	8.4524008483626100e-06
C1245_1296	1245	1296	1.0475352477769939e-11
R1246_1247	1246	1247	7.0797220050333820e-07
C1246_1247	1246	1247	1.2506406057617865e-10
R1246_1294	1246	1294	2.6889860773588029e-06
C1246_1294	1246	1294	3.2927607515531771e-11
R1246_1296	1246	1296	2.8961199036640226e-06
C1246_1296	1246	1296	3.0572587156347144e-11
R1247_1293	1247	1293	3.9805290759908074e-06
C1247_1293	1247	1293	2.2243746115071580e-11
R1247_1292	1247	1292	4.1909588751595287e-06
C1247_1292	1247	1292	2.1126878312932539e-11
R1247_1294	1247	1294	4.2037649735346499e-06
C1247_1294	1247	1294	2.1062518653499169e-11
R1247_1296	1247	1296	4.7332502866064531e-06
C1247_1296	1247	1296	1.8706358803916304e-11
R1247_1297	1247	1297	3.1630622064278729e-06
C1247_1297	1247	1297	2.7992455535673008e-11
R1248_1249	1248	1249	1.7978756844707434e+03
C1248_1249	1248	1249	4.9248053652866921e-10
R1248_1254	1248	1254	4.5339751540099669e+03
C1248_1254	1248	1254	1.9528531842899763e-10
R1248_1273	1248	1273	3.5092025656888950e+03
C1248_1273	1248	1273	2.5231338605447042e-10
R1248_1274	1248	1274	2.0966879417276068e+03
C1248_1274	1248	1274	4.2229402100268778e-10
R1248_1290	1248	1290	1.3144069216320011e+03
C1248_1290	1248	1290	6.7362607966233287e-10
R1248_1298	1248	1298	1.6492282194142056e+03
C1248_1298	1248	1298	5.3686856147446632e-10
R1248_1299	1248	1299	4.7519840286995941e+03
C1248_1299	1248	1299	1.8632612743488107e-10
R1249_1250	1249	1250	2.6640359512074479e+03
C1249_1250	1249	1250	3.3235992228208970e-10
R1249_1270	1249	1270	1.5927250553011656e+03
C1249_1270	1249	1270	5.5591439260216680e-10
R1249_1274	1249	1274	5.0683393705525223e+03
C1249_1274	1249	1274	1.7469603295398048e-10
R1249_1281	1249	1281	2.9060198534006590e+03
C1249_1281	1249	1281	3.0468435398466825e-10
R1249_1290	1249	1290	5.8391983140202437e+03
C1249_1290	1249	1290	1.5163362059035737e-10
R1249_1298	1249	1298	3.5078146673726201e+03
C1249_1298	1249	1298	2.5241321610733377e-10
R1249_1300	1249	1300	9.0428848228129700e+03
C1249_1300	1249	1300	9.7913309640559249e-11
R1250_1251	1250	1251	1.9367338502760758e+03
C1250_1251	1250	1251	4.5717111908473438e-10
R1250_1252	1250	1252	1.2137859899900334e+03
C1250_1252	1250	1252	7.2946861226110397e-10
R1250_1281	1250	1281	3.8441911791482139e+03
C1250_1281	1250	1281	2.3032641729753639e-10
R1250_1290	1250	1290	5.0474790475788714e+03
C1250_1290	1250	1290	1.7541802023422159e-10
R1250_1300	1250	1300	6.6008493790832108e+03
C1250_1300	1250	1300	1.3413709825067624e-10
R1251_1252	1251	1252	1.3591967351316976e+03
C1251_1252	1251	1252	6.5142797860988720e-10
R1251_1256	1251	1256	1.3475715639684879e+03
C1251_1256	1251	1256	6.5704768887562018e-10
R1251_1281	1251	1281	3.4670393294317873e+03
C1251_1281	1251	1281	2.5538181069469182e-10
R1251_1282	1251	1282	1.2983185620453489e+03
C1251_1282	1251	1282	6.8197344441038133e-10
R1251_1301	1251	1301	3.5485434684107227e+03
C1251_1301	1251	1301	2.4951611543779407e-10
R1252_1253	1252	1253	3.9827932786615493e+03
C1252_1253	1252	1253	2.2231100630900746e-10
R1252_1256	1252	1256	4.5360552592873619e+03
C1252_1256	1252	1256	1.9519576616425613e-10
R1252_1281	1252	1281	5.4726969129353593e+03
C1252_1281	1252	1281	1.6178838254448357e-10
R1252_1287	1252	1287	3.4348110208471339e+03
C1252_1287	1252	1287	2.5777801932218896e-10
R1252_1290	1252	1290	3.8003516633083582e+03
C1252_1290	1252	1290	2.3298338157716901e-10
R1252_1291	1252	1291	1.5372541247739828e+03
C1252_1291	1252	1291	5.7597424357549233e-10
R1252_1300	1252	1300	2.1383279473025218e+03
C1252_1300	1252	1300	4.1407062130808633e-10
R1252_1301	1252	1301	3.1321294765810321e+03
C1252_1301	1252	1301	2.8268907410127405e-10
R1252_1302	1252	1302	1.0116727967403841e+03
C1252_1302	1252	1302	8.7520271826308342e-10
R1253_1262	1253	1262	2.5740314867502284e+03
C1253_1262	1253	1262	3.4398133288488277e-10
R1253_1287	1253	1287	2.3016801032978669e+03
C1253_1287	1253	1287	3.8468368407554304e-10
R1253_1289	1253	1289	1.4174981422160654e+03
C1253_1289	1253	1289	6.2463487981421148e-10
R1253_1291	1253	1291	1.7511205962642643e+03
C1253_1291	1253	1291	5.0562981418235807e-10
R1253_1294	1253	1294	3.7652541838428497e+03
C1253_1294	1253	1294	2.3515511529060550e-10
R1253_1295	1253	1295	2.1255224861420120e+03
C1253_1295	1253	1295	4.1656523865202842e-10
R1253_1302	1253	1302	4.8562409837578480e+03
C1253_1302	1253	1302	1.8232595636447330e-10
R1254_1255	1254	1255	3.0882553471961644e-06
C1254_1255	1254	1255	2.8670517238928261e-11
R1254_1273	1254	1273	4.8352235628577323e-06
C1254_1273	1254	1273	2.0143032607170812e-10
R1254_1290	1254	1290	6.4068957500459901e+03
C1254_1290	1254	1290	1.3819778192795541e-10
R1254_1292	1254	1292	4.3852838593921239e-06
C1254_1292	1254	1292	3.2305093444768930e-10
R1254_1293	1254	1293	1.3555248328798049e-06
C1254_1293	1254	1293	6.5319259391134349e-11
R1254_1299	1254	1299	4.3940802442482746e-06
C1254_1299	1254	1299	2.2165290681045853e-10
R1254_1303	1254	1303	5.5349447925924699e-06
C1254_1303	1254	1303	1.5996885513383516e-11
R1255_1273	1255	1273	8.2073711684333446e-06
C1255_1273	1255	1273	1.0788092356605486e-11
R1255_1277	1255	1277	8.5249072710194480e-06
C1255_1277	1255	1277	1.0386257041293515e-11
R1255_1293	1255	1293	8.2418361524961795e-06
C1255_1293	1255	1293	1.0742979662751924e-11
R1255_1303	1255	1303	7.4738414070086231e-06
C1255_1303	1255	1303	1.1846903533030487e-11
R1256_1257	1256	1257	1.1954807771472490e+03
C1256_1257	1256	1257	7.4063824247584841e-10
R1256_1282	1256	1282	1.7338699235238137e+03
C1256_1282	1256	1282	5.1066044210544232e-10
R1256_1284	1256	1284	1.3477861945509890e+03
C1256_1284	1256	1284	6.5694305616105146e-10
R1256_1287	1256	1287	1.3483355877148490e+03
C1256_1287	1256	1287	6.5667537797515404e-10
R1256_1301	1256	1301	1.6818100417608532e+03
C1256_1301	1256	1301	5.2646776967330226e-10
R1256_1302	1256	1302	3.9067373646520264e+03
C1256_1302	1256	1302	2.2663893142938836e-10
R1256_1304	1256	1304	2.2128962819365429e+03
C1256_1304	1256	1304	4.0011761460648090e-10
R1257_1264	1257	1264	2.8359702598990893e+03
C1257_1264	1257	1264	3.1221017872433734e-10
R1257_1284	1257	1284	3.8720007936644838e+03
C1257_1284	1257	1284	2.2867215914541037e-10
R1257_1287	1257	1287	5.4696365646261729e+03
C1257_1287	1257	1287	1.6187890570760708e-10
R1257_1304	1257	1304	4.3431655310926790e+03
C1257_1304	1257	1304	2.0386484819915238e-10
R1257_1305	1257	1305	7.4123912113351698e+03
C1257_1305	1257	1305	1.1945116716802545e-10
R1258_1263	1258	1263	4.8633634299513087e-06
C1258_1263	1258	1263	2.9129430053907749e-10
R1258_1261	1258	1261	8.1178375840593427e-06
C1258_1261	1258	1261	6.5442460908255965e-11
R1258_1265	1258	1265	4.9469768568128562e-06
C1258_1265	1258	1265	1.3721937360240466e-10
R1258_1259	1258	1259	2.6518269454519632e-06
C1258_1259	1258	1259	3.3389010667477560e-11
R1258_1267	1258	1267	5.5861390242830122e-06
C1258_1267	1258	1267	1.5850281882550260e-11
R1258_1306	1258	1306	2.6515312764162624e-06
C1258_1306	1258	1306	3.3392733835548341e-11
R1259_1267	1259	1267	2.9728394454641664e-06
C1259_1267	1259	1267	2.9783605806594594e-11
R1259_1306	1259	1306	2.2039633026637368e-06
C1259_1306	1259	1306	4.0173934866786225e-11
R1259_1269	1259	1269	6.7087084768025312e-06
C1259_1269	1259	1269	1.3198051230898076e-11
R1259_1261	1259	1261	9.9959756304357692e-06
C1259_1261	1259	1261	8.8577525039584427e-12
R1259_1268	1259	1268	3.6928790197347804e-06
C1259_1268	1259	1268	2.3976382030613886e-11
R1260_1261	1260	1261	4.7208736236286386e+03
C1260_1261	1260	1261	1.8755401061116195e-10
R1260_1263	1260	1263	2.2715736366811984e+03
C1260_1263	1260	1263	3.8978211729627647e-10
R1260_1264	1260	1264	3.7806623188602812e+03
C1260_1264	1260	1264	2.3419673777342762e-10
R1260_1288	1260	1288	3.2722971487612372e+03
C1260_1288	1260	1288	2.7058018922125849e-10
R1260_1307	1260	1307	2.5959195930386591e+03
C1260_1307	1260	1307	3.4108097341473175e-10
R1261_1263	1261	1263	9.7604170336339441e-06
C1261_1263	1261	1263	1.4514441787817220e-10
R1261_1269	1261	1269	4.3691749701244309e-06
C1261_1269	1261	1269	2.0265125286909352e-11
R1261_1306	1261	1306	4.2202245135454267e-06
C1261_1306	1261	1306	2.0980371514788357e-11
R1261_1307	1261	1307	1.1185087917925998e-05
C1261_1307	1261	1307	4.7496387391193789e-11
R1262_1265	1262	1265	8.3349680006418254e-06
C1262_1265	1262	1265	1.5226216249182251e-10
R1262_1266	1262	1266	1.9545295138925651e-06
C1262_1266	1262	1266	4.5300865267398001e-11
R1262_1289	1262	1289	5.4461252787471267e+03
C1262_1289	1262	1289	1.6257774773475088e-10
R1262_1294	1262	1294	1.3847679114888520e-05
C1262_1294	1262	1294	1.0230378945391963e-10
R1262_1295	1262	1295	5.9441642020013605e-06
C1262_1295	1262	1295	1.6385157371125676e-10
R1262_1296	1262	1296	7.5426836126393998e-06
C1262_1296	1262	1296	1.1738776636690544e-11
R1262_1308	1262	1308	1.5574718211497192e-05
C1262_1308	1262	1308	6.2534721056915527e-11
R1263_1265	1263	1265	6.4718773450903413e-06
C1263_1265	1263	1265	2.8730140246891313e-10
R1263_1288	1263	1288	5.3272708301447501e+03
C1263_1288	1263	1288	1.6620494995106940e-10
R1263_1306	1263	1306	5.2883268658414580e-07
C1263_1306	1263	1306	1.6742890599655013e-10
R1263_1307	1263	1307	7.4529970143138393e-06
C1263_1307	1263	1307	1.9008058716167632e-10
R1263_1308	1263	1308	9.9907325554033846e-06
C1263_1308	1263	1308	9.7486410880780003e-11
R1264_1287	1264	1287	6.3319416391418863e+03
C1264_1287	1264	1287	1.3983369275336424e-10
R1264_1288	1264	1288	1.8543857255115006e+03
C1264_1288	1264	1288	4.7747281998505053e-10
R1264_1304	1264	1304	8.3346121117852181e+03
C1264_1304	1264	1304	1.0623395184138320e-10
R1264_1305	1264	1305	9.9611575987576853e+03
C1264_1305	1264	1305	8.8887137154664226e-11
R1264_1307	1264	1307	8.3962799804422666e+03
C1264_1307	1264	1307	1.0545369899079537e-10
R1264_1310	1264	1310	4.0238484150250933e+03
C1264_1310	1264	1310	2.2004277755440211e-10
R1265_1266	1265	1266	6.0018882767557587e-06
C1265_1266	1265	1266	1.4752336945842009e-11
R1265_1267	1265	1267	1.6255830386358986e-06
C1265_1267	1265	1267	5.4467766989190265e-11
R1265_1288	1265	1288	9.0568687734920659e+03
C1265_1288	1265	1288	9.7762129919721484e-11
R1265_1289	1265	1289	6.8594455588568453e+03
C1265_1289	1265	1289	1.2908022581457133e-10
R1265_1306	1265	1306	3.3224539446057088e-06
C1265_1306	1265	1306	2.6649542671240152e-11
R1265_1308	1265	1308	5.5816190061778894e-06
C1265_1308	1265	1308	1.3483649870181765e-10
R1265_1311	1265	1311	7.8512630461532085e-06
C1265_1311	1265	1311	1.1277405641552391e-11
R1266_1267	1266	1267	9.0466031495733695e-06
C1266_1267	1266	1267	9.7873065399332316e-12
R1266_1296	1266	1296	6.3030147877669477e-06
C1266_1296	1266	1296	1.4047544096175110e-11
R1266_1295	1266	1295	5.1983323796028720e-06
C1266_1295	1266	1295	1.7032746601086748e-11
R1266_1308	1266	1308	5.9507397732282472e-06
C1266_1308	1266	1308	1.4879137980178631e-11
R1266_1309	1266	1309	4.0802787913637528e-06
C1266_1309	1266	1309	2.1699957943414608e-11
R1266_1311	1266	1311	7.0667286724387371e-06
C1266_1311	1266	1311	1.2529401123793832e-11
R1267_1306	1267	1306	1.6794816795667412e-06
C1267_1306	1267	1306	5.2719764226806752e-11
R1267_1268	1267	1268	3.2610478096938783e-06
C1267_1268	1267	1268	2.7151358501030877e-11
R1267_1311	1267	1311	3.7527214375413771e-06
C1267_1311	1267	1311	2.3594044920107066e-11
R1268_1306	1268	1306	3.1215605409047079e-07
C1268_1306	1268	1306	2.8364619878344022e-10
R1268_1269	1268	1269	5.8925340269138354e-06
C1268_1269	1268	1269	1.5026112325459585e-11
R1268_1311	1268	1311	5.9089299182473308e-06
C1268_1311	1268	1311	1.4984418396395994e-11
R1268_1312	1268	1312	4.1820288949915011e-06
C1268_1312	1268	1312	2.1171991010401646e-11
R1269_1306	1269	1306	2.1358108253957793e-06
C1269_1306	1269	1306	4.1455861688308762e-11
R1269_1307	1269	1307	7.8404966737982682e-06
C1269_1307	1269	1307	1.1292891490649223e-11
R1269_1312	1269	1312	5.6381099676751595e-06
C1269_1312	1269	1312	1.5704177229184075e-11
R1270_1271	1270	1271	1.9999515420940306e+03
C1270_1271	1270	1271	4.4272011749491217e-10
R1270_1272	1270	1272	2.0076507273559021e+03
C1270_1272	1270	1272	4.4102232008557896e-10
R1270_1274	1270	1274	2.7525985679820874e+03
C1270_1274	1270	1274	3.2166651250897621e-10
R1270_1279	1270	1279	5.1820567145495470e+03
C1270_1279	1270	1279	1.7086242595802344e-10
R1270_1281	1270	1281	2.3999418505128492e+03
C1270_1281	1270	1281	3.6893343124575832e-10
R1270_1285	1270	1285	5.0202537800759537e+03
C1270_1285	1270	1285	1.7636932722684075e-10
R1270_1298	1270	1298	4.7173781242953974e+03
C1270_1298	1270	1298	1.8769298503758361e-10
R1270_1313	1270	1313	1.4914902617142288e+03
C1270_1313	1270	1313	5.9364704177307401e-10
R1271_1274	1271	1274	4.0282238489749684e+03
C1271_1274	1271	1274	2.1980376833459888e-10
R1271_1275	1271	1275	6.2939619325625417e+03
C1271_1275	1271	1275	1.4067749236282848e-10
R1271_1278	1271	1278	7.0851783798843098e+03
C1271_1278	1271	1278	1.2496774734900289e-10
R1271_1279	1271	1279	7.1253728107278293e+03
C1271_1279	1271	1279	1.2426280072909729e-10
R1271_1313	1271	1313	5.7037966015246739e+03
C1271_1313	1271	1313	1.5523323210075902e-10
R1272_1279	1272	1279	1.7234288971384938e+03
C1272_1279	1272	1279	5.1375416947581128e-10
R1272_1280	1272	1280	4.2637643829461113e+03
C1272_1280	1272	1280	2.0766128288923104e-10
R1272_1285	1272	1285	5.7730244517980998e+02
C1272_1285	1272	1285	1.5337173592331181e-09
R1272_1286	1272	1286	2.1112127612680110e+03
C1272_1286	1272	1286	4.1938870299751827e-10
R1272_1313	1272	1313	3.7379618418095051e+03
C1272_1313	1272	1313	2.3687207605933689e-10
R1272_1314	1272	1314	2.3238885545060252e+03
C1272_1314	1272	1314	3.8100741964719914e-10
R1273_1274	1273	1274	3.8042608256832864e+03
C1273_1274	1273	1274	2.3274397373659818e-10
R1273_1275	1273	1275	6.5599699687242828e+03
C1273_1275	1273	1275	1.3497299315719085e-10
R1273_1276	1273	1276	7.7267336100944169e-06
C1273_1276	1273	1276	1.8334656273696541e-10
R1273_1277	1273	1277	5.0022274002949983e-06
C1273_1277	1273	1277	1.7700490418484048e-11
R1273_1298	1273	1298	7.8080535827359090e+03
C1273_1298	1273	1298	1.1339814363693866e-10
R1273_1299	1273	1299	7.0603923812583302e-06
C1273_1299	1273	1299	2.0065032821058466e-10
R1273_1303	1273	1303	1.5967773966802753e-06
C1273_1303	1273	1303	5.5450357923452525e-11
R1273_1315	1273	1315	9.1796655583825253e-06
C1273_1315	1273	1315	1.5432697842693686e-10
R1273_1316	1273	1316	5.9070258321433460e-06
C1273_1316	1273	1316	1.6488173347680132e-10
R1274_1275	1274	1275	1.7442103273682808e+03
C1274_1275	1274	1275	5.0763303473609610e-10
R1274_1278	1274	1278	2.5304068709781664e+03
C1274_1278	1274	1278	3.4991162561842410e-10
R1274_1298	1274	1298	1.4475115669366050e+03
C1274_1298	1274	1298	6.1168338956615598e-10
R1274_1313	1274	1313	1.6957271204616534e+03
C1274_1313	1274	1313	5.2214697224335792e-10
R1274_1315	1274	1315	3.8199375681069323e+03
C1274_1315	1274	1315	2.3178880961104086e-10
R1274_1316	1274	1316	5.9116774370150351e+03
C1274_1316	1274	1316	1.4977454218934378e-10
R1275_1276	1275	1276	5.4897960534709200e+03
C1275_1276	1275	1276	1.6128445812485049e-10
R1275_1278	1275	1278	7.5909606259258571e+03
C1275_1278	1275	1278	1.1664120331173594e-10
R1275_1316	1275	1316	5.2320707175476336e+03
C1275_1316	1275	1316	1.6922913116033186e-10
R1276_1277	1276	1277	2.5600336136892221e-06
C1276_1277	1276	1277	3.4586217031113023e-11
R1276_1316	1276	1316	1.5673675170178731e-05
C1276_1316	1276	1316	6.2139903265899619e-11
R1277_1303	1277	1303	5.8608241735272037e-06
C1277_1303	1277	1303	1.5107410758018540e-11
R1277_1316	1277	1316	1.0219374750585007e-05
C1277_1316	1277	1316	8.6641189241965534e-12
R1277_1317	1277	1317	2.0575922316614117e-05
C1277_1317	1277	1317	4.3031790656842868e-12
R1278_1313	1278	1313	2.0122343300925650e+03
C1278_1313	1278	1313	4.4001772977368382e-10
R1278_1279	1278	1279	1.2626938294243524e+04
C1278_1279	1278	1279	7.0121415110078774e-11
R1278_1315	1278	1315	8.0463505356339165e+03
C1278_1315	1278	1315	1.1003979726943927e-10
R1278_1316	1278	1316	7.7116994206173631e+03
C1278_1316	1278	1316	1.1481500164967758e-10
R1278_1318	1278	1318	8.5899173351553654e+03
C1278_1318	1278	1318	1.0307651949993830e-10
R1278_1319	1278	1319	7.8931698327447930e+03
C1278_1319	1278	1319	1.1217531111858796e-10
R1279_1280	1279	1280	6.7727823867160359e+03
C1279_1280	1279	1280	1.3073191063050219e-10
R1279_1286	1279	1286	6.6002171923266542e+03
C1279_1286	1279	1286	1.3414994626682572e-10
R1279_1313	1279	1313	2.7534569556334627e+03
C1279_1313	1279	1313	3.2156623327213032e-10
R1279_1314	1279	1314	1.9235556672764485e+03
C1279_1314	1279	1314	4.6030317539687292e-10
R1279_1318	1279	1318	4.3173975925551167e+03
C1279_1318	1279	1318	2.0508159434442837e-10
R1279_1320	1279	1320	6.0021520068221826e+03
C1279_1320	1279	1320	1.4751688739199091e-10
R1280_1286	1280	1286	5.8707463621139941e+03
C1280_1286	1280	1286	1.5081877619750715e-10
R1280_1320	1280	1320	2.1204265550409960e+04
C1280_1320	1280	1320	4.1756635220165949e-11
R1281_1282	1281	1282	3.5716289179439823e+03
C1281_1282	1281	1282	2.4790335223562189e-10
R1281_1285	1281	1285	1.3116780171056071e+03
C1281_1285	1281	1285	6.7502753736301469e-10
R1281_1298	1281	1298	2.4501737058685221e+03
C1281_1298	1281	1298	3.6136979985512604e-10
R1281_1300	1281	1300	2.2896998985698474e+03
C1281_1300	1281	1300	3.8669643224993596e-10
R1281_1301	1281	1301	2.4033233651342894e+03
C1281_1301	1281	1301	3.6841433597535301e-10
R1281_1313	1281	1313	3.9854718056433371e+03
C1281_1313	1281	1313	2.2216159714046085e-10
R1281_1321	1281	1321	2.5389726162772381e+03
C1281_1321	1281	1321	3.4873112692260663e-10
R1282_1283	1282	1283	1.2146597557189652e+03
C1282_1283	1282	1283	7.2894386887455134e-10
R1282_1284	1282	1284	2.2168133294330196e+03
C1282_1284	1282	1284	3.9941061791001506e-10
R1282_1285	1282	1285	2.5711403938188341e+03
C1282_1285	1282	1285	3.4436811923168277e-10
R1282_1301	1282	1301	1.6337696772145475e+03
C1282_1301	1282	1301	5.4194835052243804e-10
R1282_1322	1282	1322	5.9607602151576293e+03
C1282_1322	1282	1322	1.4854125140757494e-10
R1283_1284	1283	1284	4.8202022391404935e+03
C1283_1284	1283	1284	1.8368913538737368e-10
R1283_1285	1283	1285	2.7687040666260914e+03
C1283_1285	1283	1285	3.1979538455294733e-10
R1283_1286	1283	1286	7.8681922073260357e+03
C1283_1286	1283	1286	1.1253141234597583e-10
R1283_1322	1283	1322	5.4987685337975809e+03
C1283_1322	1283	1322	1.6102128617669029e-10
R1284_1301	1284	1301	2.5024513491035227e+03
C1284_1301	1284	1301	3.5382057757773891e-10
R1284_1304	1284	1304	2.4801938603023732e+03
C1284_1304	1284	1304	3.5699579612379744e-10
R1284_1305	1284	1305	4.7029416534737347e+03
C1284_1305	1284	1305	1.8826914024034364e-10
R1284_1322	1284	1322	3.2895994738033110e+03
C1284_1322	1284	1322	2.6915701706272237e-10
R1285_1286	1285	1286	1.0737300647911252e+03
C1285_1286	1285	1286	8.2461953030275097e-10
R1285_1301	1285	1301	4.2350130462935394e+03
C1285_1301	1285	1301	2.0907108715400862e-10
R1285_1313	1285	1313	2.6476435628152935e+03
C1285_1313	1285	1313	3.3441766638652682e-10
R1285_1314	1285	1314	1.2774877176710077e+03
C1285_1314	1285	1314	6.9309377260723108e-10
R1285_1321	1285	1321	1.5830740726608144e+03
C1285_1321	1285	1321	5.5930344447609923e-10
R1285_1322	1285	1322	2.2602058698454939e+03
C1285_1322	1285	1322	3.9174253704620573e-10
R1285_1323	1285	1323	3.9511698300520488e+03
C1285_1323	1285	1323	2.2409028712601209e-10
R1286_1314	1286	1314	2.1131658612712295e+03
C1286_1314	1286	1314	4.1900108170749724e-10
R1286_1320	1286	1320	4.7043695040568573e+03
C1286_1320	1286	1320	1.8821199757724191e-10
R1286_1322	1286	1322	8.9829113112383111e+03
C1286_1322	1286	1322	9.8567018088253114e-11
R1286_1323	1286	1323	3.5432687800897133e+03
C1286_1323	1286	1323	2.4988755769117290e-10
R1287_1288	1287	1288	2.3508699664456913e+03
C1287_1288	1287	1288	3.7663452012987164e-10
R1287_1289	1287	1289	1.3694980618691252e+03
C1287_1289	1287	1289	6.4652795527987711e-10
R1287_1295	1287	1295	5.8816112365953622e+03
C1287_1295	1287	1295	1.5054017446629726e-10
R1287_1302	1287	1302	1.2816209661460912e+03
C1287_1302	1287	1302	6.9085853390999518e-10
R1287_1304	1287	1304	1.3260222827894877e+03
C1287_1304	1287	1304	6.6772541697971191e-10
R1287_1310	1287	1310	9.4943927285940117e+03
C1287_1310	1287	1310	9.3257020960741157e-11
R1287_1324	1287	1324	3.4208934085222577e+03
C1287_1324	1287	1324	2.5882676715217484e-10
R1288_1289	1288	1289	8.0734372908498688e+02
C1288_1289	1288	1289	1.0967060866423037e-09
R1288_1307	1288	1307	2.4431278061441221e+03
C1288_1307	1288	1307	3.6241197839642138e-10
R1288_1308	1288	1308	8.6116064271781033e+02
C1288_1308	1288	1308	1.0281691217397389e-09
R1288_1310	1288	1310	2.6580328320381373e+03
C1288_1310	1288	1310	3.3311055116692253e-10
R1288_1324	1288	1324	4.7663818728018923e+03
C1288_1324	1288	1324	1.8576329075779891e-10
R1289_1295	1289	1295	2.4165172954936033e+03
C1289_1295	1289	1295	3.6640283243623228e-10
R1289_1308	1289	1308	1.8124741168556475e+03
C1289_1308	1289	1308	4.8851389019340037e-10
R1289_1324	1289	1324	4.7960833008658565e+03
C1289_1324	1289	1324	1.8461288642341801e-10
R1290_1291	1290	1291	1.6269229868798311e+03
C1290_1291	1290	1291	5.4422906851791835e-10
R1290_1292	1290	1292	3.6058011216487707e+03
C1290_1292	1290	1292	2.4555397034630066e-10
R1290_1298	1290	1298	3.6278239460753225e+03
C1290_1298	1290	1298	2.4406332690368557e-10
R1290_1299	1290	1299	3.3626104297564002e+03
C1290_1299	1290	1299	2.6331292315778099e-10
R1290_1300	1290	1300	1.5745018140352938e+03
C1290_1300	1290	1300	5.6234853069540670e-10
R1290_1325	1290	1325	5.7362188559830220e+03
C1290_1325	1290	1325	1.5435582287389290e-10
R1291_1292	1291	1292	3.2698715941086034e+03
C1291_1292	1291	1292	2.7078090261870766e-10
R1291_1294	1291	1294	1.9199330593056527e+03
C1291_1294	1291	1294	4.6117169419449097e-10
R1291_1295	1291	1295	3.0342795508872437e+03
C1291_1295	1291	1295	2.9180527596446994e-10
R1291_1300	1291	1300	2.5267938252795852e+03
C1291_1300	1291	1300	3.5041196192650585e-10
R1291_1302	1291	1302	1.5667485789792661e+03
C1291_1302	1291	1302	5.6513137690340144e-10
R1291_1325	1291	1325	1.4939774712521369e+03
C1291_1325	1291	1325	5.9265872393504715e-10
R1292_1293	1292	1293	2.2369895323029829e-06
C1292_1293	1292	1293	3.9580819173009757e-11
R1292_1294	1292	1294	3.6084021048304273e-06
C1292_1294	1292	1294	2.6991466876494621e-10
R1292_1297	1292	1297	1.4300590463132319e-06
C1292_1297	1292	1297	6.1914840788053947e-11
R1292_1299	1292	1299	2.8127490637796044e-06
C1292_1299	1292	1299	2.4133722921066180e-10
R1292_1325	1292	1325	3.0506215246300674e-06
C1292_1325	1292	1325	3.1926630394248811e-10
R1292_1326	1292	1326	3.8494803642684913e-06
C1292_1326	1292	1326	2.3000994885403300e-11
R1293_1297	1293	1297	4.5514141281838076e-06
C1293_1297	1293	1297	1.9453707282253324e-11
R1293_1299	1293	1299	4.6994243628969964e-06
C1293_1299	1293	1299	1.8841005053524826e-11
R1293_1303	1293	1303	4.5285720936367380e-06
C1293_1303	1293	1303	1.9551831424835530e-11
R1293_1326	1293	1326	4.3767441301610410e-06
C1293_1326	1293	1326	2.0230078692478222e-11
R1294_1295	1294	1295	4.4256578206629876e-06
C1294_1295	1294	1295	2.2007138788469066e-10
R1294_1296	1294	1296	9.7472519562349627e-07
C1294_1296	1294	1296	9.0837785426653479e-11
R1294_1297	1294	1297	3.5314271363986742e-06
C1294_1297	1294	1297	2.5072548505218319e-11
R1294_1325	1294	1325	5.2131705617379103e-06
C1294_1325	1294	1325	1.3021270980459813e-10
R1294_1327	1294	1327	5.6424733728399985e-06
C1294_1327	1294	1327	1.5692032964868854e-11
R1295_1296	1295	1296	5.4794653345222479e-06
C1295_1296	1295	1296	1.6158853604230334e-11
R1295_1302	1295	1302	5.7593497091721001e+03
C1295_1302	1295	1302	1.5373589492055312e-10
R1295_1308	1295	1308	8.4088892206579527e-06
C1295_1308	1295	1308	8.0726603443628025e-11
R1295_1309	1295	1309	2.1340713615654811e-06
C1295_1309	1295	1309	4.1489652016626443e-11
R1295_1324	1295	1324	5.2357992617968629e-06
C1295_1324	1295	1324	2.4238902001799180e-10
R1295_1325	1295	1325	6.6704487341788930e-06
C1295_1325	1295	1325	2.1238002195205862e-10
R1295_1327	1295	1327	4.2449324572559108e-06
C1295_1327	1295	1327	2.0858253708761461e-11
R1296_1297	1296	1297	4.0546104334332253e-06
C1296_1297	1296	1297	2.1837332987629964e-11
R1296_1309	1296	1309	4.9810011122010179e-06
C1296_1309	1296	1309	1.7775920176591748e-11
R1296_1327	1296	1327	3.7395072214849482e-06
C1296_1327	1296	1327	2.3677418688027099e-11
R1297_1325	1297	1325	2.9282905838388868e-06
C1297_1325	1297	1325	3.0236711704316140e-11
R1297_1326	1297	1326	2.4387447161603773e-06
C1297_1326	1297	1326	3.6306333165286214e-11
R1297_1327	1297	1327	2.2964614441117654e-06
C1297_1327	1297	1327	3.8555786946489148e-11
R1298_1299	1298	1299	2.6836438971081297e+03
C1298_1299	1298	1299	3.2993154667581619e-10
R1298_1300	1298	1300	1.3523201204501320e+03
C1298_1300	1298	1300	6.5474052209271318e-10
R1298_1313	1298	1313	2.4336662847855300e+03
C1298_1313	1298	1313	3.6382095081619988e-10
R1298_1315	1298	1315	3.0477702807906771e+03
C1298_1315	1298	1315	2.9051362147618865e-10
R1298_1321	1298	1321	2.2450828672301200e+03
C1298_1321	1298	1321	3.9438133648598415e-10
R1298_1328	1298	1328	6.7257413417714570e+03
C1298_1328	1298	1328	1.3164627313288772e-10
R1299_1300	1299	1300	7.0893235810535689e+03
C1299_1300	1299	1300	1.2489467740847779e-10
R1299_1303	1299	1303	5.7234447407790791e-06
C1299_1303	1299	1303	1.5470032852618686e-11
R1299_1315	1299	1315	7.5973994190663024e-06
C1299_1315	1299	1315	8.9349134891328066e-11
R1299_1325	1299	1325	1.0497314471736559e-05
C1299_1325	1299	1325	1.3495547384136212e-10
R1299_1326	1299	1326	2.0556380322634880e-06
C1299_1326	1299	1326	4.3072698977312394e-11
R1299_1328	1299	1328	1.8169851807884805e-05
C1299_1328	1299	1328	7.7968167466298848e-11
R1300_1301	1300	1301	5.5014613931774293e+03
C1300_1301	1300	1301	1.6094246935878554e-10
R1300_1302	1300	1302	2.9528959734344303e+03
C1300_1302	1300	1302	2.9984760373058261e-10
R1300_1321	1300	1321	8.0962066890297247e+03
C1300_1321	1300	1321	1.0936217610399364e-10
R1300_1325	1300	1325	5.7275575936958667e+03
C1300_1325	1300	1325	1.5458924108847919e-10
R1300_1328	1300	1328	5.4941175268902989e+03
C1300_1328	1300	1328	1.6115759762444549e-10
R1301_1302	1301	1302	1.3428773155823571e+03
C1301_1302	1301	1302	6.5934450707138974e-10
R1301_1304	1301	1304	9.7391294330685923e+02
C1301_1304	1301	1304	9.0913544971855203e-10
R1301_1321	1301	1321	4.0983713108832062e+03
C1301_1321	1301	1321	2.1604162105780282e-10
R1301_1322	1301	1322	2.1498101673942615e+03
C1301_1322	1301	1322	4.1185905394298006e-10
R1301_1328	1301	1328	4.7305302747487112e+03
C1301_1328	1301	1328	1.8717114789991151e-10
R1302_1304	1302	1304	1.3325514645871303e+03
C1302_1304	1302	1304	6.6445372297446894e-10
R1302_1324	1302	1324	2.8346388999785545e+03
C1302_1324	1302	1324	3.1235681613862654e-10
R1302_1325	1302	1325	3.1626015451599328e+03
C1302_1325	1302	1325	2.7996532887775599e-10
R1302_1328	1302	1328	4.9670132013222319e+03
C1302_1328	1302	1328	1.7825980036942507e-10
R1303_1315	1303	1315	4.1199992146966671e-06
C1303_1315	1303	1315	2.1490751224941401e-11
R1303_1316	1303	1316	6.2973100127379785e-06
C1303_1316	1303	1316	1.4060269859813251e-11
R1303_1317	1303	1317	5.5078763442832741e-06
C1303_1317	1303	1317	1.6075502178239575e-11
R1303_1326	1303	1326	4.8106187997438206e-06
C1303_1326	1303	1326	1.8405507036790172e-11
R1303_1329	1303	1329	9.2479215527330937e-06
C1303_1329	1303	1329	9.5742462417225742e-12
R1304_1305	1304	1305	8.1981110249365986e+02
C1304_1305	1304	1305	1.0800278003149482e-09
R1304_1310	1304	1310	3.2484121290209259e+03
C1304_1310	1304	1310	2.7256971915286682e-10
R1304_1322	1304	1322	3.1091849767703784e+03
C1304_1322	1304	1322	2.8477520260622008e-10
R1304_1324	1304	1324	1.6321435433167101e+03
C1304_1324	1304	1324	5.4248830338826924e-10
R1304_1328	1304	1328	3.8173366714357403e+03
C1304_1328	1304	1328	2.3194673614339203e-10
R1304_1330	1304	1330	2.8277391907319538e+03
C1304_1330	1304	1330	3.1311896960016722e-10
R1305_1310	1305	1310	5.3375146448659389e+03
C1305_1310	1305	1310	1.6588596764819539e-10
R1305_1322	1305	1322	8.7160277174878083e+03
C1305_1322	1305	1322	1.0158512689484673e-10
R1305_1330	1305	1330	5.9812409832002295e+03
C1305_1330	1305	1330	1.4803262135515262e-10
R1306_1307	1306	1307	3.5913139435632368e-06
C1306_1307	1306	1307	2.4654452259372897e-11
R1306_1308	1306	1308	6.2497039640583530e-06
C1306_1308	1306	1308	1.4167371555388653e-11
R1306_1311	1306	1311	5.1051137024019811e-06
C1306_1311	1306	1311	1.7343762221856221e-11
R1306_1312	1306	1312	4.3383709488236581e-06
C1306_1312	1306	1312	2.0409015092176016e-11
R1306_1331	1306	1331	1.4124656761529398e-05
C1306_1331	1306	1331	6.2686038793634254e-12
R1307_1308	1307	1308	9.0515117405054723e-06
C1307_1308	1307	1308	7.4995325088043743e-11
R1307_1310	1307	1310	1.3884109411688673e-05
C1307_1310	1307	1310	7.0149307385613577e-11
R1307_1312	1307	1312	3.6156534962429124e-06
C1307_1312	1307	1312	2.4488485487341467e-11
R1307_1331	1307	1331	7.0017717597390313e-06
C1307_1331	1307	1331	1.2645639019415867e-11
R1308_1309	1308	1309	7.8279965360076373e-06
C1308_1309	1308	1309	1.1310924546621901e-11
R1308_1310	1308	1310	1.4774836224140933e-05
C1308_1310	1308	1310	6.5920233843584912e-11
R1308_1311	1308	1311	1.9885639185834881e-06
C1308_1311	1308	1311	4.4525537923403014e-11
R1308_1324	1308	1324	7.6982606115175837e-06
C1308_1324	1308	1324	9.7763118431526035e-11
R1308_1331	1308	1331	2.4072435530197841e-06
C1308_1331	1308	1331	3.6781437449039167e-11
R1308_1332	1308	1332	1.0535340607325759e-05
C1308_1332	1308	1332	8.4042729580505751e-12
R1309_1311	1309	1311	6.0695358273571198e-06
C1309_1311	1309	1311	1.4587915894806424e-11
R1309_1324	1309	1324	3.2148906204116565e-06
C1309_1324	1309	1324	2.7541179039759210e-11
R1309_1327	1309	1327	1.8091987528908871e-06
C1309_1327	1309	1327	4.8939829318653068e-11
R1309_1332	1309	1332	2.5707507736044551e-06
C1309_1332	1309	1332	3.4442031129239037e-11
R1310_1324	1310	1324	7.6354367401238367e-06
C1310_1324	1310	1324	2.4351972272657248e-10
R1310_1330	1310	1330	7.5954592764907874e-06
C1310_1330	1310	1330	1.2822933063581945e-10
R1310_1331	1310	1331	6.2257442349332295e-07
C1310_1331	1310	1331	1.4221894576584642e-10
R1310_1312	1310	1312	1.0562435566932435e-05
C1310_1312	1310	1312	8.3827141580106714e-12
R1310_1333	1310	1333	2.9669762828461900e-06
C1310_1333	1310	1333	2.9842462402517986e-11
R1311_1312	1311	1312	4.8706490055066199e-06
C1311_1312	1311	1312	1.8178661215352826e-11
R1311_1331	1311	1331	1.4675721620795774e-06
C1311_1331	1311	1331	6.0332214290937825e-11
R1311_1332	1311	1332	5.0992800166725645e-06
C1311_1332	1311	1332	1.7363603857898408e-11
R1311_1333	1311	1333	7.4348209327477476e-06
C1311_1333	1311	1333	1.1909080120545263e-11
R1312_1331	1312	1331	3.5140397006657532e-06
C1312_1331	1312	1331	2.5196607241866183e-11
R1312_1333	1312	1333	8.7072123798833651e-06
C1312_1333	1312	1333	1.0168797349489485e-11
R1313_1314	1313	1314	8.2367919109741490e+02
C1313_1314	1313	1314	1.0749558702828554e-09
R1313_1315	1313	1315	2.0792604586640391e+03
C1313_1315	1313	1315	4.2583351114602404e-10
R1313_1318	1313	1318	1.8955164305758333e+03
C1313_1318	1313	1318	4.6711216395577296e-10
R1313_1319	1313	1319	4.2112102102580657e+03
C1313_1319	1313	1319	2.1025281035442327e-10
R1313_1321	1313	1321	7.2138869344506668e+02
C1313_1321	1313	1321	1.2273810079717090e-09
R1313_1334	1313	1334	3.0885936509192234e+03
C1313_1334	1313	1334	2.8667376863786622e-10
R1314_1318	1314	1318	1.1820594119351972e+03
C1314_1318	1314	1318	7.4904761364781596e-10
R1314_1320	1314	1320	2.2552921103929652e+03
C1314_1320	1314	1320	3.9259605335369321e-10
R1314_1321	1314	1321	1.4678155869406271e+03
C1314_1321	1314	1321	6.0322208700990930e-10
R1314_1323	1314	1323	1.1929375374991112e+03
C1314_1323	1314	1323	7.4221721914812305e-10
R1314_1334	1314	1334	3.8075488103168154e+03
C1314_1334	1314	1334	2.3254298915378230e-10
R1315_1316	1315	1316	1.6178902907619378e-06
C1315_1316	1315	1316	4.6517737832897745e-10
R1315_1317	1315	1317	2.6783924425351304e-06
C1315_1317	1315	1317	3.3057843489953277e-11
R1315_1319	1315	1319	3.9978925817604844e-06
C1315_1319	1315	1319	3.5435420527761147e-10
R1315_1321	1315	1321	2.3002584460182584e+03
C1315_1321	1315	1321	3.8492143490774169e-10
R1315_1326	1315	1326	3.0990109130883671e-06
C1315_1326	1315	1326	2.8571012059380657e-11
R1315_1328	1315	1328	3.5761801546721257e-06
C1315_1328	1315	1328	2.7234664272257133e-10
R1315_1329	1315	1329	7.1543424327916033e-07
C1315_1329	1315	1329	1.2375963130332190e-10
R1315_1334	1315	1334	2.0679561712374317e-06
C1315_1334	1315	1334	4.7097741840110511e-10
R1315_1335	1315	1335	2.4475587555507477e-06
C1315_1335	1315	1335	3.6175588418132327e-11
R1316_1317	1316	1317	1.5811745992452415e-06
C1316_1317	1316	1317	5.5997533866446260e-11
R1316_1319	1316	1319	9.6806608020248700e-06
C1316_1319	1316	1319	1.0060890251338210e-10
R1316_1335	1316	1335	7.2120923047206268e-06
C1316_1335	1316	1335	1.2276864248124710e-11
R1317_1329	1317	1329	7.2616123254329098e-06
C1317_1329	1317	1329	1.2193143093014328e-11
R1317_1335	1317	1335	8.4850973847910501e-06
C1317_1335	1317	1335	1.0434986677784652e-11
R1318_1319	1318	1319	4.2410069741533198e+03
C1318_1319	1318	1319	2.0877560143054618e-10
R1318_1320	1318	1320	4.4051948347220696e+03
C1318_1320	1318	1320	2.0099423860235742e-10
R1318_1323	1318	1323	5.4053636027079756e+03
C1318_1323	1318	1323	1.6380374139057426e-10
R1318_1334	1318	1334	4.2947021006482782e+03
C1318_1334	1318	1334	2.0616535465087267e-10
R1318_1336	1318	1336	7.2086005635364900e+03
C1318_1336	1318	1336	1.2282810982463697e-10
R1319_1334	1319	1334	6.7422306426362102e-06
C1319_1334	1319	1334	2.1011889442587760e-10
R1319_1335	1319	1335	3.9525504309424055e-06
C1319_1335	1319	1335	2.2401201380468906e-11
R1319_1336	1319	1336	2.4199288328509343e-05
C1319_1336	1319	1336	4.0247491813575769e-11
R1320_1323	1320	1323	2.9294676137404690e+03
C1320_1323	1320	1323	3.0224562905116396e-10
R1320_1336	1320	1336	1.6314111846699088e+04
C1320_1336	1320	1336	5.4273183242834707e-11
R1321_1322	1321	1322	4.1750190442972316e+03
C1321_1322	1321	1322	2.1207538751455921e-10
R1321_1323	1321	1323	3.4516574103629496e+03
C1321_1323	1321	1323	2.5651989071733990e-10
R1321_1328	1321	1328	2.0417577702932529e+03
C1321_1328	1321	1328	4.3365515468214898e-10
R1321_1334	1321	1334	2.0742528204556716e+03
C1321_1334	1321	1334	4.2686155369695558e-10
R1321_1337	1321	1337	6.0530280001170677e+03
C1321_1337	1321	1337	1.4627700081395227e-10
R1322_1323	1322	1323	4.6021125097888189e+03
C1322_1323	1322	1323	1.9239398859038977e-10
R1322_1328	1322	1328	5.0104080662252154e+03
C1322_1328	1322	1328	1.7671590217741779e-10
R1322_1330	1322	1330	5.4842793282583116e+03
C1322_1330	1322	1330	1.6144669676793977e-10
R1322_1337	1322	1337	5.6420769524176312e+03
C1322_1337	1322	1337	1.5693135509621117e-10
R1323_1334	1323	1334	3.3182031211232438e+03
C1323_1334	1323	1334	2.6683682384105446e-10
R1323_1336	1323	1336	5.2884440799559225e+03
C1323_1336	1323	1336	1.6742519506935579e-10
R1323_1337	1323	1337	3.6230703748823435e+03
C1323_1337	1323	1337	2.4438354491768691e-10
R1324_1325	1324	1325	9.2826754716551568e-06
C1324_1325	1324	1325	7.3127738612671234e-11
R1324_1327	1324	1327	7.8226594523054837e-06
C1324_1327	1324	1327	1.1318641532312273e-11
R1324_1328	1324	1328	1.8062961502360641e-05
C1324_1328	1324	1328	7.8429555884833798e-11
R1324_1330	1324	1330	9.0987028782461709e-06
C1324_1330	1324	1330	5.8387582918497996e-11
R1324_1331	1324	1331	6.8125042672392113e-06
C1324_1331	1324	1331	1.2996964801297933e-11
R1324_1332	1324	1332	2.4022534255380567e-06
C1324_1332	1324	1332	3.6857842402771647e-11
R1324_1338	1324	1338	9.8498225762277746e-06
C1324_1338	1324	1338	8.9891850827539733e-12
R1325_1326	1325	1326	3.4766322281486051e-06
C1325_1326	1325	1326	2.5467714834235082e-11
R1325_1327	1325	1327	1.4431508913270884e-06
C1325_1327	1325	1327	6.1353167366011833e-11
R1325_1328	1325	1328	7.5994937105990591e-06
C1325_1328	1325	1328	1.2816125599757398e-10
R1325_1338	1325	1338	7.8423471806186101e-06
C1325_1338	1325	1338	1.1290226781698760e-11
R1326_1327	1326	1327	8.9563248773802827e-06
C1326_1327	1326	1327	9.8859609697296298e-12
R1326_1328	1326	1328	7.3834310280644429e-06
C1326_1328	1326	1328	1.1991969293605110e-11
R1326_1329	1326	1329	6.7146140740611559e-06
C1326_1329	1326	1329	1.3186443359722056e-11
R1326_1338	1326	1338	9.2166055056864329e-06
C1326_1338	1326	1338	9.6067774752181476e-12
R1327_1332	1327	1332	3.5161331651065733e-06
C1327_1332	1327	1332	2.5181605477480916e-11
R1327_1338	1327	1338	3.7462357325970386e-06
C1327_1338	1327	1338	2.3634892326602003e-11
R1328_1329	1328	1329	3.6122175403746808e-06
C1328_1329	1328	1329	2.4511779033334720e-11
R1328_1330	1328	1330	7.0242875468876500e-06
C1328_1330	1328	1330	2.0168167079417173e-10
R1328_1334	1328	1334	3.8119815455965975e-06
C1328_1334	1328	1334	1.7807564317870096e-10
R1328_1337	1328	1337	4.6930487126718304e-06
C1328_1337	1328	1337	2.0753261227956599e-10
R1328_1338	1328	1338	7.9468227651042519e-07
C1328_1338	1328	1338	1.1141796009192669e-10
R1328_1339	1328	1339	4.2461974915481163e-06
C1328_1339	1328	1339	2.0852039582765290e-11
R1329_1334	1329	1334	3.1475165169501864e-06
C1329_1334	1329	1334	2.8130711210943358e-11
R1329_1335	1329	1335	3.4081514534930289e-06
C1329_1335	1329	1335	2.5979443513067201e-11
R1329_1338	1329	1338	6.6519889763930324e-06
C1329_1338	1329	1338	1.3310587026560417e-11
R1329_1339	1329	1339	2.4126264481481124e-06
C1329_1339	1329	1339	3.6699373099371902e-11
R1330_1331	1330	1331	3.4048056574800306e-06
C1330_1331	1330	1331	2.6004972699537786e-11
R1330_1332	1330	1332	3.9285796924038894e-06
C1330_1332	1330	1332	2.2537885216176287e-11
R1330_1333	1330	1333	7.9807427842569126e-06
C1330_1333	1330	1333	1.1094440776197017e-11
R1330_1337	1330	1337	5.7389611004163899e-06
C1330_1337	1330	1337	9.2569240226393851e-11
R1330_1338	1330	1338	3.0645306062095431e-06
C1330_1338	1330	1338	2.8892476384667501e-11
R1330_1340	1330	1340	1.1208908404855216e-06
C1330_1340	1330	1340	7.8992418326522752e-11
R1331_1332	1331	1332	1.7447475458666424e-06
C1331_1332	1331	1332	5.0747673140310925e-11
R1331_1333	1331	1333	5.9885080908737882e-07
C1331_1333	1331	1333	1.4785298245640478e-10
R1331_1340	1331	1340	7.2157990541334922e-06
C1331_1340	1331	1340	1.2270557634123661e-11
R1332_1333	1332	1333	1.0965635435036736e-05
C1332_1333	1332	1333	8.0744867631743727e-12
R1332_1338	1332	1338	7.1953024087884020e-06
C1332_1338	1332	1338	1.2305511726908686e-11
R1332_1340	1332	1340	7.3127235262327319e-06
C1332_1340	1332	1340	1.2107920920622274e-11
R1333_1340	1333	1340	8.0166949424291208e-06
C1333_1340	1333	1340	1.1044685971694356e-11
R1334_1335	1334	1335	2.6266406818572681e-06
C1334_1335	1334	1335	3.3709170341256210e-11
R1334_1336	1334	1336	5.2388907805775544e-06
C1334_1336	1334	1336	1.8590970869384421e-10
R1334_1337	1334	1337	3.6539887147970771e-06
C1334_1337	1334	1337	2.6654725422438205e-10
R1334_1339	1334	1339	1.4756048331807060e-06
C1334_1339	1334	1339	6.0003787043137839e-11
R1334_1341	1334	1341	5.7726877933435861e-06
C1334_1341	1334	1341	1.5338068043814276e-11
R1335_1336	1335	1336	1.1416120188875869e-05
C1335_1336	1335	1336	7.7558642257706113e-12
R1335_1339	1335	1339	4.3752152664501821e-06
C1335_1339	1335	1339	2.0237147837948139e-11
R1335_1341	1335	1341	7.6618256301180333e-06
C1335_1341	1335	1341	1.1556237696398211e-11
R1336_1337	1336	1337	1.9459975302208059e-05
C1336_1337	1336	1337	5.0049429342571019e-11
R1336_1341	1336	1341	3.8007764300132882e-06
C1336_1341	1336	1341	2.3295734384905782e-11
R1337_1338	1337	1338	1.0192876681667237e-05
C1337_1338	1337	1338	8.6866427344549533e-12
R1337_1339	1337	1339	7.0548800895075863e-06
C1337_1339	1337	1339	1.2550444096375849e-11
R1337_1340	1337	1340	2.5810106925298716e-05
C1337_1340	1337	1340	3.4305118698757687e-12
R1337_1341	1337	1341	1.7206737950199145e-05
C1337_1341	1337	1341	5.1457678048136525e-12
R1337_1342	1337	1342	4.8333533567975128e-06
C1337_1342	1337	1342	1.8318933385136601e-11
R1338_1339	1338	1339	7.3308287667123951e-06
C1338_1339	1338	1339	1.2078017504930448e-11
R1338_1340	1338	1340	8.3492830504161972e-06
C1338_1340	1338	1340	1.0604728290483138e-11
R1338_1342	1338	1342	1.3027746623036800e-05
C1338_1342	1338	1342	6.7964077543105206e-12
R1339_1341	1339	1341	7.9791464853004904e-06
C1339_1341	1339	1341	1.1096660317380496e-11
R1339_1342	1339	1342	8.1834319507269461e-06
C1339_1342	1339	1342	1.0819651058763274e-11
R1340_1342	1340	1342	2.8990956468765157e-05
C1340_1342	1340	1342	3.0541206277686970e-12
R1341_1342	1341	1342	2.7792666858403158e-05
C1341_1342	1341	1342	3.1858000033281887e-12
.control
quit 13

.endc
.end
.END
